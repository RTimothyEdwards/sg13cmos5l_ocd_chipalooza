* NGSPICE file created from chipalooza_frame.ext - technology: ihp-sg13cmos5l

* Black-box entry subcircuit for slot16_wrapper abstract view
.subckt slot16_wrapper vss_1v2 s16_an[0] s16_an[1] s16_an_0_esd s16_an_1_esd vbias
+ dig_in[23] dig_in[22] dig_in[21] dig_in[20] dig_in[19] dig_in[18] dig_in[17] dig_in[16]
+ dig_in[15] dig_in[14] dig_in[13] dig_in[12] dig_in[11] dig_in[10] dig_in[9] dig_in[8]
+ dig_in[7] dig_in[6] dig_in[5] dig_in[4] dig_in[3] dig_in[2] dig_in[1] dig_in[0]
+ dig_out[11] dig_out[10] dig_out[9] dig_out[8] dig_out[7] dig_out[6] dig_out[5] dig_out[4]
+ dig_out[3] dig_out[2] dig_out[1] dig_out[0] ibias0 ibias1 analog_bus3 analog_bus2
+ analog_bus1 analog_bus0 vdd_1v2 vss_3v3 vdd_3v3 enable clk reset
.ends

.subckt sg13cmos5l_antennanp A VDD VSS
X0 A VDD dpantenna l=1.34u w=1.05u
X1 VSS A dantenna l=0.78u w=0.78u
.ends

.subckt sg13_hv_pmos_3CJ4LL B D0_0 G D0_1 D0_2 D0_3 S1_0 S1_1 S1_2 S1_3 D2_0 D2_1
+ D2_2 D2_3 S3_0 S3_1 S3_2 S3_3 D4_0 D4_1 D4_2 D4_3 S5_0 S5_1 S5_2 S5_3 D6_0 D6_1
+ D6_2 D6_3 S7_0 S7_1 S7_2 S7_3 D8_0 D8_1 D8_2 D8_3 S9_0 S9_1 S9_2 S9_3 a_1048_44#
+ a_1048_n4132# a_1048_n2044# a_1048_2132#
X0 a_1048_2132# G S9_3 B sg13_hv_pmos ad=6.8p pd=21.36u as=3.6p ps=10.72u w=10u l=0.4u
X1 S7_1 G D6_1 B sg13_hv_pmos ad=3.6p pd=10.72u as=3.6p ps=10.72u w=10u l=0.4u
X2 D6_3 G S5_3 B sg13_hv_pmos ad=3.6p pd=10.72u as=3.6p ps=10.72u w=10u l=0.4u
X3 D2_1 G S1_1 B sg13_hv_pmos ad=3.6p pd=10.72u as=3.6p ps=10.72u w=10u l=0.4u
X4 S9_3 G D8_3 B sg13_hv_pmos ad=3.6p pd=10.72u as=3.6p ps=10.72u w=10u l=0.4u
X5 S3_0 G D2_0 B sg13_hv_pmos ad=3.6p pd=10.72u as=3.6p ps=10.72u w=10u l=0.4u
X6 D8_3 G S7_3 B sg13_hv_pmos ad=3.6p pd=10.72u as=3.6p ps=10.72u w=10u l=0.4u
X7 D6_2 G S5_2 B sg13_hv_pmos ad=3.6p pd=10.72u as=3.6p ps=10.72u w=10u l=0.4u
X8 S1_1 G D0_1 B sg13_hv_pmos ad=3.6p pd=10.72u as=6.8p ps=21.36u w=10u l=0.4u
X9 a_1048_44# G S9_2 B sg13_hv_pmos ad=6.8p pd=21.36u as=3.6p ps=10.72u w=10u l=0.4u
X10 D6_1 G S5_1 B sg13_hv_pmos ad=3.6p pd=10.72u as=3.6p ps=10.72u w=10u l=0.4u
X11 D8_1 G S7_1 B sg13_hv_pmos ad=3.6p pd=10.72u as=3.6p ps=10.72u w=10u l=0.4u
X12 S7_3 G D6_3 B sg13_hv_pmos ad=3.6p pd=10.72u as=3.6p ps=10.72u w=10u l=0.4u
X13 S3_2 G D2_2 B sg13_hv_pmos ad=3.6p pd=10.72u as=3.6p ps=10.72u w=10u l=0.4u
X14 S7_0 G D6_0 B sg13_hv_pmos ad=3.6p pd=10.72u as=3.6p ps=10.72u w=10u l=0.4u
X15 D2_0 G S1_0 B sg13_hv_pmos ad=3.6p pd=10.72u as=3.6p ps=10.72u w=10u l=0.4u
X16 S9_1 G D8_1 B sg13_hv_pmos ad=3.6p pd=10.72u as=3.6p ps=10.72u w=10u l=0.4u
X17 S1_0 G D0_0 B sg13_hv_pmos ad=3.6p pd=10.72u as=6.8p ps=21.36u w=10u l=0.4u
X18 D2_2 G S1_2 B sg13_hv_pmos ad=3.6p pd=10.72u as=3.6p ps=10.72u w=10u l=0.4u
X19 S9_2 G D8_2 B sg13_hv_pmos ad=3.6p pd=10.72u as=3.6p ps=10.72u w=10u l=0.4u
X20 a_1048_n2044# G S9_1 B sg13_hv_pmos ad=6.8p pd=21.36u as=3.6p ps=10.72u w=10u l=0.4u
X21 D6_0 G S5_0 B sg13_hv_pmos ad=3.6p pd=10.72u as=3.6p ps=10.72u w=10u l=0.4u
X22 D8_0 G S7_0 B sg13_hv_pmos ad=3.6p pd=10.72u as=3.6p ps=10.72u w=10u l=0.4u
X23 S1_3 G D0_3 B sg13_hv_pmos ad=3.6p pd=10.72u as=6.8p ps=21.36u w=10u l=0.4u
X24 D4_2 G S3_2 B sg13_hv_pmos ad=3.6p pd=10.72u as=3.6p ps=10.72u w=10u l=0.4u
X25 S5_1 G D4_1 B sg13_hv_pmos ad=3.6p pd=10.72u as=3.6p ps=10.72u w=10u l=0.4u
X26 D2_3 G S1_3 B sg13_hv_pmos ad=3.6p pd=10.72u as=3.6p ps=10.72u w=10u l=0.4u
X27 S1_2 G D0_2 B sg13_hv_pmos ad=3.6p pd=10.72u as=6.8p ps=21.36u w=10u l=0.4u
X28 S7_2 G D6_2 B sg13_hv_pmos ad=3.6p pd=10.72u as=3.6p ps=10.72u w=10u l=0.4u
X29 S9_0 G D8_0 B sg13_hv_pmos ad=3.6p pd=10.72u as=3.6p ps=10.72u w=10u l=0.4u
X30 S3_3 G D2_3 B sg13_hv_pmos ad=3.6p pd=10.72u as=3.6p ps=10.72u w=10u l=0.4u
X31 D4_1 G S3_1 B sg13_hv_pmos ad=3.6p pd=10.72u as=3.6p ps=10.72u w=10u l=0.4u
X32 a_1048_n4132# G S9_0 B sg13_hv_pmos ad=6.8p pd=21.36u as=3.6p ps=10.72u w=10u l=0.4u
X33 D4_3 G S3_3 B sg13_hv_pmos ad=3.6p pd=10.72u as=3.6p ps=10.72u w=10u l=0.4u
X34 D8_2 G S7_2 B sg13_hv_pmos ad=3.6p pd=10.72u as=3.6p ps=10.72u w=10u l=0.4u
X35 S5_0 G D4_0 B sg13_hv_pmos ad=3.6p pd=10.72u as=3.6p ps=10.72u w=10u l=0.4u
X36 S3_1 G D2_1 B sg13_hv_pmos ad=3.6p pd=10.72u as=3.6p ps=10.72u w=10u l=0.4u
X37 S5_2 G D4_2 B sg13_hv_pmos ad=3.6p pd=10.72u as=3.6p ps=10.72u w=10u l=0.4u
X38 S5_3 G D4_3 B sg13_hv_pmos ad=3.6p pd=10.72u as=3.6p ps=10.72u w=10u l=0.4u
X39 D4_0 G S3_0 B sg13_hv_pmos ad=3.6p pd=10.72u as=3.6p ps=10.72u w=10u l=0.4u
.ends

.subckt sg13_hv_nmos_VCL2HP D0 G0 S1 G1 D2 G2 S3 G3 D4 G4 S5 G5 D6 G6 S7 G7 D8 G8
+ S9 G9 D10 G10 S11 G11 D12 G12 S13 G13 D14 G14 S15 G15 D16 G16 S17 G17 D18 G18 S19
+ G19 D20 G20 S21 G21 D22 G22 S23 G23 D24 G24 S25 G25 D26 G26 S27 G27 D28 G28 S29
+ G29 D30 G30 S31 G31 D32 G32 S33 G33 D34 G34 S35 G35 D36 G36 S37 G37 D38 G38 S39
+ G39 sub a_3482_n500#
X0 S3 G2 D2 sub sg13_hv_nmos ad=0.95p pd=5.38u as=0.95p ps=5.38u w=5u l=0.5u
X1 D22 G21 S21 sub sg13_hv_nmos ad=0.95p pd=5.38u as=0.95p ps=5.38u w=5u l=0.5u
X2 D18 G17 S17 sub sg13_hv_nmos ad=0.95p pd=5.38u as=0.95p ps=5.38u w=5u l=0.5u
X3 D32 G31 S31 sub sg13_hv_nmos ad=0.95p pd=5.38u as=0.95p ps=5.38u w=5u l=0.5u
X4 D2 G1 S1 sub sg13_hv_nmos ad=0.95p pd=5.38u as=0.95p ps=5.38u w=5u l=0.5u
X5 S39 G38 D38 sub sg13_hv_nmos ad=0.95p pd=5.38u as=0.95p ps=5.38u w=5u l=0.5u
X6 S17 G16 D16 sub sg13_hv_nmos ad=0.95p pd=5.38u as=0.95p ps=5.38u w=5u l=0.5u
X7 D8 G7 S7 sub sg13_hv_nmos ad=0.95p pd=5.38u as=0.95p ps=5.38u w=5u l=0.5u
X8 S15 G14 D14 sub sg13_hv_nmos ad=0.95p pd=5.38u as=0.95p ps=5.38u w=5u l=0.5u
X9 D24 G23 S23 sub sg13_hv_nmos ad=0.95p pd=5.38u as=0.95p ps=5.38u w=5u l=0.5u
X10 D38 G37 S37 sub sg13_hv_nmos ad=0.95p pd=5.38u as=0.95p ps=5.38u w=5u l=0.5u
X11 D26 G25 S25 sub sg13_hv_nmos ad=0.95p pd=5.38u as=0.95p ps=5.38u w=5u l=0.5u
X12 D16 G15 S15 sub sg13_hv_nmos ad=0.95p pd=5.38u as=0.95p ps=5.38u w=5u l=0.5u
X13 S9 G8 D8 sub sg13_hv_nmos ad=0.95p pd=5.38u as=0.95p ps=5.38u w=5u l=0.5u
X14 S23 G22 D22 sub sg13_hv_nmos ad=0.95p pd=5.38u as=0.95p ps=5.38u w=5u l=0.5u
X15 D34 G33 S33 sub sg13_hv_nmos ad=0.95p pd=5.38u as=0.95p ps=5.38u w=5u l=0.5u
X16 S7 G6 D6 sub sg13_hv_nmos ad=0.95p pd=5.38u as=0.95p ps=5.38u w=5u l=0.5u
X17 S25 G24 D24 sub sg13_hv_nmos ad=0.95p pd=5.38u as=0.95p ps=5.38u w=5u l=0.5u
X18 S13 G12 D12 sub sg13_hv_nmos ad=0.95p pd=5.38u as=0.95p ps=5.38u w=5u l=0.5u
X19 S33 G32 D32 sub sg13_hv_nmos ad=0.95p pd=5.38u as=0.95p ps=5.38u w=5u l=0.5u
X20 S1 G0 D0 sub sg13_hv_nmos ad=0.95p pd=5.38u as=1.7p ps=10.68u w=5u l=0.5u
X21 D6 G5 S5 sub sg13_hv_nmos ad=0.95p pd=5.38u as=0.95p ps=5.38u w=5u l=0.5u
X22 S21 G20 D20 sub sg13_hv_nmos ad=0.95p pd=5.38u as=0.95p ps=5.38u w=5u l=0.5u
X23 S35 G34 D34 sub sg13_hv_nmos ad=0.95p pd=5.38u as=0.95p ps=5.38u w=5u l=0.5u
X24 a_3482_n500# G39 S39 sub sg13_hv_nmos ad=1.7p pd=10.68u as=0.95p ps=5.38u w=5u l=0.5u
X25 D14 G13 S13 sub sg13_hv_nmos ad=0.95p pd=5.38u as=0.95p ps=5.38u w=5u l=0.5u
X26 S27 G26 D26 sub sg13_hv_nmos ad=0.95p pd=5.38u as=0.95p ps=5.38u w=5u l=0.5u
X27 S29 G28 D28 sub sg13_hv_nmos ad=0.95p pd=5.38u as=0.95p ps=5.38u w=5u l=0.5u
X28 S5 G4 D4 sub sg13_hv_nmos ad=0.95p pd=5.38u as=0.95p ps=5.38u w=5u l=0.5u
X29 D12 G11 S11 sub sg13_hv_nmos ad=0.95p pd=5.38u as=0.95p ps=5.38u w=5u l=0.5u
X30 D36 G35 S35 sub sg13_hv_nmos ad=0.95p pd=5.38u as=0.95p ps=5.38u w=5u l=0.5u
X31 D28 G27 S27 sub sg13_hv_nmos ad=0.95p pd=5.38u as=0.95p ps=5.38u w=5u l=0.5u
X32 D4 G3 S3 sub sg13_hv_nmos ad=0.95p pd=5.38u as=0.95p ps=5.38u w=5u l=0.5u
X33 S11 G10 D10 sub sg13_hv_nmos ad=0.95p pd=5.38u as=0.95p ps=5.38u w=5u l=0.5u
X34 D20 G19 S19 sub sg13_hv_nmos ad=0.95p pd=5.38u as=0.95p ps=5.38u w=5u l=0.5u
X35 D30 G29 S29 sub sg13_hv_nmos ad=0.95p pd=5.38u as=0.95p ps=5.38u w=5u l=0.5u
X36 S37 G36 D36 sub sg13_hv_nmos ad=0.95p pd=5.38u as=0.95p ps=5.38u w=5u l=0.5u
X37 D10 G9 S9 sub sg13_hv_nmos ad=0.95p pd=5.38u as=0.95p ps=5.38u w=5u l=0.5u
X38 S19 G18 D18 sub sg13_hv_nmos ad=0.95p pd=5.38u as=0.95p ps=5.38u w=5u l=0.5u
X39 S31 G30 D30 sub sg13_hv_nmos ad=0.95p pd=5.38u as=0.95p ps=5.38u w=5u l=0.5u
.ends

.subckt sg13_hv_pmos_G9ZGU3 D0 G0 S1 G1 D2 G2 S3 G3 D4 G4 S5 G5 D6 G6 S7 G7 D8 G8
+ S9 G9 D10 G10 S11 G11 D12 G12 S13 G13 D14 G14 S15 G15 D16 G16 S17 G17 D18 G18 S19
+ G19 D20 G20 S21 G21 D22 G22 S23 G23 D24 G24 S25 G25 D26 G26 S27 G27 D28 G28 S29
+ G29 D30 G30 S31 G31 D32 G32 S33 G33 D34 G34 S35 G35 D36 G36 S37 G37 D38 G38 S39
+ G39 w_n3674_n1124# a_3482_n1000#
X0 D6 G5 S5 w_n3674_n1124# sg13_hv_pmos ad=1.9p pd=10.38u as=1.9p ps=10.38u w=10u l=0.5u
X1 S13 G12 D12 w_n3674_n1124# sg13_hv_pmos ad=1.9p pd=10.38u as=1.9p ps=10.38u w=10u l=0.5u
X2 S21 G20 D20 w_n3674_n1124# sg13_hv_pmos ad=1.9p pd=10.38u as=1.9p ps=10.38u w=10u l=0.5u
X3 S33 G32 D32 w_n3674_n1124# sg13_hv_pmos ad=1.9p pd=10.38u as=1.9p ps=10.38u w=10u l=0.5u
X4 S35 G34 D34 w_n3674_n1124# sg13_hv_pmos ad=1.9p pd=10.38u as=1.9p ps=10.38u w=10u l=0.5u
X5 a_3482_n1000# G39 S39 w_n3674_n1124# sg13_hv_pmos ad=3.4p pd=20.68u as=1.9p ps=10.38u w=10u l=0.5u
X6 S1 G0 D0 w_n3674_n1124# sg13_hv_pmos ad=1.9p pd=10.38u as=3.4p ps=20.68u w=10u l=0.5u
X7 D12 G11 S11 w_n3674_n1124# sg13_hv_pmos ad=1.9p pd=10.38u as=1.9p ps=10.38u w=10u l=0.5u
X8 D14 G13 S13 w_n3674_n1124# sg13_hv_pmos ad=1.9p pd=10.38u as=1.9p ps=10.38u w=10u l=0.5u
X9 S27 G26 D26 w_n3674_n1124# sg13_hv_pmos ad=1.9p pd=10.38u as=1.9p ps=10.38u w=10u l=0.5u
X10 S29 G28 D28 w_n3674_n1124# sg13_hv_pmos ad=1.9p pd=10.38u as=1.9p ps=10.38u w=10u l=0.5u
X11 D36 G35 S35 w_n3674_n1124# sg13_hv_pmos ad=1.9p pd=10.38u as=1.9p ps=10.38u w=10u l=0.5u
X12 S5 G4 D4 w_n3674_n1124# sg13_hv_pmos ad=1.9p pd=10.38u as=1.9p ps=10.38u w=10u l=0.5u
X13 S11 G10 D10 w_n3674_n1124# sg13_hv_pmos ad=1.9p pd=10.38u as=1.9p ps=10.38u w=10u l=0.5u
X14 D20 G19 S19 w_n3674_n1124# sg13_hv_pmos ad=1.9p pd=10.38u as=1.9p ps=10.38u w=10u l=0.5u
X15 D28 G27 S27 w_n3674_n1124# sg13_hv_pmos ad=1.9p pd=10.38u as=1.9p ps=10.38u w=10u l=0.5u
X16 D30 G29 S29 w_n3674_n1124# sg13_hv_pmos ad=1.9p pd=10.38u as=1.9p ps=10.38u w=10u l=0.5u
X17 D4 G3 S3 w_n3674_n1124# sg13_hv_pmos ad=1.9p pd=10.38u as=1.9p ps=10.38u w=10u l=0.5u
X18 S37 G36 D36 w_n3674_n1124# sg13_hv_pmos ad=1.9p pd=10.38u as=1.9p ps=10.38u w=10u l=0.5u
X19 S31 G30 D30 w_n3674_n1124# sg13_hv_pmos ad=1.9p pd=10.38u as=1.9p ps=10.38u w=10u l=0.5u
X20 D10 G9 S9 w_n3674_n1124# sg13_hv_pmos ad=1.9p pd=10.38u as=1.9p ps=10.38u w=10u l=0.5u
X21 S19 G18 D18 w_n3674_n1124# sg13_hv_pmos ad=1.9p pd=10.38u as=1.9p ps=10.38u w=10u l=0.5u
X22 D22 G21 S21 w_n3674_n1124# sg13_hv_pmos ad=1.9p pd=10.38u as=1.9p ps=10.38u w=10u l=0.5u
X23 S3 G2 D2 w_n3674_n1124# sg13_hv_pmos ad=1.9p pd=10.38u as=1.9p ps=10.38u w=10u l=0.5u
X24 D18 G17 S17 w_n3674_n1124# sg13_hv_pmos ad=1.9p pd=10.38u as=1.9p ps=10.38u w=10u l=0.5u
X25 D32 G31 S31 w_n3674_n1124# sg13_hv_pmos ad=1.9p pd=10.38u as=1.9p ps=10.38u w=10u l=0.5u
X26 D2 G1 S1 w_n3674_n1124# sg13_hv_pmos ad=1.9p pd=10.38u as=1.9p ps=10.38u w=10u l=0.5u
X27 S39 G38 D38 w_n3674_n1124# sg13_hv_pmos ad=1.9p pd=10.38u as=1.9p ps=10.38u w=10u l=0.5u
X28 S17 G16 D16 w_n3674_n1124# sg13_hv_pmos ad=1.9p pd=10.38u as=1.9p ps=10.38u w=10u l=0.5u
X29 S15 G14 D14 w_n3674_n1124# sg13_hv_pmos ad=1.9p pd=10.38u as=1.9p ps=10.38u w=10u l=0.5u
X30 D8 G7 S7 w_n3674_n1124# sg13_hv_pmos ad=1.9p pd=10.38u as=1.9p ps=10.38u w=10u l=0.5u
X31 D24 G23 S23 w_n3674_n1124# sg13_hv_pmos ad=1.9p pd=10.38u as=1.9p ps=10.38u w=10u l=0.5u
X32 D26 G25 S25 w_n3674_n1124# sg13_hv_pmos ad=1.9p pd=10.38u as=1.9p ps=10.38u w=10u l=0.5u
X33 D38 G37 S37 w_n3674_n1124# sg13_hv_pmos ad=1.9p pd=10.38u as=1.9p ps=10.38u w=10u l=0.5u
X34 D16 G15 S15 w_n3674_n1124# sg13_hv_pmos ad=1.9p pd=10.38u as=1.9p ps=10.38u w=10u l=0.5u
X35 S7 G6 D6 w_n3674_n1124# sg13_hv_pmos ad=1.9p pd=10.38u as=1.9p ps=10.38u w=10u l=0.5u
X36 S9 G8 D8 w_n3674_n1124# sg13_hv_pmos ad=1.9p pd=10.38u as=1.9p ps=10.38u w=10u l=0.5u
X37 S23 G22 D22 w_n3674_n1124# sg13_hv_pmos ad=1.9p pd=10.38u as=1.9p ps=10.38u w=10u l=0.5u
X38 S25 G24 D24 w_n3674_n1124# sg13_hv_pmos ad=1.9p pd=10.38u as=1.9p ps=10.38u w=10u l=0.5u
X39 D34 G33 S33 w_n3674_n1124# sg13_hv_pmos ad=1.9p pd=10.38u as=1.9p ps=10.38u w=10u l=0.5u
.ends

.subckt sg13_hv_pmos_2TUKLB D0 G0 S1 G1 w_n330_n174# a_138_n50#
X0 a_138_n50# G1 S1 w_n330_n174# sg13_hv_pmos ad=0.17p pd=1.68u as=95f ps=0.88u w=0.5u l=0.5u
X1 S1 G0 D0 w_n330_n174# sg13_hv_pmos ad=95f pd=0.88u as=0.17p ps=1.68u w=0.5u l=0.5u
.ends

.subckt sg13_hv_nmos_CJ33WB D0 S0 G0 D1 S1 G1 sub
X0 D1 G1 S1 sub sg13_hv_nmos ad=0.68p pd=4.68u as=0.68p ps=4.68u w=2u l=0.5u
X1 S0 G0 D0 sub sg13_hv_nmos ad=0.68p pd=4.68u as=0.68p ps=4.68u w=2u l=0.5u
.ends

.subckt gate_drive_med in_p in_n vdd out vss outn
Xsg13_hv_nmos_VCL2HP_0 vss sg13_hv_pmos_G9ZGU3_0/G1 sg13_hv_pmos_G9ZGU3_0/S1 sg13_hv_pmos_G9ZGU3_0/G1
+ vss sg13_hv_pmos_G9ZGU3_0/S1 sg13_hv_pmos_G9ZGU3_0/S7 sg13_hv_pmos_G9ZGU3_0/S1 vss
+ sg13_hv_pmos_G9ZGU3_0/S1 sg13_hv_pmos_G9ZGU3_0/S7 sg13_hv_pmos_G9ZGU3_0/S1 vss sg13_hv_pmos_G9ZGU3_0/S1
+ sg13_hv_pmos_G9ZGU3_0/S7 sg13_hv_pmos_G9ZGU3_0/S1 vss sg13_hv_pmos_G9ZGU3_0/S7 outn
+ sg13_hv_pmos_G9ZGU3_0/S7 vss sg13_hv_pmos_G9ZGU3_0/S7 outn sg13_hv_pmos_G9ZGU3_0/S7
+ vss sg13_hv_pmos_G9ZGU3_0/S7 outn sg13_hv_pmos_G9ZGU3_0/S7 vss sg13_hv_pmos_G9ZGU3_0/S7
+ outn sg13_hv_pmos_G9ZGU3_0/S7 vss sg13_hv_pmos_G9ZGU3_0/S7 outn sg13_hv_pmos_G9ZGU3_0/S7
+ vss sg13_hv_pmos_G9ZGU3_0/S7 outn sg13_hv_pmos_G9ZGU3_0/S7 vss sg13_hv_pmos_G9ZGU3_0/S7
+ outn sg13_hv_pmos_G9ZGU3_0/S7 vss sg13_hv_pmos_G9ZGU3_0/S7 outn sg13_hv_pmos_G9ZGU3_0/S7
+ vss outn out outn vss outn out outn vss outn out outn vss outn out outn vss outn
+ out outn vss outn out outn vss outn out outn vss outn out outn vss vss sg13_hv_nmos_VCL2HP
Xsg13_hv_pmos_G9ZGU3_0 vdd sg13_hv_pmos_G9ZGU3_0/G1 sg13_hv_pmos_G9ZGU3_0/S1 sg13_hv_pmos_G9ZGU3_0/G1
+ vdd sg13_hv_pmos_G9ZGU3_0/S1 sg13_hv_pmos_G9ZGU3_0/S7 sg13_hv_pmos_G9ZGU3_0/S1 vdd
+ sg13_hv_pmos_G9ZGU3_0/S1 sg13_hv_pmos_G9ZGU3_0/S7 sg13_hv_pmos_G9ZGU3_0/S1 vdd sg13_hv_pmos_G9ZGU3_0/S1
+ sg13_hv_pmos_G9ZGU3_0/S7 sg13_hv_pmos_G9ZGU3_0/S1 vdd sg13_hv_pmos_G9ZGU3_0/S7 outn
+ sg13_hv_pmos_G9ZGU3_0/S7 vdd sg13_hv_pmos_G9ZGU3_0/S7 outn sg13_hv_pmos_G9ZGU3_0/S7
+ vdd sg13_hv_pmos_G9ZGU3_0/S7 outn sg13_hv_pmos_G9ZGU3_0/S7 vdd sg13_hv_pmos_G9ZGU3_0/S7
+ outn sg13_hv_pmos_G9ZGU3_0/S7 vdd sg13_hv_pmos_G9ZGU3_0/S7 outn sg13_hv_pmos_G9ZGU3_0/S7
+ vdd sg13_hv_pmos_G9ZGU3_0/S7 outn sg13_hv_pmos_G9ZGU3_0/S7 vdd sg13_hv_pmos_G9ZGU3_0/S7
+ outn sg13_hv_pmos_G9ZGU3_0/S7 vdd sg13_hv_pmos_G9ZGU3_0/S7 outn sg13_hv_pmos_G9ZGU3_0/S7
+ vdd outn out outn vdd outn out outn vdd outn out outn vdd outn out outn vdd outn
+ out outn vdd outn out outn vdd outn out outn vdd outn out outn vdd vdd sg13_hv_pmos_G9ZGU3
Xsg13_hv_pmos_2TUKLB_0 sg13_hv_pmos_2TUKLB_0/G1 sg13_hv_pmos_G9ZGU3_0/G1 vdd sg13_hv_pmos_2TUKLB_0/G1
+ vdd sg13_hv_pmos_G9ZGU3_0/G1 sg13_hv_pmos_2TUKLB
Xsg13_hv_nmos_CJ33WB_0 vss sg13_hv_pmos_2TUKLB_0/G1 in_p sg13_hv_pmos_G9ZGU3_0/G1
+ vss in_n vss sg13_hv_nmos_CJ33WB
.ends

.subckt sg13_hv_nmos_9DTRBE B D0_0 G D0_1 D0_2 D0_3 S1_0 S1_1 S1_2 S1_3 D2_0 D2_1
+ D2_2 D2_3 S3_0 S3_1 S3_2 S3_3 D4_0 D4_1 D4_2 D4_3 S5_0 S5_1 S5_2 S5_3 D6_0 D6_1
+ D6_2 D6_3 S7_0 S7_1 S7_2 S7_3 D8_0 D8_1 D8_2 D8_3 S9_0 S9_1 S9_2 S9_3 a_1098_n4132#
+ a_1098_44# a_1098_n2044# a_1098_2132#
X0 D8_0 G S7_0 B sg13_hv_nmos ad=3.6p pd=10.72u as=3.6p ps=10.72u w=10u l=0.45u
X1 S5_2 G D4_2 B sg13_hv_nmos ad=3.6p pd=10.72u as=3.6p ps=10.72u w=10u l=0.45u
X2 S9_2 G D8_2 B sg13_hv_nmos ad=3.6p pd=10.72u as=3.6p ps=10.72u w=10u l=0.45u
X3 S1_3 G D0_3 B sg13_hv_nmos ad=3.6p pd=10.72u as=6.8p ps=21.36u w=10u l=0.45u
X4 D6_3 G S5_3 B sg13_hv_nmos ad=3.6p pd=10.72u as=3.6p ps=10.72u w=10u l=0.45u
X5 D2_1 G S1_1 B sg13_hv_nmos ad=3.6p pd=10.72u as=3.6p ps=10.72u w=10u l=0.45u
X6 S7_1 G D6_1 B sg13_hv_nmos ad=3.6p pd=10.72u as=3.6p ps=10.72u w=10u l=0.45u
X7 D8_2 G S7_2 B sg13_hv_nmos ad=3.6p pd=10.72u as=3.6p ps=10.72u w=10u l=0.45u
X8 S9_3 G D8_3 B sg13_hv_nmos ad=3.6p pd=10.72u as=3.6p ps=10.72u w=10u l=0.45u
X9 D2_2 G S1_2 B sg13_hv_nmos ad=3.6p pd=10.72u as=3.6p ps=10.72u w=10u l=0.45u
X10 D6_2 G S5_2 B sg13_hv_nmos ad=3.6p pd=10.72u as=3.6p ps=10.72u w=10u l=0.45u
X11 D4_3 G S3_3 B sg13_hv_nmos ad=3.6p pd=10.72u as=3.6p ps=10.72u w=10u l=0.45u
X12 D4_1 G S3_1 B sg13_hv_nmos ad=3.6p pd=10.72u as=3.6p ps=10.72u w=10u l=0.45u
X13 S1_0 G D0_0 B sg13_hv_nmos ad=3.6p pd=10.72u as=6.8p ps=21.36u w=10u l=0.45u
X14 D6_1 G S5_1 B sg13_hv_nmos ad=3.6p pd=10.72u as=3.6p ps=10.72u w=10u l=0.45u
X15 S5_1 G D4_1 B sg13_hv_nmos ad=3.6p pd=10.72u as=3.6p ps=10.72u w=10u l=0.45u
X16 D2_0 G S1_0 B sg13_hv_nmos ad=3.6p pd=10.72u as=3.6p ps=10.72u w=10u l=0.45u
X17 S7_0 G D6_0 B sg13_hv_nmos ad=3.6p pd=10.72u as=3.6p ps=10.72u w=10u l=0.45u
X18 D2_3 G S1_3 B sg13_hv_nmos ad=3.6p pd=10.72u as=3.6p ps=10.72u w=10u l=0.45u
X19 S3_1 G D2_1 B sg13_hv_nmos ad=3.6p pd=10.72u as=3.6p ps=10.72u w=10u l=0.45u
X20 D4_0 G S3_0 B sg13_hv_nmos ad=3.6p pd=10.72u as=3.6p ps=10.72u w=10u l=0.45u
X21 a_1098_2132# G S9_3 B sg13_hv_nmos ad=6.8p pd=21.36u as=3.6p ps=10.72u w=10u l=0.45u
X22 S1_2 G D0_2 B sg13_hv_nmos ad=3.6p pd=10.72u as=6.8p ps=21.36u w=10u l=0.45u
X23 D6_0 G S5_0 B sg13_hv_nmos ad=3.6p pd=10.72u as=3.6p ps=10.72u w=10u l=0.45u
X24 S3_3 G D2_3 B sg13_hv_nmos ad=3.6p pd=10.72u as=3.6p ps=10.72u w=10u l=0.45u
X25 D8_3 G S7_3 B sg13_hv_nmos ad=3.6p pd=10.72u as=3.6p ps=10.72u w=10u l=0.45u
X26 S5_0 G D4_0 B sg13_hv_nmos ad=3.6p pd=10.72u as=3.6p ps=10.72u w=10u l=0.45u
X27 S5_3 G D4_3 B sg13_hv_nmos ad=3.6p pd=10.72u as=3.6p ps=10.72u w=10u l=0.45u
X28 S9_1 G D8_1 B sg13_hv_nmos ad=3.6p pd=10.72u as=3.6p ps=10.72u w=10u l=0.45u
X29 a_1098_n2044# G S9_1 B sg13_hv_nmos ad=6.8p pd=21.36u as=3.6p ps=10.72u w=10u l=0.45u
X30 S3_0 G D2_0 B sg13_hv_nmos ad=3.6p pd=10.72u as=3.6p ps=10.72u w=10u l=0.45u
X31 S7_3 G D6_3 B sg13_hv_nmos ad=3.6p pd=10.72u as=3.6p ps=10.72u w=10u l=0.45u
X32 S7_2 G D6_2 B sg13_hv_nmos ad=3.6p pd=10.72u as=3.6p ps=10.72u w=10u l=0.45u
X33 D8_1 G S7_1 B sg13_hv_nmos ad=3.6p pd=10.72u as=3.6p ps=10.72u w=10u l=0.45u
X34 S3_2 G D2_2 B sg13_hv_nmos ad=3.6p pd=10.72u as=3.6p ps=10.72u w=10u l=0.45u
X35 a_1098_44# G S9_2 B sg13_hv_nmos ad=6.8p pd=21.36u as=3.6p ps=10.72u w=10u l=0.45u
X36 S9_0 G D8_0 B sg13_hv_nmos ad=3.6p pd=10.72u as=3.6p ps=10.72u w=10u l=0.45u
X37 D4_2 G S3_2 B sg13_hv_nmos ad=3.6p pd=10.72u as=3.6p ps=10.72u w=10u l=0.45u
X38 a_1098_n4132# G S9_0 B sg13_hv_nmos ad=6.8p pd=21.36u as=3.6p ps=10.72u w=10u l=0.45u
X39 S1_1 G D0_1 B sg13_hv_nmos ad=3.6p pd=10.72u as=6.8p ps=21.36u w=10u l=0.45u
.ends

.subckt sg13cmos5l_decap_4 VDD VSS
X0 VDD VSS VDD VDD sg13_lv_pmos ad=0.34p pd=2.68u as=0 ps=0 w=1u l=1u
X1 VSS VDD VSS VSS sg13_lv_nmos ad=0.1428p pd=1.52u as=0 ps=0 w=0.42u l=1u
.ends

.subckt sg13cmos5l_inv_4 Y A VDD VSS
X0 Y A VSS VSS sg13_lv_nmos ad=0.1406p pd=1.12u as=0.2516p ps=2.16u w=0.74u l=0.13u
X1 Y A VDD VDD sg13_lv_pmos ad=0.2128p pd=1.5u as=0.3808p ps=2.92u w=1.12u l=0.13u
X2 VSS A Y VSS sg13_lv_nmos ad=0.1406p pd=1.12u as=0.1406p ps=1.12u w=0.74u l=0.13u
X3 Y A VSS VSS sg13_lv_nmos ad=0.1406p pd=1.12u as=0.1406p ps=1.12u w=0.74u l=0.13u
X4 VDD A Y VDD sg13_lv_pmos ad=0.2128p pd=1.5u as=0.2128p ps=1.5u w=1.12u l=0.13u
X5 VSS A Y VSS sg13_lv_nmos ad=0.2516p pd=2.16u as=0.1406p ps=1.12u w=0.74u l=0.13u
X6 Y A VDD VDD sg13_lv_pmos ad=0.2128p pd=1.5u as=0.2128p ps=1.5u w=1.12u l=0.13u
X7 VDD A Y VDD sg13_lv_pmos ad=0.3808p pd=2.92u as=0.2128p ps=1.5u w=1.12u l=0.13u
.ends

.subckt analog_switch_med in enable avdd out dvss dvdd avss
Xsg13cmos5l_antennanp_0 enable dvdd dvss sg13cmos5l_antennanp
Xsg13_hv_pmos_3CJ4LL_0 avdd out gate_drive_med_0/outn out out out in in in in out
+ out out out in in in in out out out out in in in in out out out out in in in in
+ out out out out in in in in out out out out sg13_hv_pmos_3CJ4LL
Xgate_drive_med_0 sg13cmos5l_inv_4_1/Y sg13cmos5l_inv_4_1/A avdd gate_drive_med_0/out
+ avss gate_drive_med_0/outn gate_drive_med
Xsg13_hv_nmos_9DTRBE_0 avss out gate_drive_med_0/out out out out in in in in out out
+ out out in in in in out out out out in in in in out out out out in in in in out
+ out out out in in in in out out out out sg13_hv_nmos_9DTRBE
Xsg13cmos5l_decap_4_0 dvdd dvss sg13cmos5l_decap_4
Xsg13cmos5l_decap_4_1 dvdd dvss sg13cmos5l_decap_4
Xsg13cmos5l_inv_4_0 sg13cmos5l_inv_4_1/A enable dvdd dvss sg13cmos5l_inv_4
Xsg13cmos5l_inv_4_1 sg13cmos5l_inv_4_1/Y sg13cmos5l_inv_4_1/A dvdd dvss sg13cmos5l_inv_4
.ends

.subckt sg13_hv_pmos_HVFXC8 B D0 G S1 D2 S3 a_376_n500#
X0 a_376_n500# G S3 B sg13_hv_pmos ad=3.4p pd=11.36u as=1.8p ps=5.72u w=5u l=0.4u
X1 S1 G D0 B sg13_hv_pmos ad=1.8p pd=5.72u as=3.4p ps=11.36u w=5u l=0.4u
X2 D2 G S1 B sg13_hv_pmos ad=1.8p pd=5.72u as=1.8p ps=5.72u w=5u l=0.4u
X3 S3 G D2 B sg13_hv_pmos ad=1.8p pd=5.72u as=1.8p ps=5.72u w=5u l=0.4u
.ends

.subckt sg13_hv_pmos_XRP95E D0 G0 S1 G1 D2 G2 S3 G3 w_n506_n324# a_314_n200#
X0 S3 G2 D2 w_n506_n324# sg13_hv_pmos ad=0.38p pd=2.38u as=0.38p ps=2.38u w=2u l=0.5u
X1 D2 G1 S1 w_n506_n324# sg13_hv_pmos ad=0.38p pd=2.38u as=0.38p ps=2.38u w=2u l=0.5u
X2 S1 G0 D0 w_n506_n324# sg13_hv_pmos ad=0.38p pd=2.38u as=0.68p ps=4.68u w=2u l=0.5u
X3 a_314_n200# G3 S3 w_n506_n324# sg13_hv_pmos ad=0.68p pd=4.68u as=0.38p ps=2.38u w=2u l=0.5u
.ends

.subckt sg13_hv_nmos_HSMMZS D0 G0 S1 G1 D2 G2 S3 G3 a_314_n100# sub
X0 S3 G2 D2 sub sg13_hv_nmos ad=0.19p pd=1.38u as=0.19p ps=1.38u w=1u l=0.5u
X1 D2 G1 S1 sub sg13_hv_nmos ad=0.19p pd=1.38u as=0.19p ps=1.38u w=1u l=0.5u
X2 S1 G0 D0 sub sg13_hv_nmos ad=0.19p pd=1.38u as=0.34p ps=2.68u w=1u l=0.5u
X3 a_314_n100# G3 S3 sub sg13_hv_nmos ad=0.34p pd=2.68u as=0.19p ps=1.38u w=1u l=0.5u
.ends

.subckt sw_lvl_shift in_n in_p out outn vss vdd
Xsg13_hv_pmos_XRP95E_0 vdd sg13_hv_pmos_XRP95E_0/G1 outn sg13_hv_pmos_XRP95E_0/G1
+ vdd outn out outn vdd vdd sg13_hv_pmos_XRP95E
Xsg13_hv_pmos_2TUKLB_0 sg13_hv_pmos_2TUKLB_0/G1 sg13_hv_pmos_XRP95E_0/G1 vdd sg13_hv_pmos_2TUKLB_0/G1
+ vdd sg13_hv_pmos_XRP95E_0/G1 sg13_hv_pmos_2TUKLB
Xsg13_hv_nmos_CJ33WB_0 vss sg13_hv_pmos_2TUKLB_0/G1 in_p sg13_hv_pmos_XRP95E_0/G1
+ vss in_n vss sg13_hv_nmos_CJ33WB
Xsg13_hv_nmos_HSMMZS_0 vss sg13_hv_pmos_XRP95E_0/G1 outn sg13_hv_pmos_XRP95E_0/G1
+ vss outn out outn vss vss sg13_hv_nmos_HSMMZS
.ends

.subckt analog_pswitch_small in out avss enable avdd dvdd dvss
Xsg13cmos5l_antennanp_0 enable dvdd dvss sg13cmos5l_antennanp
Xsg13_hv_pmos_HVFXC8_0 avdd out sw_lvl_shift_0/outn in out in out sg13_hv_pmos_HVFXC8
Xsg13cmos5l_decap_4_0 dvdd dvss sg13cmos5l_decap_4
Xsw_lvl_shift_0 sw_lvl_shift_0/in_n sw_lvl_shift_0/in_p sw_lvl_shift_0/out sw_lvl_shift_0/outn
+ avss avdd sw_lvl_shift
Xsg13cmos5l_decap_4_1 dvdd dvss sg13cmos5l_decap_4
Xsg13cmos5l_inv_4_0 sw_lvl_shift_0/in_n enable dvdd dvss sg13cmos5l_inv_4
Xsg13cmos5l_inv_4_1 sw_lvl_shift_0/in_p sw_lvl_shift_0/in_n dvdd dvss sg13cmos5l_inv_4
.ends

.subckt sg13_hv_nmos_U4HMWB B D0 G S1 D2 S3 a_396_n500#
X0 S1 G D0 B sg13_hv_nmos ad=1.8p pd=5.72u as=3.4p ps=11.36u w=5u l=0.45u
X1 D2 G S1 B sg13_hv_nmos ad=1.8p pd=5.72u as=1.8p ps=5.72u w=5u l=0.45u
X2 a_396_n500# G S3 B sg13_hv_nmos ad=3.4p pd=11.36u as=1.8p ps=5.72u w=5u l=0.45u
X3 S3 G D2 B sg13_hv_nmos ad=1.8p pd=5.72u as=1.8p ps=5.72u w=5u l=0.45u
.ends

.subckt analog_switch_small in out avss enable avdd dvdd dvss
Xsg13_hv_nmos_U4HMWB_0 avss in sw_lvl_shift_0/out out in out in sg13_hv_nmos_U4HMWB
Xsg13cmos5l_antennanp_0 enable dvdd dvss sg13cmos5l_antennanp
Xsg13_hv_pmos_HVFXC8_0 avdd out sw_lvl_shift_0/outn in out in out sg13_hv_pmos_HVFXC8
Xsw_lvl_shift_0 sw_lvl_shift_0/in_n sw_lvl_shift_0/in_p sw_lvl_shift_0/out sw_lvl_shift_0/outn
+ avss avdd sw_lvl_shift
Xsg13cmos5l_decap_4_0 dvdd dvss sg13cmos5l_decap_4
Xsg13cmos5l_decap_4_1 dvdd dvss sg13cmos5l_decap_4
Xsg13cmos5l_inv_4_0 sw_lvl_shift_0/in_n enable dvdd dvss sg13cmos5l_inv_4
Xsg13cmos5l_inv_4_1 sw_lvl_shift_0/in_p sw_lvl_shift_0/in_n dvdd dvss sg13cmos5l_inv_4
.ends

.subckt analog_switch_array analog_switch_med_3/out analog_switch_med_17/enable analog_switch_small_1/in
+ m3_189186_500988# analog_switch_med_0/enable analog_switch_med_2/enable m3_189186_501576#
+ analog_switch_med_20/in m3_189186_500400# analog_switch_med_18/in analog_switch_med_20/enable
+ analog_switch_med_1/enable analog_pswitch_small_3/in m3_248802_509908# analog_switch_small_0/avdd
+ analog_pswitch_small_3/enable analog_pswitch_small_2/in analog_switch_med_22/in
+ m3_250566_516139# analog_switch_med_0/in m3_249390_511986# analog_pswitch_small_2/enable
+ analog_pswitch_small_2/avdd analog_switch_small_1/enable analog_pswitch_small_0/avdd
+ analog_switch_med_3/enable analog_switch_small_0/out analog_switch_med_3/in analog_switch_med_2/in
+ analog_switch_small_1/dvdd analog_switch_med_1/in analog_switch_small_1/avdd analog_switch_small_1/dvss
+ analog_switch_small_0/dvdd m3_229182_500988# analog_pswitch_small_3/out analog_pswitch_small_1/out
+ analog_switch_med_17/in analog_pswitch_small_1/enable m3_229182_501576# analog_pswitch_small_0/dvdd
+ analog_pswitch_small_0/out analog_switch_small_0/enable m3_189186_502176# analog_pswitch_small_2/dvdd
+ analog_pswitch_small_2/dvss m3_251154_516139# m3_229182_500400# analog_pswitch_small_3/avdd
+ analog_switch_med_0/out analog_switch_med_1/out analog_pswitch_small_2/out analog_switch_small_0/dvss
+ analog_switch_med_18/enable analog_switch_small_1/out analog_pswitch_small_0/enable
+ analog_pswitch_small_1/avdd m3_249978_514146# analog_switch_med_22/enable analog_pswitch_small_1/dvdd
+ m3_222018_502176# analog_switch_med_3/dvss analog_switch_med_3/dvdd analog_pswitch_small_1/dvss
+ analog_switch_med_2/out analog_switch_med_3/avdd analog_switch_med_22/dvdd sub analog_pswitch_small_3/dvdd
+ analog_pswitch_small_3/dvss analog_pswitch_small_0/dvss analog_switch_med_22/dvss
Xanalog_switch_med_0 analog_switch_med_0/in analog_switch_med_0/enable analog_switch_med_3/avdd
+ analog_switch_med_0/out analog_switch_med_3/dvss analog_switch_med_3/dvdd sub analog_switch_med
Xanalog_switch_med_1 analog_switch_med_1/in analog_switch_med_1/enable analog_switch_med_3/avdd
+ analog_switch_med_1/out analog_switch_med_3/dvss analog_switch_med_3/dvdd sub analog_switch_med
Xanalog_switch_med_2 analog_switch_med_2/in analog_switch_med_2/enable analog_switch_med_3/avdd
+ analog_switch_med_2/out analog_switch_med_3/dvss analog_switch_med_3/dvdd sub analog_switch_med
Xanalog_switch_med_3 analog_switch_med_3/in analog_switch_med_3/enable analog_switch_med_3/avdd
+ analog_switch_med_3/out analog_switch_med_3/dvss analog_switch_med_3/dvdd sub analog_switch_med
Xanalog_pswitch_small_1 analog_pswitch_small_2/in analog_pswitch_small_1/out sub analog_pswitch_small_1/enable
+ analog_pswitch_small_1/avdd analog_pswitch_small_1/dvdd analog_pswitch_small_1/dvss
+ analog_pswitch_small
Xanalog_pswitch_small_0 analog_pswitch_small_3/in analog_pswitch_small_0/out sub analog_pswitch_small_0/enable
+ analog_pswitch_small_0/avdd analog_pswitch_small_0/dvdd analog_pswitch_small_0/dvss
+ analog_pswitch_small
Xanalog_pswitch_small_2 analog_pswitch_small_2/in analog_pswitch_small_2/out sub analog_pswitch_small_2/enable
+ analog_pswitch_small_2/avdd analog_pswitch_small_2/dvdd analog_pswitch_small_2/dvss
+ analog_pswitch_small
Xanalog_pswitch_small_3 analog_pswitch_small_3/in analog_pswitch_small_3/out sub analog_pswitch_small_3/enable
+ analog_pswitch_small_3/avdd analog_pswitch_small_3/dvdd analog_pswitch_small_3/dvss
+ analog_pswitch_small
Xanalog_switch_med_20 analog_switch_med_20/in analog_switch_med_20/enable analog_switch_med_3/avdd
+ analog_switch_med_2/out analog_switch_med_22/dvss analog_switch_med_22/dvdd sub
+ analog_switch_med
Xanalog_switch_med_22 analog_switch_med_22/in analog_switch_med_22/enable analog_switch_med_3/avdd
+ analog_switch_med_3/out analog_switch_med_22/dvss analog_switch_med_22/dvdd sub
+ analog_switch_med
Xanalog_switch_med_17 analog_switch_med_17/in analog_switch_med_17/enable analog_switch_med_3/avdd
+ analog_switch_med_0/out analog_switch_med_22/dvss analog_switch_med_22/dvdd sub
+ analog_switch_med
Xanalog_switch_med_18 analog_switch_med_18/in analog_switch_med_18/enable analog_switch_med_3/avdd
+ analog_switch_med_1/out analog_switch_med_22/dvss analog_switch_med_22/dvdd sub
+ analog_switch_med
Xanalog_switch_small_0 analog_switch_small_1/in analog_switch_small_0/out sub analog_switch_small_0/enable
+ analog_switch_small_0/avdd analog_switch_small_0/dvdd analog_switch_small_0/dvss
+ analog_switch_small
Xanalog_switch_small_1 analog_switch_small_1/in analog_switch_small_1/out sub analog_switch_small_1/enable
+ analog_switch_small_1/avdd analog_switch_small_1/dvdd analog_switch_small_1/dvss
+ analog_switch_small
.ends

.subckt sg13_hv_pmos_ZN7EJW B D0_0 G D0_1 D0_2 D0_3 D0_4 D0_5 D0_6 D0_7 D0_8 D0_9
+ S1_0 S1_1 S1_2 S1_3 S1_4 S1_5 S1_6 S1_7 S1_8 S1_9 D2_0 D2_1 D2_2 D2_3 D2_4 D2_5
+ D2_6 D2_7 D2_8 D2_9 S3_0 S3_1 S3_2 S3_3 S3_4 S3_5 S3_6 S3_7 S3_8 S3_9 D4_0 D4_1
+ D4_2 D4_3 D4_4 D4_5 D4_6 D4_7 D4_8 D4_9 S5_0 S5_1 S5_2 S5_3 S5_4 S5_5 S5_6 S5_7
+ S5_8 S5_9 D6_0 D6_1 D6_2 D6_3 D6_4 D6_5 D6_6 D6_7 D6_8 D6_9 S7_0 S7_1 S7_2 S7_3
+ S7_4 S7_5 S7_6 S7_7 S7_8 S7_9 D8_0 D8_1 D8_2 D8_3 D8_4 D8_5 D8_6 D8_7 D8_8 D8_9
+ S9_0 S9_1 S9_2 S9_3 S9_4 S9_5 S9_6 S9_7 S9_8 S9_9 a_1048_44# a_1048_n4132# a_1048_n8308#
+ a_1048_8396# a_1048_4220# a_1048_n10396# a_1048_n2044# a_1048_2132# a_1048_6308#
+ a_1048_n6220#
X0 a_1048_n8308# G S9_1 B sg13_hv_pmos ad=6.8p pd=21.36u as=3.6p ps=10.72u w=10u l=0.4u
X1 S3_7 G D2_7 B sg13_hv_pmos ad=3.6p pd=10.72u as=3.6p ps=10.72u w=10u l=0.4u
X2 a_1048_2132# G S9_6 B sg13_hv_pmos ad=6.8p pd=21.36u as=3.6p ps=10.72u w=10u l=0.4u
X3 S7_9 G D6_9 B sg13_hv_pmos ad=3.6p pd=10.72u as=3.6p ps=10.72u w=10u l=0.4u
X4 D4_0 G S3_0 B sg13_hv_pmos ad=3.6p pd=10.72u as=3.6p ps=10.72u w=10u l=0.4u
X5 D4_8 G S3_8 B sg13_hv_pmos ad=3.6p pd=10.72u as=3.6p ps=10.72u w=10u l=0.4u
X6 S5_1 G D4_1 B sg13_hv_pmos ad=3.6p pd=10.72u as=3.6p ps=10.72u w=10u l=0.4u
X7 S7_4 G D6_4 B sg13_hv_pmos ad=3.6p pd=10.72u as=3.6p ps=10.72u w=10u l=0.4u
X8 S1_0 G D0_0 B sg13_hv_pmos ad=3.6p pd=10.72u as=6.8p ps=21.36u w=10u l=0.4u
X9 S3_2 G D2_2 B sg13_hv_pmos ad=3.6p pd=10.72u as=3.6p ps=10.72u w=10u l=0.4u
X10 D4_7 G S3_7 B sg13_hv_pmos ad=3.6p pd=10.72u as=3.6p ps=10.72u w=10u l=0.4u
X11 a_1048_n10396# G S9_0 B sg13_hv_pmos ad=6.8p pd=21.36u as=3.6p ps=10.72u w=10u l=0.4u
X12 D2_4 G S1_4 B sg13_hv_pmos ad=3.6p pd=10.72u as=3.6p ps=10.72u w=10u l=0.4u
X13 D6_6 G S5_6 B sg13_hv_pmos ad=3.6p pd=10.72u as=3.6p ps=10.72u w=10u l=0.4u
X14 S3_3 G D2_3 B sg13_hv_pmos ad=3.6p pd=10.72u as=3.6p ps=10.72u w=10u l=0.4u
X15 S9_6 G D8_6 B sg13_hv_pmos ad=3.6p pd=10.72u as=3.6p ps=10.72u w=10u l=0.4u
X16 S5_8 G D4_8 B sg13_hv_pmos ad=3.6p pd=10.72u as=3.6p ps=10.72u w=10u l=0.4u
X17 D4_1 G S3_1 B sg13_hv_pmos ad=3.6p pd=10.72u as=3.6p ps=10.72u w=10u l=0.4u
X18 S5_7 G D4_7 B sg13_hv_pmos ad=3.6p pd=10.72u as=3.6p ps=10.72u w=10u l=0.4u
X19 S1_4 G D0_4 B sg13_hv_pmos ad=3.6p pd=10.72u as=6.8p ps=21.36u w=10u l=0.4u
X20 a_1048_6308# G S9_8 B sg13_hv_pmos ad=6.8p pd=21.36u as=3.6p ps=10.72u w=10u l=0.4u
X21 D6_5 G S5_5 B sg13_hv_pmos ad=3.6p pd=10.72u as=3.6p ps=10.72u w=10u l=0.4u
X22 S5_0 G D4_0 B sg13_hv_pmos ad=3.6p pd=10.72u as=3.6p ps=10.72u w=10u l=0.4u
X23 D8_6 G S7_6 B sg13_hv_pmos ad=3.6p pd=10.72u as=3.6p ps=10.72u w=10u l=0.4u
X24 a_1048_44# G S9_5 B sg13_hv_pmos ad=6.8p pd=21.36u as=3.6p ps=10.72u w=10u l=0.4u
X25 S7_2 G D6_2 B sg13_hv_pmos ad=3.6p pd=10.72u as=3.6p ps=10.72u w=10u l=0.4u
X26 a_1048_4220# G S9_7 B sg13_hv_pmos ad=6.8p pd=21.36u as=3.6p ps=10.72u w=10u l=0.4u
X27 S1_9 G D0_9 B sg13_hv_pmos ad=3.6p pd=10.72u as=6.8p ps=21.36u w=10u l=0.4u
X28 D8_4 G S7_4 B sg13_hv_pmos ad=3.6p pd=10.72u as=3.6p ps=10.72u w=10u l=0.4u
X29 D6_4 G S5_4 B sg13_hv_pmos ad=3.6p pd=10.72u as=3.6p ps=10.72u w=10u l=0.4u
X30 S9_0 G D8_0 B sg13_hv_pmos ad=3.6p pd=10.72u as=3.6p ps=10.72u w=10u l=0.4u
X31 D2_2 G S1_2 B sg13_hv_pmos ad=3.6p pd=10.72u as=3.6p ps=10.72u w=10u l=0.4u
X32 D6_8 G S5_8 B sg13_hv_pmos ad=3.6p pd=10.72u as=3.6p ps=10.72u w=10u l=0.4u
X33 S7_3 G D6_3 B sg13_hv_pmos ad=3.6p pd=10.72u as=3.6p ps=10.72u w=10u l=0.4u
X34 S3_5 G D2_5 B sg13_hv_pmos ad=3.6p pd=10.72u as=3.6p ps=10.72u w=10u l=0.4u
X35 S3_1 G D2_1 B sg13_hv_pmos ad=3.6p pd=10.72u as=3.6p ps=10.72u w=10u l=0.4u
X36 S9_8 G D8_8 B sg13_hv_pmos ad=3.6p pd=10.72u as=3.6p ps=10.72u w=10u l=0.4u
X37 D2_9 G S1_9 B sg13_hv_pmos ad=3.6p pd=10.72u as=3.6p ps=10.72u w=10u l=0.4u
X38 S7_6 G D6_6 B sg13_hv_pmos ad=3.6p pd=10.72u as=3.6p ps=10.72u w=10u l=0.4u
X39 D2_3 G S1_3 B sg13_hv_pmos ad=3.6p pd=10.72u as=3.6p ps=10.72u w=10u l=0.4u
X40 D6_7 G S5_7 B sg13_hv_pmos ad=3.6p pd=10.72u as=3.6p ps=10.72u w=10u l=0.4u
X41 S9_7 G D8_7 B sg13_hv_pmos ad=3.6p pd=10.72u as=3.6p ps=10.72u w=10u l=0.4u
X42 S1_2 G D0_2 B sg13_hv_pmos ad=3.6p pd=10.72u as=6.8p ps=21.36u w=10u l=0.4u
X43 S9_4 G D8_4 B sg13_hv_pmos ad=3.6p pd=10.72u as=3.6p ps=10.72u w=10u l=0.4u
X44 S3_9 G D2_9 B sg13_hv_pmos ad=3.6p pd=10.72u as=3.6p ps=10.72u w=10u l=0.4u
X45 D8_8 G S7_8 B sg13_hv_pmos ad=3.6p pd=10.72u as=3.6p ps=10.72u w=10u l=0.4u
X46 S1_3 G D0_3 B sg13_hv_pmos ad=3.6p pd=10.72u as=6.8p ps=21.36u w=10u l=0.4u
X47 S7_0 G D6_0 B sg13_hv_pmos ad=3.6p pd=10.72u as=3.6p ps=10.72u w=10u l=0.4u
X48 D8_2 G S7_2 B sg13_hv_pmos ad=3.6p pd=10.72u as=3.6p ps=10.72u w=10u l=0.4u
X49 D8_7 G S7_7 B sg13_hv_pmos ad=3.6p pd=10.72u as=3.6p ps=10.72u w=10u l=0.4u
X50 D6_2 G S5_2 B sg13_hv_pmos ad=3.6p pd=10.72u as=3.6p ps=10.72u w=10u l=0.4u
X51 D8_0 G S7_0 B sg13_hv_pmos ad=3.6p pd=10.72u as=3.6p ps=10.72u w=10u l=0.4u
X52 S7_1 G D6_1 B sg13_hv_pmos ad=3.6p pd=10.72u as=3.6p ps=10.72u w=10u l=0.4u
X53 D2_5 G S1_5 B sg13_hv_pmos ad=3.6p pd=10.72u as=3.6p ps=10.72u w=10u l=0.4u
X54 D8_3 G S7_3 B sg13_hv_pmos ad=3.6p pd=10.72u as=3.6p ps=10.72u w=10u l=0.4u
X55 D6_3 G S5_3 B sg13_hv_pmos ad=3.6p pd=10.72u as=3.6p ps=10.72u w=10u l=0.4u
X56 S7_8 G D6_8 B sg13_hv_pmos ad=3.6p pd=10.72u as=3.6p ps=10.72u w=10u l=0.4u
X57 D4_9 G S3_9 B sg13_hv_pmos ad=3.6p pd=10.72u as=3.6p ps=10.72u w=10u l=0.4u
X58 S9_5 G D8_5 B sg13_hv_pmos ad=3.6p pd=10.72u as=3.6p ps=10.72u w=10u l=0.4u
X59 D2_1 G S1_1 B sg13_hv_pmos ad=3.6p pd=10.72u as=3.6p ps=10.72u w=10u l=0.4u
X60 a_1048_n2044# G S9_4 B sg13_hv_pmos ad=6.8p pd=21.36u as=3.6p ps=10.72u w=10u l=0.4u
X61 S7_7 G D6_7 B sg13_hv_pmos ad=3.6p pd=10.72u as=3.6p ps=10.72u w=10u l=0.4u
X62 S1_6 G D0_6 B sg13_hv_pmos ad=3.6p pd=10.72u as=6.8p ps=21.36u w=10u l=0.4u
X63 S5_4 G D4_4 B sg13_hv_pmos ad=3.6p pd=10.72u as=3.6p ps=10.72u w=10u l=0.4u
X64 D4_5 G S3_5 B sg13_hv_pmos ad=3.6p pd=10.72u as=3.6p ps=10.72u w=10u l=0.4u
X65 S9_2 G D8_2 B sg13_hv_pmos ad=3.6p pd=10.72u as=3.6p ps=10.72u w=10u l=0.4u
X66 S1_5 G D0_5 B sg13_hv_pmos ad=3.6p pd=10.72u as=6.8p ps=21.36u w=10u l=0.4u
X67 S7_5 G D6_5 B sg13_hv_pmos ad=3.6p pd=10.72u as=3.6p ps=10.72u w=10u l=0.4u
X68 D2_6 G S1_6 B sg13_hv_pmos ad=3.6p pd=10.72u as=3.6p ps=10.72u w=10u l=0.4u
X69 S5_9 G D4_9 B sg13_hv_pmos ad=3.6p pd=10.72u as=3.6p ps=10.72u w=10u l=0.4u
X70 S1_1 G D0_1 B sg13_hv_pmos ad=3.6p pd=10.72u as=6.8p ps=21.36u w=10u l=0.4u
X71 S9_3 G D8_3 B sg13_hv_pmos ad=3.6p pd=10.72u as=3.6p ps=10.72u w=10u l=0.4u
X72 a_1048_8396# G S9_9 B sg13_hv_pmos ad=6.8p pd=21.36u as=3.6p ps=10.72u w=10u l=0.4u
X73 D8_1 G S7_1 B sg13_hv_pmos ad=3.6p pd=10.72u as=3.6p ps=10.72u w=10u l=0.4u
X74 D6_1 G S5_1 B sg13_hv_pmos ad=3.6p pd=10.72u as=3.6p ps=10.72u w=10u l=0.4u
X75 D4_4 G S3_4 B sg13_hv_pmos ad=3.6p pd=10.72u as=3.6p ps=10.72u w=10u l=0.4u
X76 S3_6 G D2_6 B sg13_hv_pmos ad=3.6p pd=10.72u as=3.6p ps=10.72u w=10u l=0.4u
X77 D6_0 G S5_0 B sg13_hv_pmos ad=3.6p pd=10.72u as=3.6p ps=10.72u w=10u l=0.4u
X78 a_1048_n6220# G S9_2 B sg13_hv_pmos ad=6.8p pd=21.36u as=3.6p ps=10.72u w=10u l=0.4u
X79 S1_8 G D0_8 B sg13_hv_pmos ad=3.6p pd=10.72u as=6.8p ps=21.36u w=10u l=0.4u
X80 D6_9 G S5_9 B sg13_hv_pmos ad=3.6p pd=10.72u as=3.6p ps=10.72u w=10u l=0.4u
X81 a_1048_n4132# G S9_3 B sg13_hv_pmos ad=6.8p pd=21.36u as=3.6p ps=10.72u w=10u l=0.4u
X82 S5_2 G D4_2 B sg13_hv_pmos ad=3.6p pd=10.72u as=3.6p ps=10.72u w=10u l=0.4u
X83 S9_9 G D8_9 B sg13_hv_pmos ad=3.6p pd=10.72u as=3.6p ps=10.72u w=10u l=0.4u
X84 S3_0 G D2_0 B sg13_hv_pmos ad=3.6p pd=10.72u as=3.6p ps=10.72u w=10u l=0.4u
X85 D8_5 G S7_5 B sg13_hv_pmos ad=3.6p pd=10.72u as=3.6p ps=10.72u w=10u l=0.4u
X86 S1_7 G D0_7 B sg13_hv_pmos ad=3.6p pd=10.72u as=6.8p ps=21.36u w=10u l=0.4u
X87 D2_8 G S1_8 B sg13_hv_pmos ad=3.6p pd=10.72u as=3.6p ps=10.72u w=10u l=0.4u
X88 S5_3 G D4_3 B sg13_hv_pmos ad=3.6p pd=10.72u as=3.6p ps=10.72u w=10u l=0.4u
X89 D4_6 G S3_6 B sg13_hv_pmos ad=3.6p pd=10.72u as=3.6p ps=10.72u w=10u l=0.4u
X90 D2_0 G S1_0 B sg13_hv_pmos ad=3.6p pd=10.72u as=3.6p ps=10.72u w=10u l=0.4u
X91 S9_1 G D8_1 B sg13_hv_pmos ad=3.6p pd=10.72u as=3.6p ps=10.72u w=10u l=0.4u
X92 S3_4 G D2_4 B sg13_hv_pmos ad=3.6p pd=10.72u as=3.6p ps=10.72u w=10u l=0.4u
X93 D2_7 G S1_7 B sg13_hv_pmos ad=3.6p pd=10.72u as=3.6p ps=10.72u w=10u l=0.4u
X94 S5_5 G D4_5 B sg13_hv_pmos ad=3.6p pd=10.72u as=3.6p ps=10.72u w=10u l=0.4u
X95 D8_9 G S7_9 B sg13_hv_pmos ad=3.6p pd=10.72u as=3.6p ps=10.72u w=10u l=0.4u
X96 D4_2 G S3_2 B sg13_hv_pmos ad=3.6p pd=10.72u as=3.6p ps=10.72u w=10u l=0.4u
X97 S3_8 G D2_8 B sg13_hv_pmos ad=3.6p pd=10.72u as=3.6p ps=10.72u w=10u l=0.4u
X98 S5_6 G D4_6 B sg13_hv_pmos ad=3.6p pd=10.72u as=3.6p ps=10.72u w=10u l=0.4u
X99 D4_3 G S3_3 B sg13_hv_pmos ad=3.6p pd=10.72u as=3.6p ps=10.72u w=10u l=0.4u
.ends

.subckt sg13_hv_nmos_XAVYYR D0 G0 S1 G1 D2 G2 S3 G3 sub a_314_n200#
X0 S3 G2 D2 sub sg13_hv_nmos ad=0.38p pd=2.38u as=0.38p ps=2.38u w=2u l=0.5u
X1 D2 G1 S1 sub sg13_hv_nmos ad=0.38p pd=2.38u as=0.38p ps=2.38u w=2u l=0.5u
X2 S1 G0 D0 sub sg13_hv_nmos ad=0.38p pd=2.38u as=0.68p ps=4.68u w=2u l=0.5u
X3 a_314_n200# G3 S3 sub sg13_hv_nmos ad=0.68p pd=4.68u as=0.38p ps=2.38u w=2u l=0.5u
.ends

.subckt sg13_hv_nmos_3JX36Y D0 G0 S1 G1 D2 G2 S3 G3 D4 G4 S5 G5 D6 G6 S7 G7 D8 G8
+ S9 G9 D10 G10 S11 G11 D12 G12 S13 G13 D14 G14 S15 G15 D16 G16 S17 G17 D18 G18 S19
+ G19 D20 G20 S21 G21 D22 G22 S23 G23 D24 G24 S25 G25 D26 G26 S27 G27 D28 G28 S29
+ G29 D30 G30 S31 G31 D32 G32 S33 G33 D34 G34 S35 G35 D36 G36 S37 G37 D38 G38 S39
+ G39 D40 G40 S41 G41 D42 G42 S43 G43 D44 G44 S45 G45 D46 G46 S47 G47 D48 G48 S49
+ G49 D50 G50 S51 G51 D52 G52 S53 G53 D54 G54 S55 G55 D56 G56 S57 G57 D58 G58 S59
+ G59 D60 G60 S61 G61 D62 G62 S63 G63 D64 G64 S65 G65 D66 G66 S67 G67 D68 G68 S69
+ G69 D70 G70 S71 G71 D72 G72 S73 G73 D74 G74 S75 G75 D76 G76 S77 G77 D78 G78 S79
+ G79 D80 G80 S81 G81 D82 G82 S83 G83 D84 G84 S85 G85 D86 G86 S87 G87 a_7706_n500#
+ sub
X0 S27 G26 D26 sub sg13_hv_nmos ad=0.95p pd=5.38u as=0.95p ps=5.38u w=5u l=0.5u
X1 D46 G45 S45 sub sg13_hv_nmos ad=0.95p pd=5.38u as=0.95p ps=5.38u w=5u l=0.5u
X2 D8 G7 S7 sub sg13_hv_nmos ad=0.95p pd=5.38u as=0.95p ps=5.38u w=5u l=0.5u
X3 S15 G14 D14 sub sg13_hv_nmos ad=0.95p pd=5.38u as=0.95p ps=5.38u w=5u l=0.5u
X4 D42 G41 S41 sub sg13_hv_nmos ad=0.95p pd=5.38u as=0.95p ps=5.38u w=5u l=0.5u
X5 D56 G55 S55 sub sg13_hv_nmos ad=0.95p pd=5.38u as=0.95p ps=5.38u w=5u l=0.5u
X6 D74 G73 S73 sub sg13_hv_nmos ad=0.95p pd=5.38u as=0.95p ps=5.38u w=5u l=0.5u
X7 S81 G80 D80 sub sg13_hv_nmos ad=0.95p pd=5.38u as=0.95p ps=5.38u w=5u l=0.5u
X8 D6 G5 S5 sub sg13_hv_nmos ad=0.95p pd=5.38u as=0.95p ps=5.38u w=5u l=0.5u
X9 S83 G82 D82 sub sg13_hv_nmos ad=0.95p pd=5.38u as=0.95p ps=5.38u w=5u l=0.5u
X10 S19 G18 D18 sub sg13_hv_nmos ad=0.95p pd=5.38u as=0.95p ps=5.38u w=5u l=0.5u
X11 S21 G20 D20 sub sg13_hv_nmos ad=0.95p pd=5.38u as=0.95p ps=5.38u w=5u l=0.5u
X12 D26 G25 S25 sub sg13_hv_nmos ad=0.95p pd=5.38u as=0.95p ps=5.38u w=5u l=0.5u
X13 S63 G62 D62 sub sg13_hv_nmos ad=0.95p pd=5.38u as=0.95p ps=5.38u w=5u l=0.5u
X14 D68 G67 S67 sub sg13_hv_nmos ad=0.95p pd=5.38u as=0.95p ps=5.38u w=5u l=0.5u
X15 D70 G69 S69 sub sg13_hv_nmos ad=0.95p pd=5.38u as=0.95p ps=5.38u w=5u l=0.5u
X16 D12 G11 S11 sub sg13_hv_nmos ad=0.95p pd=5.38u as=0.95p ps=5.38u w=5u l=0.5u
X17 S41 G40 D40 sub sg13_hv_nmos ad=0.95p pd=5.38u as=0.95p ps=5.38u w=5u l=0.5u
X18 D82 G81 S81 sub sg13_hv_nmos ad=0.95p pd=5.38u as=0.95p ps=5.38u w=5u l=0.5u
X19 D84 G83 S83 sub sg13_hv_nmos ad=0.95p pd=5.38u as=0.95p ps=5.38u w=5u l=0.5u
X20 D32 G31 S31 sub sg13_hv_nmos ad=0.95p pd=5.38u as=0.95p ps=5.38u w=5u l=0.5u
X21 S39 G38 D38 sub sg13_hv_nmos ad=0.95p pd=5.38u as=0.95p ps=5.38u w=5u l=0.5u
X22 D48 G47 S47 sub sg13_hv_nmos ad=0.95p pd=5.38u as=0.95p ps=5.38u w=5u l=0.5u
X23 D62 G61 S61 sub sg13_hv_nmos ad=0.95p pd=5.38u as=0.95p ps=5.38u w=5u l=0.5u
X24 S13 G12 D12 sub sg13_hv_nmos ad=0.95p pd=5.38u as=0.95p ps=5.38u w=5u l=0.5u
X25 D18 G17 S17 sub sg13_hv_nmos ad=0.95p pd=5.38u as=0.95p ps=5.38u w=5u l=0.5u
X26 D20 G19 S19 sub sg13_hv_nmos ad=0.95p pd=5.38u as=0.95p ps=5.38u w=5u l=0.5u
X27 D50 G49 S49 sub sg13_hv_nmos ad=0.95p pd=5.38u as=0.95p ps=5.38u w=5u l=0.5u
X28 S69 G68 D68 sub sg13_hv_nmos ad=0.95p pd=5.38u as=0.95p ps=5.38u w=5u l=0.5u
X29 S71 G70 D70 sub sg13_hv_nmos ad=0.95p pd=5.38u as=0.95p ps=5.38u w=5u l=0.5u
X30 D76 G75 S75 sub sg13_hv_nmos ad=0.95p pd=5.38u as=0.95p ps=5.38u w=5u l=0.5u
X31 S11 G10 D10 sub sg13_hv_nmos ad=0.95p pd=5.38u as=0.95p ps=5.38u w=5u l=0.5u
X32 D40 G39 S39 sub sg13_hv_nmos ad=0.95p pd=5.38u as=0.95p ps=5.38u w=5u l=0.5u
X33 D78 G77 S77 sub sg13_hv_nmos ad=0.95p pd=5.38u as=0.95p ps=5.38u w=5u l=0.5u
X34 S33 G32 D32 sub sg13_hv_nmos ad=0.95p pd=5.38u as=0.95p ps=5.38u w=5u l=0.5u
X35 S47 G46 D46 sub sg13_hv_nmos ad=0.95p pd=5.38u as=0.95p ps=5.38u w=5u l=0.5u
X36 D58 G57 S57 sub sg13_hv_nmos ad=0.95p pd=5.38u as=0.95p ps=5.38u w=5u l=0.5u
X37 D24 G23 S23 sub sg13_hv_nmos ad=0.95p pd=5.38u as=0.95p ps=5.38u w=5u l=0.5u
X38 S31 G30 D30 sub sg13_hv_nmos ad=0.95p pd=5.38u as=0.95p ps=5.38u w=5u l=0.5u
X39 S49 G48 D48 sub sg13_hv_nmos ad=0.95p pd=5.38u as=0.95p ps=5.38u w=5u l=0.5u
X40 S65 G64 D64 sub sg13_hv_nmos ad=0.95p pd=5.38u as=0.95p ps=5.38u w=5u l=0.5u
X41 S17 G16 D16 sub sg13_hv_nmos ad=0.95p pd=5.38u as=0.95p ps=5.38u w=5u l=0.5u
X42 S77 G76 D76 sub sg13_hv_nmos ad=0.95p pd=5.38u as=0.95p ps=5.38u w=5u l=0.5u
X43 S37 G36 D36 sub sg13_hv_nmos ad=0.95p pd=5.38u as=0.95p ps=5.38u w=5u l=0.5u
X44 S57 G56 D56 sub sg13_hv_nmos ad=0.95p pd=5.38u as=0.95p ps=5.38u w=5u l=0.5u
X45 S5 G4 D4 sub sg13_hv_nmos ad=0.95p pd=5.38u as=0.95p ps=5.38u w=5u l=0.5u
X46 S23 G22 D22 sub sg13_hv_nmos ad=0.95p pd=5.38u as=0.95p ps=5.38u w=5u l=0.5u
X47 S25 G24 D24 sub sg13_hv_nmos ad=0.95p pd=5.38u as=0.95p ps=5.38u w=5u l=0.5u
X48 D30 G29 S29 sub sg13_hv_nmos ad=0.95p pd=5.38u as=0.95p ps=5.38u w=5u l=0.5u
X49 S45 G44 D44 sub sg13_hv_nmos ad=0.95p pd=5.38u as=0.95p ps=5.38u w=5u l=0.5u
X50 S59 G58 D58 sub sg13_hv_nmos ad=0.95p pd=5.38u as=0.95p ps=5.38u w=5u l=0.5u
X51 D64 G63 S63 sub sg13_hv_nmos ad=0.95p pd=5.38u as=0.95p ps=5.38u w=5u l=0.5u
X52 D66 G65 S65 sub sg13_hv_nmos ad=0.95p pd=5.38u as=0.95p ps=5.38u w=5u l=0.5u
X53 S73 G72 D72 sub sg13_hv_nmos ad=0.95p pd=5.38u as=0.95p ps=5.38u w=5u l=0.5u
X54 D38 G37 S37 sub sg13_hv_nmos ad=0.95p pd=5.38u as=0.95p ps=5.38u w=5u l=0.5u
X55 S51 G50 D50 sub sg13_hv_nmos ad=0.95p pd=5.38u as=0.95p ps=5.38u w=5u l=0.5u
X56 S53 G52 D52 sub sg13_hv_nmos ad=0.95p pd=5.38u as=0.95p ps=5.38u w=5u l=0.5u
X57 D4 G3 S3 sub sg13_hv_nmos ad=0.95p pd=5.38u as=0.95p ps=5.38u w=5u l=0.5u
X58 S29 G28 D28 sub sg13_hv_nmos ad=0.95p pd=5.38u as=0.95p ps=5.38u w=5u l=0.5u
X59 D36 G35 S35 sub sg13_hv_nmos ad=0.95p pd=5.38u as=0.95p ps=5.38u w=5u l=0.5u
X60 D60 G59 S59 sub sg13_hv_nmos ad=0.95p pd=5.38u as=0.95p ps=5.38u w=5u l=0.5u
X61 S85 G84 D84 sub sg13_hv_nmos ad=0.95p pd=5.38u as=0.95p ps=5.38u w=5u l=0.5u
X62 D2 G1 S1 sub sg13_hv_nmos ad=0.95p pd=5.38u as=0.95p ps=5.38u w=5u l=0.5u
X63 S67 G66 D66 sub sg13_hv_nmos ad=0.95p pd=5.38u as=0.95p ps=5.38u w=5u l=0.5u
X64 D72 G71 S71 sub sg13_hv_nmos ad=0.95p pd=5.38u as=0.95p ps=5.38u w=5u l=0.5u
X65 D22 G21 S21 sub sg13_hv_nmos ad=0.95p pd=5.38u as=0.95p ps=5.38u w=5u l=0.5u
X66 D52 G51 S51 sub sg13_hv_nmos ad=0.95p pd=5.38u as=0.95p ps=5.38u w=5u l=0.5u
X67 S3 G2 D2 sub sg13_hv_nmos ad=0.95p pd=5.38u as=0.95p ps=5.38u w=5u l=0.5u
X68 D10 G9 S9 sub sg13_hv_nmos ad=0.95p pd=5.38u as=0.95p ps=5.38u w=5u l=0.5u
X69 D28 G27 S27 sub sg13_hv_nmos ad=0.95p pd=5.38u as=0.95p ps=5.38u w=5u l=0.5u
X70 S35 G34 D34 sub sg13_hv_nmos ad=0.95p pd=5.38u as=0.95p ps=5.38u w=5u l=0.5u
X71 D44 G43 S43 sub sg13_hv_nmos ad=0.95p pd=5.38u as=0.95p ps=5.38u w=5u l=0.5u
X72 D54 G53 S53 sub sg13_hv_nmos ad=0.95p pd=5.38u as=0.95p ps=5.38u w=5u l=0.5u
X73 S61 G60 D60 sub sg13_hv_nmos ad=0.95p pd=5.38u as=0.95p ps=5.38u w=5u l=0.5u
X74 S79 G78 D78 sub sg13_hv_nmos ad=0.95p pd=5.38u as=0.95p ps=5.38u w=5u l=0.5u
X75 D86 G85 S85 sub sg13_hv_nmos ad=0.95p pd=5.38u as=0.95p ps=5.38u w=5u l=0.5u
X76 S1 G0 D0 sub sg13_hv_nmos ad=0.95p pd=5.38u as=1.7p ps=10.68u w=5u l=0.5u
X77 a_7706_n500# G87 S87 sub sg13_hv_nmos ad=1.7p pd=10.68u as=0.95p ps=5.38u w=5u l=0.5u
X78 S9 G8 D8 sub sg13_hv_nmos ad=0.95p pd=5.38u as=0.95p ps=5.38u w=5u l=0.5u
X79 D14 G13 S13 sub sg13_hv_nmos ad=0.95p pd=5.38u as=0.95p ps=5.38u w=5u l=0.5u
X80 D16 G15 S15 sub sg13_hv_nmos ad=0.95p pd=5.38u as=0.95p ps=5.38u w=5u l=0.5u
X81 D34 G33 S33 sub sg13_hv_nmos ad=0.95p pd=5.38u as=0.95p ps=5.38u w=5u l=0.5u
X82 S43 G42 D42 sub sg13_hv_nmos ad=0.95p pd=5.38u as=0.95p ps=5.38u w=5u l=0.5u
X83 S55 G54 D54 sub sg13_hv_nmos ad=0.95p pd=5.38u as=0.95p ps=5.38u w=5u l=0.5u
X84 S75 G74 D74 sub sg13_hv_nmos ad=0.95p pd=5.38u as=0.95p ps=5.38u w=5u l=0.5u
X85 D80 G79 S79 sub sg13_hv_nmos ad=0.95p pd=5.38u as=0.95p ps=5.38u w=5u l=0.5u
X86 S7 G6 D6 sub sg13_hv_nmos ad=0.95p pd=5.38u as=0.95p ps=5.38u w=5u l=0.5u
X87 S87 G86 D86 sub sg13_hv_nmos ad=0.95p pd=5.38u as=0.95p ps=5.38u w=5u l=0.5u
.ends

.subckt sg13_hv_pmos_RQMCRC D0 G0 S1 G1 D2 G2 S3 G3 D4 G4 S5 G5 D6 G6 S7 G7 D8 G8
+ S9 G9 D10 G10 S11 G11 D12 G12 S13 G13 D14 G14 S15 G15 D16 G16 S17 G17 D18 G18 S19
+ G19 D20 G20 S21 G21 D22 G22 S23 G23 D24 G24 S25 G25 D26 G26 S27 G27 D28 G28 S29
+ G29 D30 G30 S31 G31 D32 G32 S33 G33 D34 G34 S35 G35 D36 G36 S37 G37 D38 G38 S39
+ G39 D40 G40 S41 G41 D42 G42 S43 G43 D44 G44 S45 G45 D46 G46 S47 G47 D48 G48 S49
+ G49 D50 G50 S51 G51 D52 G52 S53 G53 D54 G54 S55 G55 D56 G56 S57 G57 D58 G58 S59
+ G59 D60 G60 S61 G61 D62 G62 S63 G63 D64 G64 S65 G65 D66 G66 S67 G67 D68 G68 S69
+ G69 D70 G70 S71 G71 D72 G72 S73 G73 D74 G74 S75 G75 D76 G76 S77 G77 D78 G78 S79
+ G79 D80 G80 S81 G81 D82 G82 S83 G83 D84 G84 S85 G85 D86 G86 S87 G87 w_n7898_n1124#
+ a_7706_n1000#
X0 D30 G29 S29 w_n7898_n1124# sg13_hv_pmos ad=1.9p pd=10.38u as=1.9p ps=10.38u w=10u l=0.5u
X1 S37 G36 D36 w_n7898_n1124# sg13_hv_pmos ad=1.9p pd=10.38u as=1.9p ps=10.38u w=10u l=0.5u
X2 S45 G44 D44 w_n7898_n1124# sg13_hv_pmos ad=1.9p pd=10.38u as=1.9p ps=10.38u w=10u l=0.5u
X3 S57 G56 D56 w_n7898_n1124# sg13_hv_pmos ad=1.9p pd=10.38u as=1.9p ps=10.38u w=10u l=0.5u
X4 S59 G58 D58 w_n7898_n1124# sg13_hv_pmos ad=1.9p pd=10.38u as=1.9p ps=10.38u w=10u l=0.5u
X5 D64 G63 S63 w_n7898_n1124# sg13_hv_pmos ad=1.9p pd=10.38u as=1.9p ps=10.38u w=10u l=0.5u
X6 S5 G4 D4 w_n7898_n1124# sg13_hv_pmos ad=1.9p pd=10.38u as=1.9p ps=10.38u w=10u l=0.5u
X7 S23 G22 D22 w_n7898_n1124# sg13_hv_pmos ad=1.9p pd=10.38u as=1.9p ps=10.38u w=10u l=0.5u
X8 S25 G24 D24 w_n7898_n1124# sg13_hv_pmos ad=1.9p pd=10.38u as=1.9p ps=10.38u w=10u l=0.5u
X9 D66 G65 S65 w_n7898_n1124# sg13_hv_pmos ad=1.9p pd=10.38u as=1.9p ps=10.38u w=10u l=0.5u
X10 S73 G72 D72 w_n7898_n1124# sg13_hv_pmos ad=1.9p pd=10.38u as=1.9p ps=10.38u w=10u l=0.5u
X11 D36 G35 S35 w_n7898_n1124# sg13_hv_pmos ad=1.9p pd=10.38u as=1.9p ps=10.38u w=10u l=0.5u
X12 D38 G37 S37 w_n7898_n1124# sg13_hv_pmos ad=1.9p pd=10.38u as=1.9p ps=10.38u w=10u l=0.5u
X13 S51 G50 D50 w_n7898_n1124# sg13_hv_pmos ad=1.9p pd=10.38u as=1.9p ps=10.38u w=10u l=0.5u
X14 S53 G52 D52 w_n7898_n1124# sg13_hv_pmos ad=1.9p pd=10.38u as=1.9p ps=10.38u w=10u l=0.5u
X15 D60 G59 S59 w_n7898_n1124# sg13_hv_pmos ad=1.9p pd=10.38u as=1.9p ps=10.38u w=10u l=0.5u
X16 D2 G1 S1 w_n7898_n1124# sg13_hv_pmos ad=1.9p pd=10.38u as=1.9p ps=10.38u w=10u l=0.5u
X17 D4 G3 S3 w_n7898_n1124# sg13_hv_pmos ad=1.9p pd=10.38u as=1.9p ps=10.38u w=10u l=0.5u
X18 S29 G28 D28 w_n7898_n1124# sg13_hv_pmos ad=1.9p pd=10.38u as=1.9p ps=10.38u w=10u l=0.5u
X19 S67 G66 D66 w_n7898_n1124# sg13_hv_pmos ad=1.9p pd=10.38u as=1.9p ps=10.38u w=10u l=0.5u
X20 D72 G71 S71 w_n7898_n1124# sg13_hv_pmos ad=1.9p pd=10.38u as=1.9p ps=10.38u w=10u l=0.5u
X21 S85 G84 D84 w_n7898_n1124# sg13_hv_pmos ad=1.9p pd=10.38u as=1.9p ps=10.38u w=10u l=0.5u
X22 D22 G21 S21 w_n7898_n1124# sg13_hv_pmos ad=1.9p pd=10.38u as=1.9p ps=10.38u w=10u l=0.5u
X23 S35 G34 D34 w_n7898_n1124# sg13_hv_pmos ad=1.9p pd=10.38u as=1.9p ps=10.38u w=10u l=0.5u
X24 D44 G43 S43 w_n7898_n1124# sg13_hv_pmos ad=1.9p pd=10.38u as=1.9p ps=10.38u w=10u l=0.5u
X25 D52 G51 S51 w_n7898_n1124# sg13_hv_pmos ad=1.9p pd=10.38u as=1.9p ps=10.38u w=10u l=0.5u
X26 D54 G53 S53 w_n7898_n1124# sg13_hv_pmos ad=1.9p pd=10.38u as=1.9p ps=10.38u w=10u l=0.5u
X27 S79 G78 D78 w_n7898_n1124# sg13_hv_pmos ad=1.9p pd=10.38u as=1.9p ps=10.38u w=10u l=0.5u
X28 S1 G0 D0 w_n7898_n1124# sg13_hv_pmos ad=1.9p pd=10.38u as=3.4p ps=20.68u w=10u l=0.5u
X29 S3 G2 D2 w_n7898_n1124# sg13_hv_pmos ad=1.9p pd=10.38u as=1.9p ps=10.38u w=10u l=0.5u
X30 D10 G9 S9 w_n7898_n1124# sg13_hv_pmos ad=1.9p pd=10.38u as=1.9p ps=10.38u w=10u l=0.5u
X31 D28 G27 S27 w_n7898_n1124# sg13_hv_pmos ad=1.9p pd=10.38u as=1.9p ps=10.38u w=10u l=0.5u
X32 S61 G60 D60 w_n7898_n1124# sg13_hv_pmos ad=1.9p pd=10.38u as=1.9p ps=10.38u w=10u l=0.5u
X33 D86 G85 S85 w_n7898_n1124# sg13_hv_pmos ad=1.9p pd=10.38u as=1.9p ps=10.38u w=10u l=0.5u
X34 a_7706_n1000# G87 S87 w_n7898_n1124# sg13_hv_pmos ad=3.4p pd=20.68u as=1.9p ps=10.38u w=10u l=0.5u
X35 D16 G15 S15 w_n7898_n1124# sg13_hv_pmos ad=1.9p pd=10.38u as=1.9p ps=10.38u w=10u l=0.5u
X36 S55 G54 D54 w_n7898_n1124# sg13_hv_pmos ad=1.9p pd=10.38u as=1.9p ps=10.38u w=10u l=0.5u
X37 S75 G74 D74 w_n7898_n1124# sg13_hv_pmos ad=1.9p pd=10.38u as=1.9p ps=10.38u w=10u l=0.5u
X38 S7 G6 D6 w_n7898_n1124# sg13_hv_pmos ad=1.9p pd=10.38u as=1.9p ps=10.38u w=10u l=0.5u
X39 S9 G8 D8 w_n7898_n1124# sg13_hv_pmos ad=1.9p pd=10.38u as=1.9p ps=10.38u w=10u l=0.5u
X40 D14 G13 S13 w_n7898_n1124# sg13_hv_pmos ad=1.9p pd=10.38u as=1.9p ps=10.38u w=10u l=0.5u
X41 D34 G33 S33 w_n7898_n1124# sg13_hv_pmos ad=1.9p pd=10.38u as=1.9p ps=10.38u w=10u l=0.5u
X42 S43 G42 D42 w_n7898_n1124# sg13_hv_pmos ad=1.9p pd=10.38u as=1.9p ps=10.38u w=10u l=0.5u
X43 D80 G79 S79 w_n7898_n1124# sg13_hv_pmos ad=1.9p pd=10.38u as=1.9p ps=10.38u w=10u l=0.5u
X44 S87 G86 D86 w_n7898_n1124# sg13_hv_pmos ad=1.9p pd=10.38u as=1.9p ps=10.38u w=10u l=0.5u
X45 D46 G45 S45 w_n7898_n1124# sg13_hv_pmos ad=1.9p pd=10.38u as=1.9p ps=10.38u w=10u l=0.5u
X46 S27 G26 D26 w_n7898_n1124# sg13_hv_pmos ad=1.9p pd=10.38u as=1.9p ps=10.38u w=10u l=0.5u
X47 D74 G73 S73 w_n7898_n1124# sg13_hv_pmos ad=1.9p pd=10.38u as=1.9p ps=10.38u w=10u l=0.5u
X48 D6 G5 S5 w_n7898_n1124# sg13_hv_pmos ad=1.9p pd=10.38u as=1.9p ps=10.38u w=10u l=0.5u
X49 D8 G7 S7 w_n7898_n1124# sg13_hv_pmos ad=1.9p pd=10.38u as=1.9p ps=10.38u w=10u l=0.5u
X50 S15 G14 D14 w_n7898_n1124# sg13_hv_pmos ad=1.9p pd=10.38u as=1.9p ps=10.38u w=10u l=0.5u
X51 D42 G41 S41 w_n7898_n1124# sg13_hv_pmos ad=1.9p pd=10.38u as=1.9p ps=10.38u w=10u l=0.5u
X52 D56 G55 S55 w_n7898_n1124# sg13_hv_pmos ad=1.9p pd=10.38u as=1.9p ps=10.38u w=10u l=0.5u
X53 S81 G80 D80 w_n7898_n1124# sg13_hv_pmos ad=1.9p pd=10.38u as=1.9p ps=10.38u w=10u l=0.5u
X54 S83 G82 D82 w_n7898_n1124# sg13_hv_pmos ad=1.9p pd=10.38u as=1.9p ps=10.38u w=10u l=0.5u
X55 S21 G20 D20 w_n7898_n1124# sg13_hv_pmos ad=1.9p pd=10.38u as=1.9p ps=10.38u w=10u l=0.5u
X56 D26 G25 S25 w_n7898_n1124# sg13_hv_pmos ad=1.9p pd=10.38u as=1.9p ps=10.38u w=10u l=0.5u
X57 S63 G62 D62 w_n7898_n1124# sg13_hv_pmos ad=1.9p pd=10.38u as=1.9p ps=10.38u w=10u l=0.5u
X58 D68 G67 S67 w_n7898_n1124# sg13_hv_pmos ad=1.9p pd=10.38u as=1.9p ps=10.38u w=10u l=0.5u
X59 D70 G69 S69 w_n7898_n1124# sg13_hv_pmos ad=1.9p pd=10.38u as=1.9p ps=10.38u w=10u l=0.5u
X60 D12 G11 S11 w_n7898_n1124# sg13_hv_pmos ad=1.9p pd=10.38u as=1.9p ps=10.38u w=10u l=0.5u
X61 S19 G18 D18 w_n7898_n1124# sg13_hv_pmos ad=1.9p pd=10.38u as=1.9p ps=10.38u w=10u l=0.5u
X62 S41 G40 D40 w_n7898_n1124# sg13_hv_pmos ad=1.9p pd=10.38u as=1.9p ps=10.38u w=10u l=0.5u
X63 D82 G81 S81 w_n7898_n1124# sg13_hv_pmos ad=1.9p pd=10.38u as=1.9p ps=10.38u w=10u l=0.5u
X64 D84 G83 S83 w_n7898_n1124# sg13_hv_pmos ad=1.9p pd=10.38u as=1.9p ps=10.38u w=10u l=0.5u
X65 S39 G38 D38 w_n7898_n1124# sg13_hv_pmos ad=1.9p pd=10.38u as=1.9p ps=10.38u w=10u l=0.5u
X66 D32 G31 S31 w_n7898_n1124# sg13_hv_pmos ad=1.9p pd=10.38u as=1.9p ps=10.38u w=10u l=0.5u
X67 D48 G47 S47 w_n7898_n1124# sg13_hv_pmos ad=1.9p pd=10.38u as=1.9p ps=10.38u w=10u l=0.5u
X68 D50 G49 S49 w_n7898_n1124# sg13_hv_pmos ad=1.9p pd=10.38u as=1.9p ps=10.38u w=10u l=0.5u
X69 D62 G61 S61 w_n7898_n1124# sg13_hv_pmos ad=1.9p pd=10.38u as=1.9p ps=10.38u w=10u l=0.5u
X70 S69 G68 D68 w_n7898_n1124# sg13_hv_pmos ad=1.9p pd=10.38u as=1.9p ps=10.38u w=10u l=0.5u
X71 S11 G10 D10 w_n7898_n1124# sg13_hv_pmos ad=1.9p pd=10.38u as=1.9p ps=10.38u w=10u l=0.5u
X72 S13 G12 D12 w_n7898_n1124# sg13_hv_pmos ad=1.9p pd=10.38u as=1.9p ps=10.38u w=10u l=0.5u
X73 D18 G17 S17 w_n7898_n1124# sg13_hv_pmos ad=1.9p pd=10.38u as=1.9p ps=10.38u w=10u l=0.5u
X74 D20 G19 S19 w_n7898_n1124# sg13_hv_pmos ad=1.9p pd=10.38u as=1.9p ps=10.38u w=10u l=0.5u
X75 D40 G39 S39 w_n7898_n1124# sg13_hv_pmos ad=1.9p pd=10.38u as=1.9p ps=10.38u w=10u l=0.5u
X76 S71 G70 D70 w_n7898_n1124# sg13_hv_pmos ad=1.9p pd=10.38u as=1.9p ps=10.38u w=10u l=0.5u
X77 D76 G75 S75 w_n7898_n1124# sg13_hv_pmos ad=1.9p pd=10.38u as=1.9p ps=10.38u w=10u l=0.5u
X78 D78 G77 S77 w_n7898_n1124# sg13_hv_pmos ad=1.9p pd=10.38u as=1.9p ps=10.38u w=10u l=0.5u
X79 S31 G30 D30 w_n7898_n1124# sg13_hv_pmos ad=1.9p pd=10.38u as=1.9p ps=10.38u w=10u l=0.5u
X80 S33 G32 D32 w_n7898_n1124# sg13_hv_pmos ad=1.9p pd=10.38u as=1.9p ps=10.38u w=10u l=0.5u
X81 S47 G46 D46 w_n7898_n1124# sg13_hv_pmos ad=1.9p pd=10.38u as=1.9p ps=10.38u w=10u l=0.5u
X82 S49 G48 D48 w_n7898_n1124# sg13_hv_pmos ad=1.9p pd=10.38u as=1.9p ps=10.38u w=10u l=0.5u
X83 D58 G57 S57 w_n7898_n1124# sg13_hv_pmos ad=1.9p pd=10.38u as=1.9p ps=10.38u w=10u l=0.5u
X84 S65 G64 D64 w_n7898_n1124# sg13_hv_pmos ad=1.9p pd=10.38u as=1.9p ps=10.38u w=10u l=0.5u
X85 S17 G16 D16 w_n7898_n1124# sg13_hv_pmos ad=1.9p pd=10.38u as=1.9p ps=10.38u w=10u l=0.5u
X86 D24 G23 S23 w_n7898_n1124# sg13_hv_pmos ad=1.9p pd=10.38u as=1.9p ps=10.38u w=10u l=0.5u
X87 S77 G76 D76 w_n7898_n1124# sg13_hv_pmos ad=1.9p pd=10.38u as=1.9p ps=10.38u w=10u l=0.5u
.ends

.subckt sg13_hv_pmos_FG6ZZW D0 G0 S1 G1 D2 G2 S3 G3 a_314_n100# w_n506_n224#
X0 a_314_n100# G3 S3 w_n506_n224# sg13_hv_pmos ad=0.34p pd=2.68u as=0.19p ps=1.38u w=1u l=0.5u
X1 S3 G2 D2 w_n506_n224# sg13_hv_pmos ad=0.19p pd=1.38u as=0.19p ps=1.38u w=1u l=0.5u
X2 D2 G1 S1 w_n506_n224# sg13_hv_pmos ad=0.19p pd=1.38u as=0.19p ps=1.38u w=1u l=0.5u
X3 S1 G0 D0 w_n506_n224# sg13_hv_pmos ad=0.19p pd=1.38u as=0.34p ps=2.68u w=1u l=0.5u
.ends

.subckt gate_drive_large in_p in_n out vss vdd
Xsg13_hv_nmos_XAVYYR_0 vss in_p sg13_hv_pmos_FG6ZZW_0/S1 in_p vss in_n sg13_hv_pmos_RQMCRC_0/G1
+ in_n vss vss sg13_hv_nmos_XAVYYR
Xsg13_hv_nmos_3JX36Y_0 vss sg13_hv_pmos_RQMCRC_0/G1 sg13_hv_pmos_RQMCRC_0/S1 sg13_hv_pmos_RQMCRC_0/G1
+ vss sg13_hv_pmos_RQMCRC_0/S1 sg13_hv_pmos_RQMCRC_0/S7 sg13_hv_pmos_RQMCRC_0/S1 vss
+ sg13_hv_pmos_RQMCRC_0/S1 sg13_hv_pmos_RQMCRC_0/S7 sg13_hv_pmos_RQMCRC_0/S1 vss sg13_hv_pmos_RQMCRC_0/S1
+ sg13_hv_pmos_RQMCRC_0/S7 sg13_hv_pmos_RQMCRC_0/S1 vss sg13_hv_pmos_RQMCRC_0/S7 sg13_hv_pmos_RQMCRC_0/S9
+ sg13_hv_pmos_RQMCRC_0/S7 vss sg13_hv_pmos_RQMCRC_0/S7 sg13_hv_pmos_RQMCRC_0/S9 sg13_hv_pmos_RQMCRC_0/S7
+ vss sg13_hv_pmos_RQMCRC_0/S7 sg13_hv_pmos_RQMCRC_0/S9 sg13_hv_pmos_RQMCRC_0/S7 vss
+ sg13_hv_pmos_RQMCRC_0/S7 sg13_hv_pmos_RQMCRC_0/S9 sg13_hv_pmos_RQMCRC_0/S7 vss sg13_hv_pmos_RQMCRC_0/S7
+ sg13_hv_pmos_RQMCRC_0/S9 sg13_hv_pmos_RQMCRC_0/S7 vss sg13_hv_pmos_RQMCRC_0/S7 sg13_hv_pmos_RQMCRC_0/S9
+ sg13_hv_pmos_RQMCRC_0/S7 vss sg13_hv_pmos_RQMCRC_0/S7 sg13_hv_pmos_RQMCRC_0/S9 sg13_hv_pmos_RQMCRC_0/S7
+ vss sg13_hv_pmos_RQMCRC_0/S7 sg13_hv_pmos_RQMCRC_0/S9 sg13_hv_pmos_RQMCRC_0/S7 vss
+ sg13_hv_pmos_RQMCRC_0/S7 sg13_hv_pmos_RQMCRC_0/S9 sg13_hv_pmos_RQMCRC_0/S7 vss sg13_hv_pmos_RQMCRC_0/S7
+ sg13_hv_pmos_RQMCRC_0/S9 sg13_hv_pmos_RQMCRC_0/S7 vss sg13_hv_pmos_RQMCRC_0/S9 out
+ sg13_hv_pmos_RQMCRC_0/S9 vss sg13_hv_pmos_RQMCRC_0/S9 out sg13_hv_pmos_RQMCRC_0/S9
+ vss sg13_hv_pmos_RQMCRC_0/S9 out sg13_hv_pmos_RQMCRC_0/S9 vss sg13_hv_pmos_RQMCRC_0/S9
+ out sg13_hv_pmos_RQMCRC_0/S9 vss sg13_hv_pmos_RQMCRC_0/S9 out sg13_hv_pmos_RQMCRC_0/S9
+ vss sg13_hv_pmos_RQMCRC_0/S9 out sg13_hv_pmos_RQMCRC_0/S9 vss sg13_hv_pmos_RQMCRC_0/S9
+ out sg13_hv_pmos_RQMCRC_0/S9 vss sg13_hv_pmos_RQMCRC_0/S9 out sg13_hv_pmos_RQMCRC_0/S9
+ vss sg13_hv_pmos_RQMCRC_0/S9 out sg13_hv_pmos_RQMCRC_0/S9 vss sg13_hv_pmos_RQMCRC_0/S9
+ out sg13_hv_pmos_RQMCRC_0/S9 vss sg13_hv_pmos_RQMCRC_0/S9 out sg13_hv_pmos_RQMCRC_0/S9
+ vss sg13_hv_pmos_RQMCRC_0/S9 out sg13_hv_pmos_RQMCRC_0/S9 vss sg13_hv_pmos_RQMCRC_0/S9
+ out sg13_hv_pmos_RQMCRC_0/S9 vss sg13_hv_pmos_RQMCRC_0/S9 out sg13_hv_pmos_RQMCRC_0/S9
+ vss sg13_hv_pmos_RQMCRC_0/S9 out sg13_hv_pmos_RQMCRC_0/S9 vss sg13_hv_pmos_RQMCRC_0/S9
+ out sg13_hv_pmos_RQMCRC_0/S9 vss sg13_hv_pmos_RQMCRC_0/S9 out sg13_hv_pmos_RQMCRC_0/S9
+ vss sg13_hv_pmos_RQMCRC_0/S9 out sg13_hv_pmos_RQMCRC_0/S9 vss sg13_hv_pmos_RQMCRC_0/S9
+ out sg13_hv_pmos_RQMCRC_0/S9 vss sg13_hv_pmos_RQMCRC_0/S9 out sg13_hv_pmos_RQMCRC_0/S9
+ vss sg13_hv_pmos_RQMCRC_0/S9 out sg13_hv_pmos_RQMCRC_0/S9 vss sg13_hv_pmos_RQMCRC_0/S9
+ out sg13_hv_pmos_RQMCRC_0/S9 vss sg13_hv_pmos_RQMCRC_0/S9 out sg13_hv_pmos_RQMCRC_0/S9
+ vss sg13_hv_pmos_RQMCRC_0/S9 out sg13_hv_pmos_RQMCRC_0/S9 vss sg13_hv_pmos_RQMCRC_0/S9
+ out sg13_hv_pmos_RQMCRC_0/S9 vss sg13_hv_pmos_RQMCRC_0/S9 out sg13_hv_pmos_RQMCRC_0/S9
+ vss sg13_hv_pmos_RQMCRC_0/S9 out sg13_hv_pmos_RQMCRC_0/S9 vss sg13_hv_pmos_RQMCRC_0/S9
+ out sg13_hv_pmos_RQMCRC_0/S9 vss sg13_hv_pmos_RQMCRC_0/S9 out sg13_hv_pmos_RQMCRC_0/S9
+ vss sg13_hv_pmos_RQMCRC_0/S9 out sg13_hv_pmos_RQMCRC_0/S9 vss vss sg13_hv_nmos_3JX36Y
Xsg13_hv_pmos_RQMCRC_0 vdd sg13_hv_pmos_RQMCRC_0/G1 sg13_hv_pmos_RQMCRC_0/S1 sg13_hv_pmos_RQMCRC_0/G1
+ vdd sg13_hv_pmos_RQMCRC_0/S1 sg13_hv_pmos_RQMCRC_0/S7 sg13_hv_pmos_RQMCRC_0/S1 vdd
+ sg13_hv_pmos_RQMCRC_0/S1 sg13_hv_pmos_RQMCRC_0/S7 sg13_hv_pmos_RQMCRC_0/S1 vdd sg13_hv_pmos_RQMCRC_0/S1
+ sg13_hv_pmos_RQMCRC_0/S7 sg13_hv_pmos_RQMCRC_0/S1 vdd sg13_hv_pmos_RQMCRC_0/S7 sg13_hv_pmos_RQMCRC_0/S9
+ sg13_hv_pmos_RQMCRC_0/S7 vdd sg13_hv_pmos_RQMCRC_0/S7 sg13_hv_pmos_RQMCRC_0/S9 sg13_hv_pmos_RQMCRC_0/S7
+ vdd sg13_hv_pmos_RQMCRC_0/S7 sg13_hv_pmos_RQMCRC_0/S9 sg13_hv_pmos_RQMCRC_0/S7 vdd
+ sg13_hv_pmos_RQMCRC_0/S7 sg13_hv_pmos_RQMCRC_0/S9 sg13_hv_pmos_RQMCRC_0/S7 vdd sg13_hv_pmos_RQMCRC_0/S7
+ sg13_hv_pmos_RQMCRC_0/S9 sg13_hv_pmos_RQMCRC_0/S7 vdd sg13_hv_pmos_RQMCRC_0/S7 sg13_hv_pmos_RQMCRC_0/S9
+ sg13_hv_pmos_RQMCRC_0/S7 vdd sg13_hv_pmos_RQMCRC_0/S7 sg13_hv_pmos_RQMCRC_0/S9 sg13_hv_pmos_RQMCRC_0/S7
+ vdd sg13_hv_pmos_RQMCRC_0/S7 sg13_hv_pmos_RQMCRC_0/S9 sg13_hv_pmos_RQMCRC_0/S7 vdd
+ sg13_hv_pmos_RQMCRC_0/S7 sg13_hv_pmos_RQMCRC_0/S9 sg13_hv_pmos_RQMCRC_0/S7 vdd sg13_hv_pmos_RQMCRC_0/S7
+ sg13_hv_pmos_RQMCRC_0/S9 sg13_hv_pmos_RQMCRC_0/S7 vdd sg13_hv_pmos_RQMCRC_0/S9 out
+ sg13_hv_pmos_RQMCRC_0/S9 vdd sg13_hv_pmos_RQMCRC_0/S9 out sg13_hv_pmos_RQMCRC_0/S9
+ vdd sg13_hv_pmos_RQMCRC_0/S9 out sg13_hv_pmos_RQMCRC_0/S9 vdd sg13_hv_pmos_RQMCRC_0/S9
+ out sg13_hv_pmos_RQMCRC_0/S9 vdd sg13_hv_pmos_RQMCRC_0/S9 out sg13_hv_pmos_RQMCRC_0/S9
+ vdd sg13_hv_pmos_RQMCRC_0/S9 out sg13_hv_pmos_RQMCRC_0/S9 vdd sg13_hv_pmos_RQMCRC_0/S9
+ out sg13_hv_pmos_RQMCRC_0/S9 vdd sg13_hv_pmos_RQMCRC_0/S9 out sg13_hv_pmos_RQMCRC_0/S9
+ vdd sg13_hv_pmos_RQMCRC_0/S9 out sg13_hv_pmos_RQMCRC_0/S9 vdd sg13_hv_pmos_RQMCRC_0/S9
+ out sg13_hv_pmos_RQMCRC_0/S9 vdd sg13_hv_pmos_RQMCRC_0/S9 out sg13_hv_pmos_RQMCRC_0/S9
+ vdd sg13_hv_pmos_RQMCRC_0/S9 out sg13_hv_pmos_RQMCRC_0/S9 vdd sg13_hv_pmos_RQMCRC_0/S9
+ out sg13_hv_pmos_RQMCRC_0/S9 vdd sg13_hv_pmos_RQMCRC_0/S9 out sg13_hv_pmos_RQMCRC_0/S9
+ vdd sg13_hv_pmos_RQMCRC_0/S9 out sg13_hv_pmos_RQMCRC_0/S9 vdd sg13_hv_pmos_RQMCRC_0/S9
+ out sg13_hv_pmos_RQMCRC_0/S9 vdd sg13_hv_pmos_RQMCRC_0/S9 out sg13_hv_pmos_RQMCRC_0/S9
+ vdd sg13_hv_pmos_RQMCRC_0/S9 out sg13_hv_pmos_RQMCRC_0/S9 vdd sg13_hv_pmos_RQMCRC_0/S9
+ out sg13_hv_pmos_RQMCRC_0/S9 vdd sg13_hv_pmos_RQMCRC_0/S9 out sg13_hv_pmos_RQMCRC_0/S9
+ vdd sg13_hv_pmos_RQMCRC_0/S9 out sg13_hv_pmos_RQMCRC_0/S9 vdd sg13_hv_pmos_RQMCRC_0/S9
+ out sg13_hv_pmos_RQMCRC_0/S9 vdd sg13_hv_pmos_RQMCRC_0/S9 out sg13_hv_pmos_RQMCRC_0/S9
+ vdd sg13_hv_pmos_RQMCRC_0/S9 out sg13_hv_pmos_RQMCRC_0/S9 vdd sg13_hv_pmos_RQMCRC_0/S9
+ out sg13_hv_pmos_RQMCRC_0/S9 vdd sg13_hv_pmos_RQMCRC_0/S9 out sg13_hv_pmos_RQMCRC_0/S9
+ vdd sg13_hv_pmos_RQMCRC_0/S9 out sg13_hv_pmos_RQMCRC_0/S9 vdd sg13_hv_pmos_RQMCRC_0/S9
+ out sg13_hv_pmos_RQMCRC_0/S9 vdd sg13_hv_pmos_RQMCRC_0/S9 out sg13_hv_pmos_RQMCRC_0/S9
+ vdd sg13_hv_pmos_RQMCRC_0/S9 out sg13_hv_pmos_RQMCRC_0/S9 vdd vdd sg13_hv_pmos_RQMCRC
Xsg13_hv_pmos_FG6ZZW_0 vdd sg13_hv_pmos_RQMCRC_0/G1 sg13_hv_pmos_FG6ZZW_0/S1 sg13_hv_pmos_RQMCRC_0/G1
+ vdd sg13_hv_pmos_FG6ZZW_0/S1 sg13_hv_pmos_RQMCRC_0/G1 sg13_hv_pmos_FG6ZZW_0/S1 vdd
+ vdd sg13_hv_pmos_FG6ZZW
.ends

.subckt power_stage2 IOVDD_IN enable IOVSS IOVDD_OUT DVSS DVDD
Xsg13_hv_pmos_ZN7EJW_2 IOVDD_IN IOVDD_IN gate_drive_large_0/out IOVDD_IN IOVDD_IN
+ IOVDD_IN IOVDD_IN IOVDD_IN IOVDD_IN IOVDD_IN IOVDD_IN IOVDD_IN IOVDD_OUT IOVDD_OUT
+ IOVDD_OUT IOVDD_OUT IOVDD_OUT IOVDD_OUT IOVDD_OUT IOVDD_OUT IOVDD_OUT IOVDD_OUT
+ IOVDD_IN IOVDD_IN IOVDD_IN IOVDD_IN IOVDD_IN IOVDD_IN IOVDD_IN IOVDD_IN IOVDD_IN
+ IOVDD_IN IOVDD_OUT IOVDD_OUT IOVDD_OUT IOVDD_OUT IOVDD_OUT IOVDD_OUT IOVDD_OUT IOVDD_OUT
+ IOVDD_OUT IOVDD_OUT IOVDD_IN IOVDD_IN IOVDD_IN IOVDD_IN IOVDD_IN IOVDD_IN IOVDD_IN
+ IOVDD_IN IOVDD_IN IOVDD_IN IOVDD_OUT IOVDD_OUT IOVDD_OUT IOVDD_OUT IOVDD_OUT IOVDD_OUT
+ IOVDD_OUT IOVDD_OUT IOVDD_OUT IOVDD_OUT IOVDD_IN IOVDD_IN IOVDD_IN IOVDD_IN IOVDD_IN
+ IOVDD_IN IOVDD_IN IOVDD_IN IOVDD_IN IOVDD_IN IOVDD_OUT IOVDD_OUT IOVDD_OUT IOVDD_OUT
+ IOVDD_OUT IOVDD_OUT IOVDD_OUT IOVDD_OUT IOVDD_OUT IOVDD_OUT IOVDD_IN IOVDD_IN IOVDD_IN
+ IOVDD_IN IOVDD_IN IOVDD_IN IOVDD_IN IOVDD_IN IOVDD_IN IOVDD_IN IOVDD_OUT IOVDD_OUT
+ IOVDD_OUT IOVDD_OUT IOVDD_OUT IOVDD_OUT IOVDD_OUT IOVDD_OUT IOVDD_OUT IOVDD_OUT
+ IOVDD_IN IOVDD_IN IOVDD_IN IOVDD_IN IOVDD_IN IOVDD_IN IOVDD_IN IOVDD_IN IOVDD_IN
+ IOVDD_IN sg13_hv_pmos_ZN7EJW
Xsg13_hv_pmos_ZN7EJW_3 IOVDD_IN IOVDD_IN gate_drive_large_0/out IOVDD_IN IOVDD_IN
+ IOVDD_IN IOVDD_IN IOVDD_IN IOVDD_IN IOVDD_IN IOVDD_IN IOVDD_IN IOVDD_OUT IOVDD_OUT
+ IOVDD_OUT IOVDD_OUT IOVDD_OUT IOVDD_OUT IOVDD_OUT IOVDD_OUT IOVDD_OUT IOVDD_OUT
+ IOVDD_IN IOVDD_IN IOVDD_IN IOVDD_IN IOVDD_IN IOVDD_IN IOVDD_IN IOVDD_IN IOVDD_IN
+ IOVDD_IN IOVDD_OUT IOVDD_OUT IOVDD_OUT IOVDD_OUT IOVDD_OUT IOVDD_OUT IOVDD_OUT IOVDD_OUT
+ IOVDD_OUT IOVDD_OUT IOVDD_IN IOVDD_IN IOVDD_IN IOVDD_IN IOVDD_IN IOVDD_IN IOVDD_IN
+ IOVDD_IN IOVDD_IN IOVDD_IN IOVDD_OUT IOVDD_OUT IOVDD_OUT IOVDD_OUT IOVDD_OUT IOVDD_OUT
+ IOVDD_OUT IOVDD_OUT IOVDD_OUT IOVDD_OUT IOVDD_IN IOVDD_IN IOVDD_IN IOVDD_IN IOVDD_IN
+ IOVDD_IN IOVDD_IN IOVDD_IN IOVDD_IN IOVDD_IN IOVDD_OUT IOVDD_OUT IOVDD_OUT IOVDD_OUT
+ IOVDD_OUT IOVDD_OUT IOVDD_OUT IOVDD_OUT IOVDD_OUT IOVDD_OUT IOVDD_IN IOVDD_IN IOVDD_IN
+ IOVDD_IN IOVDD_IN IOVDD_IN IOVDD_IN IOVDD_IN IOVDD_IN IOVDD_IN IOVDD_OUT IOVDD_OUT
+ IOVDD_OUT IOVDD_OUT IOVDD_OUT IOVDD_OUT IOVDD_OUT IOVDD_OUT IOVDD_OUT IOVDD_OUT
+ IOVDD_IN IOVDD_IN IOVDD_IN IOVDD_IN IOVDD_IN IOVDD_IN IOVDD_IN IOVDD_IN IOVDD_IN
+ IOVDD_IN sg13_hv_pmos_ZN7EJW
Xsg13_hv_pmos_ZN7EJW_4 IOVDD_IN IOVDD_IN gate_drive_large_0/out IOVDD_IN IOVDD_IN
+ IOVDD_IN IOVDD_IN IOVDD_IN IOVDD_IN IOVDD_IN IOVDD_IN IOVDD_IN IOVDD_OUT IOVDD_OUT
+ IOVDD_OUT IOVDD_OUT IOVDD_OUT IOVDD_OUT IOVDD_OUT IOVDD_OUT IOVDD_OUT IOVDD_OUT
+ IOVDD_IN IOVDD_IN IOVDD_IN IOVDD_IN IOVDD_IN IOVDD_IN IOVDD_IN IOVDD_IN IOVDD_IN
+ IOVDD_IN IOVDD_OUT IOVDD_OUT IOVDD_OUT IOVDD_OUT IOVDD_OUT IOVDD_OUT IOVDD_OUT IOVDD_OUT
+ IOVDD_OUT IOVDD_OUT IOVDD_IN IOVDD_IN IOVDD_IN IOVDD_IN IOVDD_IN IOVDD_IN IOVDD_IN
+ IOVDD_IN IOVDD_IN IOVDD_IN IOVDD_OUT IOVDD_OUT IOVDD_OUT IOVDD_OUT IOVDD_OUT IOVDD_OUT
+ IOVDD_OUT IOVDD_OUT IOVDD_OUT IOVDD_OUT IOVDD_IN IOVDD_IN IOVDD_IN IOVDD_IN IOVDD_IN
+ IOVDD_IN IOVDD_IN IOVDD_IN IOVDD_IN IOVDD_IN IOVDD_OUT IOVDD_OUT IOVDD_OUT IOVDD_OUT
+ IOVDD_OUT IOVDD_OUT IOVDD_OUT IOVDD_OUT IOVDD_OUT IOVDD_OUT IOVDD_IN IOVDD_IN IOVDD_IN
+ IOVDD_IN IOVDD_IN IOVDD_IN IOVDD_IN IOVDD_IN IOVDD_IN IOVDD_IN IOVDD_OUT IOVDD_OUT
+ IOVDD_OUT IOVDD_OUT IOVDD_OUT IOVDD_OUT IOVDD_OUT IOVDD_OUT IOVDD_OUT IOVDD_OUT
+ IOVDD_IN IOVDD_IN IOVDD_IN IOVDD_IN IOVDD_IN IOVDD_IN IOVDD_IN IOVDD_IN IOVDD_IN
+ IOVDD_IN sg13_hv_pmos_ZN7EJW
Xsg13_hv_pmos_ZN7EJW_5 IOVDD_IN IOVDD_IN gate_drive_large_0/out IOVDD_IN IOVDD_IN
+ IOVDD_IN IOVDD_IN IOVDD_IN IOVDD_IN IOVDD_IN IOVDD_IN IOVDD_IN IOVDD_OUT IOVDD_OUT
+ IOVDD_OUT IOVDD_OUT IOVDD_OUT IOVDD_OUT IOVDD_OUT IOVDD_OUT IOVDD_OUT IOVDD_OUT
+ IOVDD_IN IOVDD_IN IOVDD_IN IOVDD_IN IOVDD_IN IOVDD_IN IOVDD_IN IOVDD_IN IOVDD_IN
+ IOVDD_IN IOVDD_OUT IOVDD_OUT IOVDD_OUT IOVDD_OUT IOVDD_OUT IOVDD_OUT IOVDD_OUT IOVDD_OUT
+ IOVDD_OUT IOVDD_OUT IOVDD_IN IOVDD_IN IOVDD_IN IOVDD_IN IOVDD_IN IOVDD_IN IOVDD_IN
+ IOVDD_IN IOVDD_IN IOVDD_IN IOVDD_OUT IOVDD_OUT IOVDD_OUT IOVDD_OUT IOVDD_OUT IOVDD_OUT
+ IOVDD_OUT IOVDD_OUT IOVDD_OUT IOVDD_OUT IOVDD_IN IOVDD_IN IOVDD_IN IOVDD_IN IOVDD_IN
+ IOVDD_IN IOVDD_IN IOVDD_IN IOVDD_IN IOVDD_IN IOVDD_OUT IOVDD_OUT IOVDD_OUT IOVDD_OUT
+ IOVDD_OUT IOVDD_OUT IOVDD_OUT IOVDD_OUT IOVDD_OUT IOVDD_OUT IOVDD_IN IOVDD_IN IOVDD_IN
+ IOVDD_IN IOVDD_IN IOVDD_IN IOVDD_IN IOVDD_IN IOVDD_IN IOVDD_IN IOVDD_OUT IOVDD_OUT
+ IOVDD_OUT IOVDD_OUT IOVDD_OUT IOVDD_OUT IOVDD_OUT IOVDD_OUT IOVDD_OUT IOVDD_OUT
+ IOVDD_IN IOVDD_IN IOVDD_IN IOVDD_IN IOVDD_IN IOVDD_IN IOVDD_IN IOVDD_IN IOVDD_IN
+ IOVDD_IN sg13_hv_pmos_ZN7EJW
Xsg13_hv_pmos_ZN7EJW_6 IOVDD_IN IOVDD_IN gate_drive_large_0/out IOVDD_IN IOVDD_IN
+ IOVDD_IN IOVDD_IN IOVDD_IN IOVDD_IN IOVDD_IN IOVDD_IN IOVDD_IN IOVDD_OUT IOVDD_OUT
+ IOVDD_OUT IOVDD_OUT IOVDD_OUT IOVDD_OUT IOVDD_OUT IOVDD_OUT IOVDD_OUT IOVDD_OUT
+ IOVDD_IN IOVDD_IN IOVDD_IN IOVDD_IN IOVDD_IN IOVDD_IN IOVDD_IN IOVDD_IN IOVDD_IN
+ IOVDD_IN IOVDD_OUT IOVDD_OUT IOVDD_OUT IOVDD_OUT IOVDD_OUT IOVDD_OUT IOVDD_OUT IOVDD_OUT
+ IOVDD_OUT IOVDD_OUT IOVDD_IN IOVDD_IN IOVDD_IN IOVDD_IN IOVDD_IN IOVDD_IN IOVDD_IN
+ IOVDD_IN IOVDD_IN IOVDD_IN IOVDD_OUT IOVDD_OUT IOVDD_OUT IOVDD_OUT IOVDD_OUT IOVDD_OUT
+ IOVDD_OUT IOVDD_OUT IOVDD_OUT IOVDD_OUT IOVDD_IN IOVDD_IN IOVDD_IN IOVDD_IN IOVDD_IN
+ IOVDD_IN IOVDD_IN IOVDD_IN IOVDD_IN IOVDD_IN IOVDD_OUT IOVDD_OUT IOVDD_OUT IOVDD_OUT
+ IOVDD_OUT IOVDD_OUT IOVDD_OUT IOVDD_OUT IOVDD_OUT IOVDD_OUT IOVDD_IN IOVDD_IN IOVDD_IN
+ IOVDD_IN IOVDD_IN IOVDD_IN IOVDD_IN IOVDD_IN IOVDD_IN IOVDD_IN IOVDD_OUT IOVDD_OUT
+ IOVDD_OUT IOVDD_OUT IOVDD_OUT IOVDD_OUT IOVDD_OUT IOVDD_OUT IOVDD_OUT IOVDD_OUT
+ IOVDD_IN IOVDD_IN IOVDD_IN IOVDD_IN IOVDD_IN IOVDD_IN IOVDD_IN IOVDD_IN IOVDD_IN
+ IOVDD_IN sg13_hv_pmos_ZN7EJW
Xsg13cmos5l_antennanp_0 enable DVDD DVSS sg13cmos5l_antennanp
Xsg13cmos5l_decap_4_0 DVDD DVSS sg13cmos5l_decap_4
Xsg13cmos5l_decap_4_1 DVDD DVSS sg13cmos5l_decap_4
Xgate_drive_large_0 sg13cmos5l_inv_4_1/A sg13cmos5l_inv_4_1/Y gate_drive_large_0/out
+ IOVSS IOVDD_IN gate_drive_large
Xsg13cmos5l_inv_4_0 sg13cmos5l_inv_4_1/A enable DVDD DVSS sg13cmos5l_inv_4
Xsg13_hv_pmos_ZN7EJW_0 IOVDD_IN IOVDD_IN gate_drive_large_0/out IOVDD_IN IOVDD_IN
+ IOVDD_IN IOVDD_IN IOVDD_IN IOVDD_IN IOVDD_IN IOVDD_IN IOVDD_IN IOVDD_OUT IOVDD_OUT
+ IOVDD_OUT IOVDD_OUT IOVDD_OUT IOVDD_OUT IOVDD_OUT IOVDD_OUT IOVDD_OUT IOVDD_OUT
+ IOVDD_IN IOVDD_IN IOVDD_IN IOVDD_IN IOVDD_IN IOVDD_IN IOVDD_IN IOVDD_IN IOVDD_IN
+ IOVDD_IN IOVDD_OUT IOVDD_OUT IOVDD_OUT IOVDD_OUT IOVDD_OUT IOVDD_OUT IOVDD_OUT IOVDD_OUT
+ IOVDD_OUT IOVDD_OUT IOVDD_IN IOVDD_IN IOVDD_IN IOVDD_IN IOVDD_IN IOVDD_IN IOVDD_IN
+ IOVDD_IN IOVDD_IN IOVDD_IN IOVDD_OUT IOVDD_OUT IOVDD_OUT IOVDD_OUT IOVDD_OUT IOVDD_OUT
+ IOVDD_OUT IOVDD_OUT IOVDD_OUT IOVDD_OUT IOVDD_IN IOVDD_IN IOVDD_IN IOVDD_IN IOVDD_IN
+ IOVDD_IN IOVDD_IN IOVDD_IN IOVDD_IN IOVDD_IN IOVDD_OUT IOVDD_OUT IOVDD_OUT IOVDD_OUT
+ IOVDD_OUT IOVDD_OUT IOVDD_OUT IOVDD_OUT IOVDD_OUT IOVDD_OUT IOVDD_IN IOVDD_IN IOVDD_IN
+ IOVDD_IN IOVDD_IN IOVDD_IN IOVDD_IN IOVDD_IN IOVDD_IN IOVDD_IN IOVDD_OUT IOVDD_OUT
+ IOVDD_OUT IOVDD_OUT IOVDD_OUT IOVDD_OUT IOVDD_OUT IOVDD_OUT IOVDD_OUT IOVDD_OUT
+ IOVDD_IN IOVDD_IN IOVDD_IN IOVDD_IN IOVDD_IN IOVDD_IN IOVDD_IN IOVDD_IN IOVDD_IN
+ IOVDD_IN sg13_hv_pmos_ZN7EJW
Xsg13cmos5l_inv_4_1 sg13cmos5l_inv_4_1/Y sg13cmos5l_inv_4_1/A DVDD DVSS sg13cmos5l_inv_4
Xsg13_hv_pmos_ZN7EJW_1 IOVDD_IN IOVDD_IN gate_drive_large_0/out IOVDD_IN IOVDD_IN
+ IOVDD_IN IOVDD_IN IOVDD_IN IOVDD_IN IOVDD_IN IOVDD_IN IOVDD_IN IOVDD_OUT IOVDD_OUT
+ IOVDD_OUT IOVDD_OUT IOVDD_OUT IOVDD_OUT IOVDD_OUT IOVDD_OUT IOVDD_OUT IOVDD_OUT
+ IOVDD_IN IOVDD_IN IOVDD_IN IOVDD_IN IOVDD_IN IOVDD_IN IOVDD_IN IOVDD_IN IOVDD_IN
+ IOVDD_IN IOVDD_OUT IOVDD_OUT IOVDD_OUT IOVDD_OUT IOVDD_OUT IOVDD_OUT IOVDD_OUT IOVDD_OUT
+ IOVDD_OUT IOVDD_OUT IOVDD_IN IOVDD_IN IOVDD_IN IOVDD_IN IOVDD_IN IOVDD_IN IOVDD_IN
+ IOVDD_IN IOVDD_IN IOVDD_IN IOVDD_OUT IOVDD_OUT IOVDD_OUT IOVDD_OUT IOVDD_OUT IOVDD_OUT
+ IOVDD_OUT IOVDD_OUT IOVDD_OUT IOVDD_OUT IOVDD_IN IOVDD_IN IOVDD_IN IOVDD_IN IOVDD_IN
+ IOVDD_IN IOVDD_IN IOVDD_IN IOVDD_IN IOVDD_IN IOVDD_OUT IOVDD_OUT IOVDD_OUT IOVDD_OUT
+ IOVDD_OUT IOVDD_OUT IOVDD_OUT IOVDD_OUT IOVDD_OUT IOVDD_OUT IOVDD_IN IOVDD_IN IOVDD_IN
+ IOVDD_IN IOVDD_IN IOVDD_IN IOVDD_IN IOVDD_IN IOVDD_IN IOVDD_IN IOVDD_OUT IOVDD_OUT
+ IOVDD_OUT IOVDD_OUT IOVDD_OUT IOVDD_OUT IOVDD_OUT IOVDD_OUT IOVDD_OUT IOVDD_OUT
+ IOVDD_IN IOVDD_IN IOVDD_IN IOVDD_IN IOVDD_IN IOVDD_IN IOVDD_IN IOVDD_IN IOVDD_IN
+ IOVDD_IN sg13_hv_pmos_ZN7EJW
.ends

.subckt sg13_lv_pmos_5MXUJM B D0_0 G D0_1 D0_2 D0_3 D0_4 D0_5 D0_6 D0_7 D0_8 D0_9
+ S1_0 S1_1 S1_2 S1_3 S1_4 S1_5 S1_6 S1_7 S1_8 S1_9 D2_0 D2_1 D2_2 D2_3 D2_4 D2_5
+ D2_6 D2_7 D2_8 D2_9 S3_0 S3_1 S3_2 S3_3 S3_4 S3_5 S3_6 S3_7 S3_8 S3_9 D4_0 D4_1
+ D4_2 D4_3 D4_4 D4_5 D4_6 D4_7 D4_8 D4_9 S5_0 S5_1 S5_2 S5_3 S5_4 S5_5 S5_6 S5_7
+ S5_8 S5_9 D6_0 D6_1 D6_2 D6_3 D6_4 D6_5 D6_6 D6_7 D6_8 D6_9 S7_0 S7_1 S7_2 S7_3
+ S7_4 S7_5 S7_6 S7_7 S7_8 S7_9 D8_0 D8_1 D8_2 D8_3 D8_4 D8_5 D8_6 D8_7 D8_8 D8_9
+ S9_0 S9_1 S9_2 S9_3 S9_4 S9_5 S9_6 S9_7 S9_8 S9_9 a_778_n3220# a_778_n4308# a_778_1132#
+ a_778_n5396# a_778_n1044# a_778_44# a_778_2220# a_778_3308# a_778_n2132# a_778_4396#
X0 D8_4 G S7_4 B sg13_lv_pmos ad=1.8p pd=5.72u as=1.8p ps=5.72u w=5u l=0.13u
X1 S7_1 G D6_1 B sg13_lv_pmos ad=1.8p pd=5.72u as=1.8p ps=5.72u w=5u l=0.13u
X2 S3_4 G D2_4 B sg13_lv_pmos ad=1.8p pd=5.72u as=1.8p ps=5.72u w=5u l=0.13u
X3 D4_1 G S3_1 B sg13_lv_pmos ad=1.8p pd=5.72u as=1.8p ps=5.72u w=5u l=0.13u
X4 a_778_n3220# G S9_2 B sg13_lv_pmos ad=3.4p pd=11.36u as=1.8p ps=5.72u w=5u l=0.13u
X5 S1_2 G D0_2 B sg13_lv_pmos ad=1.8p pd=5.72u as=3.4p ps=11.36u w=5u l=0.13u
X6 a_778_n2132# G S9_3 B sg13_lv_pmos ad=3.4p pd=11.36u as=1.8p ps=5.72u w=5u l=0.13u
X7 S1_3 G D0_3 B sg13_lv_pmos ad=1.8p pd=5.72u as=3.4p ps=11.36u w=5u l=0.13u
X8 D8_9 G S7_9 B sg13_lv_pmos ad=1.8p pd=5.72u as=1.8p ps=5.72u w=5u l=0.13u
X9 S3_9 G D2_9 B sg13_lv_pmos ad=1.8p pd=5.72u as=1.8p ps=5.72u w=5u l=0.13u
X10 S5_9 G D4_9 B sg13_lv_pmos ad=1.8p pd=5.72u as=1.8p ps=5.72u w=5u l=0.13u
X11 D8_0 G S7_0 B sg13_lv_pmos ad=1.8p pd=5.72u as=1.8p ps=5.72u w=5u l=0.13u
X12 S3_0 G D2_0 B sg13_lv_pmos ad=1.8p pd=5.72u as=1.8p ps=5.72u w=5u l=0.13u
X13 D6_6 G S5_6 B sg13_lv_pmos ad=1.8p pd=5.72u as=1.8p ps=5.72u w=5u l=0.13u
X14 D2_1 G S1_1 B sg13_lv_pmos ad=1.8p pd=5.72u as=1.8p ps=5.72u w=5u l=0.13u
X15 S7_8 G D6_8 B sg13_lv_pmos ad=1.8p pd=5.72u as=1.8p ps=5.72u w=5u l=0.13u
X16 a_778_4396# G S9_9 B sg13_lv_pmos ad=3.4p pd=11.36u as=1.8p ps=5.72u w=5u l=0.13u
X17 S7_7 G D6_7 B sg13_lv_pmos ad=1.8p pd=5.72u as=1.8p ps=5.72u w=5u l=0.13u
X18 D4_8 G S3_8 B sg13_lv_pmos ad=1.8p pd=5.72u as=1.8p ps=5.72u w=5u l=0.13u
X19 S1_9 G D0_9 B sg13_lv_pmos ad=1.8p pd=5.72u as=3.4p ps=11.36u w=5u l=0.13u
X20 D4_7 G S3_7 B sg13_lv_pmos ad=1.8p pd=5.72u as=1.8p ps=5.72u w=5u l=0.13u
X21 D6_5 G S5_5 B sg13_lv_pmos ad=1.8p pd=5.72u as=1.8p ps=5.72u w=5u l=0.13u
X22 S9_8 G D8_8 B sg13_lv_pmos ad=1.8p pd=5.72u as=1.8p ps=5.72u w=5u l=0.13u
X23 S5_4 G D4_4 B sg13_lv_pmos ad=1.8p pd=5.72u as=1.8p ps=5.72u w=5u l=0.13u
X24 S9_7 G D8_7 B sg13_lv_pmos ad=1.8p pd=5.72u as=1.8p ps=5.72u w=5u l=0.13u
X25 S9_4 G D8_4 B sg13_lv_pmos ad=1.8p pd=5.72u as=1.8p ps=5.72u w=5u l=0.13u
X26 D8_6 G S7_6 B sg13_lv_pmos ad=1.8p pd=5.72u as=1.8p ps=5.72u w=5u l=0.13u
X27 S5_0 G D4_0 B sg13_lv_pmos ad=1.8p pd=5.72u as=1.8p ps=5.72u w=5u l=0.13u
X28 D8_2 G S7_2 B sg13_lv_pmos ad=1.8p pd=5.72u as=1.8p ps=5.72u w=5u l=0.13u
X29 D6_4 G S5_4 B sg13_lv_pmos ad=1.8p pd=5.72u as=1.8p ps=5.72u w=5u l=0.13u
X30 S3_2 G D2_2 B sg13_lv_pmos ad=1.8p pd=5.72u as=1.8p ps=5.72u w=5u l=0.13u
X31 S5_6 G D4_6 B sg13_lv_pmos ad=1.8p pd=5.72u as=1.8p ps=5.72u w=5u l=0.13u
X32 S3_6 G D2_6 B sg13_lv_pmos ad=1.8p pd=5.72u as=1.8p ps=5.72u w=5u l=0.13u
X33 S9_0 G D8_0 B sg13_lv_pmos ad=1.8p pd=5.72u as=1.8p ps=5.72u w=5u l=0.13u
X34 D8_3 G S7_3 B sg13_lv_pmos ad=1.8p pd=5.72u as=1.8p ps=5.72u w=5u l=0.13u
X35 S3_3 G D2_3 B sg13_lv_pmos ad=1.8p pd=5.72u as=1.8p ps=5.72u w=5u l=0.13u
X36 a_778_n4308# G S9_1 B sg13_lv_pmos ad=3.4p pd=11.36u as=1.8p ps=5.72u w=5u l=0.13u
X37 S1_1 G D0_1 B sg13_lv_pmos ad=1.8p pd=5.72u as=3.4p ps=11.36u w=5u l=0.13u
X38 a_778_1132# G S9_6 B sg13_lv_pmos ad=3.4p pd=11.36u as=1.8p ps=5.72u w=5u l=0.13u
X39 D6_0 G S5_0 B sg13_lv_pmos ad=1.8p pd=5.72u as=1.8p ps=5.72u w=5u l=0.13u
X40 S1_6 G D0_6 B sg13_lv_pmos ad=1.8p pd=5.72u as=3.4p ps=11.36u w=5u l=0.13u
X41 D6_8 G S5_8 B sg13_lv_pmos ad=1.8p pd=5.72u as=1.8p ps=5.72u w=5u l=0.13u
X42 D6_7 G S5_7 B sg13_lv_pmos ad=1.8p pd=5.72u as=1.8p ps=5.72u w=5u l=0.13u
X43 S7_4 G D6_4 B sg13_lv_pmos ad=1.8p pd=5.72u as=1.8p ps=5.72u w=5u l=0.13u
X44 D4_4 G S3_4 B sg13_lv_pmos ad=1.8p pd=5.72u as=1.8p ps=5.72u w=5u l=0.13u
X45 S1_5 G D0_5 B sg13_lv_pmos ad=1.8p pd=5.72u as=3.4p ps=11.36u w=5u l=0.13u
X46 S5_2 G D4_2 B sg13_lv_pmos ad=1.8p pd=5.72u as=1.8p ps=5.72u w=5u l=0.13u
X47 D2_5 G S1_5 B sg13_lv_pmos ad=1.8p pd=5.72u as=1.8p ps=5.72u w=5u l=0.13u
X48 S9_2 G D8_2 B sg13_lv_pmos ad=1.8p pd=5.72u as=1.8p ps=5.72u w=5u l=0.13u
X49 D2_9 G S1_9 B sg13_lv_pmos ad=1.8p pd=5.72u as=1.8p ps=5.72u w=5u l=0.13u
X50 S5_3 G D4_3 B sg13_lv_pmos ad=1.8p pd=5.72u as=1.8p ps=5.72u w=5u l=0.13u
X51 S9_3 G D8_3 B sg13_lv_pmos ad=1.8p pd=5.72u as=1.8p ps=5.72u w=5u l=0.13u
X52 S3_5 G D2_5 B sg13_lv_pmos ad=1.8p pd=5.72u as=1.8p ps=5.72u w=5u l=0.13u
X53 D8_8 G S7_8 B sg13_lv_pmos ad=1.8p pd=5.72u as=1.8p ps=5.72u w=5u l=0.13u
X54 S7_0 G D6_0 B sg13_lv_pmos ad=1.8p pd=5.72u as=1.8p ps=5.72u w=5u l=0.13u
X55 D8_7 G S7_7 B sg13_lv_pmos ad=1.8p pd=5.72u as=1.8p ps=5.72u w=5u l=0.13u
X56 D4_0 G S3_0 B sg13_lv_pmos ad=1.8p pd=5.72u as=1.8p ps=5.72u w=5u l=0.13u
X57 D6_2 G S5_2 B sg13_lv_pmos ad=1.8p pd=5.72u as=1.8p ps=5.72u w=5u l=0.13u
X58 S5_8 G D4_8 B sg13_lv_pmos ad=1.8p pd=5.72u as=1.8p ps=5.72u w=5u l=0.13u
X59 S3_8 G D2_8 B sg13_lv_pmos ad=1.8p pd=5.72u as=1.8p ps=5.72u w=5u l=0.13u
X60 D8_1 G S7_1 B sg13_lv_pmos ad=1.8p pd=5.72u as=1.8p ps=5.72u w=5u l=0.13u
X61 D6_3 G S5_3 B sg13_lv_pmos ad=1.8p pd=5.72u as=1.8p ps=5.72u w=5u l=0.13u
X62 D2_4 G S1_4 B sg13_lv_pmos ad=1.8p pd=5.72u as=1.8p ps=5.72u w=5u l=0.13u
X63 S3_1 G D2_1 B sg13_lv_pmos ad=1.8p pd=5.72u as=1.8p ps=5.72u w=5u l=0.13u
X64 D4_5 G S3_5 B sg13_lv_pmos ad=1.8p pd=5.72u as=1.8p ps=5.72u w=5u l=0.13u
X65 S5_7 G D4_7 B sg13_lv_pmos ad=1.8p pd=5.72u as=1.8p ps=5.72u w=5u l=0.13u
X66 S3_7 G D2_7 B sg13_lv_pmos ad=1.8p pd=5.72u as=1.8p ps=5.72u w=5u l=0.13u
X67 a_778_3308# G S9_8 B sg13_lv_pmos ad=3.4p pd=11.36u as=1.8p ps=5.72u w=5u l=0.13u
X68 a_778_2220# G S9_7 B sg13_lv_pmos ad=3.4p pd=11.36u as=1.8p ps=5.72u w=5u l=0.13u
X69 S1_8 G D0_8 B sg13_lv_pmos ad=1.8p pd=5.72u as=3.4p ps=11.36u w=5u l=0.13u
X70 D2_0 G S1_0 B sg13_lv_pmos ad=1.8p pd=5.72u as=1.8p ps=5.72u w=5u l=0.13u
X71 S1_7 G D0_7 B sg13_lv_pmos ad=1.8p pd=5.72u as=3.4p ps=11.36u w=5u l=0.13u
X72 S7_9 G D6_9 B sg13_lv_pmos ad=1.8p pd=5.72u as=1.8p ps=5.72u w=5u l=0.13u
X73 D4_9 G S3_9 B sg13_lv_pmos ad=1.8p pd=5.72u as=1.8p ps=5.72u w=5u l=0.13u
X74 D2_6 G S1_6 B sg13_lv_pmos ad=1.8p pd=5.72u as=1.8p ps=5.72u w=5u l=0.13u
X75 S9_9 G D8_9 B sg13_lv_pmos ad=1.8p pd=5.72u as=1.8p ps=5.72u w=5u l=0.13u
X76 S7_2 G D6_2 B sg13_lv_pmos ad=1.8p pd=5.72u as=1.8p ps=5.72u w=5u l=0.13u
X77 D4_2 G S3_2 B sg13_lv_pmos ad=1.8p pd=5.72u as=1.8p ps=5.72u w=5u l=0.13u
X78 S7_3 G D6_3 B sg13_lv_pmos ad=1.8p pd=5.72u as=1.8p ps=5.72u w=5u l=0.13u
X79 a_778_44# G S9_5 B sg13_lv_pmos ad=3.4p pd=11.36u as=1.8p ps=5.72u w=5u l=0.13u
X80 S5_1 G D4_1 B sg13_lv_pmos ad=1.8p pd=5.72u as=1.8p ps=5.72u w=5u l=0.13u
X81 D4_3 G S3_3 B sg13_lv_pmos ad=1.8p pd=5.72u as=1.8p ps=5.72u w=5u l=0.13u
X82 a_778_n1044# G S9_4 B sg13_lv_pmos ad=3.4p pd=11.36u as=1.8p ps=5.72u w=5u l=0.13u
X83 S9_1 G D8_1 B sg13_lv_pmos ad=1.8p pd=5.72u as=1.8p ps=5.72u w=5u l=0.13u
X84 S1_4 G D0_4 B sg13_lv_pmos ad=1.8p pd=5.72u as=3.4p ps=11.36u w=5u l=0.13u
X85 S9_5 G D8_5 B sg13_lv_pmos ad=1.8p pd=5.72u as=1.8p ps=5.72u w=5u l=0.13u
X86 D8_5 G S7_5 B sg13_lv_pmos ad=1.8p pd=5.72u as=1.8p ps=5.72u w=5u l=0.13u
X87 D6_1 G S5_1 B sg13_lv_pmos ad=1.8p pd=5.72u as=1.8p ps=5.72u w=5u l=0.13u
X88 D2_2 G S1_2 B sg13_lv_pmos ad=1.8p pd=5.72u as=1.8p ps=5.72u w=5u l=0.13u
X89 a_778_n5396# G S9_0 B sg13_lv_pmos ad=3.4p pd=11.36u as=1.8p ps=5.72u w=5u l=0.13u
X90 S5_5 G D4_5 B sg13_lv_pmos ad=1.8p pd=5.72u as=1.8p ps=5.72u w=5u l=0.13u
X91 S7_6 G D6_6 B sg13_lv_pmos ad=1.8p pd=5.72u as=1.8p ps=5.72u w=5u l=0.13u
X92 S1_0 G D0_0 B sg13_lv_pmos ad=1.8p pd=5.72u as=3.4p ps=11.36u w=5u l=0.13u
X93 D2_3 G S1_3 B sg13_lv_pmos ad=1.8p pd=5.72u as=1.8p ps=5.72u w=5u l=0.13u
X94 S7_5 G D6_5 B sg13_lv_pmos ad=1.8p pd=5.72u as=1.8p ps=5.72u w=5u l=0.13u
X95 D4_6 G S3_6 B sg13_lv_pmos ad=1.8p pd=5.72u as=1.8p ps=5.72u w=5u l=0.13u
X96 D6_9 G S5_9 B sg13_lv_pmos ad=1.8p pd=5.72u as=1.8p ps=5.72u w=5u l=0.13u
X97 S9_6 G D8_6 B sg13_lv_pmos ad=1.8p pd=5.72u as=1.8p ps=5.72u w=5u l=0.13u
X98 D2_8 G S1_8 B sg13_lv_pmos ad=1.8p pd=5.72u as=1.8p ps=5.72u w=5u l=0.13u
X99 D2_7 G S1_7 B sg13_lv_pmos ad=1.8p pd=5.72u as=1.8p ps=5.72u w=5u l=0.13u
.ends

.subckt sg13cmos5l_inv_2 Y A VDD VSS
X0 Y A VSS VSS sg13_lv_nmos ad=0.1406p pd=1.12u as=0.2516p ps=2.16u w=0.74u l=0.13u
X1 Y A VDD VDD sg13_lv_pmos ad=0.2128p pd=1.5u as=0.3808p ps=2.92u w=1.12u l=0.13u
X2 VSS A Y VSS sg13_lv_nmos ad=0.2516p pd=2.16u as=0.1406p ps=1.12u w=0.74u l=0.13u
X3 VDD A Y VDD sg13_lv_pmos ad=0.3864p pd=2.93u as=0.2128p ps=1.5u w=1.12u l=0.13u
.ends

.subckt sg13cmos5l_inv_16 Y A VDD VSS
X0 Y A VDD VDD sg13_lv_pmos ad=0.2128p pd=1.5u as=0.2128p ps=1.5u w=1.12u l=0.13u
X1 Y A VSS VSS sg13_lv_nmos ad=0.1406p pd=1.12u as=0.1406p ps=1.12u w=0.74u l=0.13u
X2 VDD A Y VDD sg13_lv_pmos ad=0.2128p pd=1.5u as=0.2128p ps=1.5u w=1.12u l=0.13u
X3 Y A VDD VDD sg13_lv_pmos ad=0.2128p pd=1.5u as=0.2128p ps=1.5u w=1.12u l=0.13u
X4 VSS A Y VSS sg13_lv_nmos ad=0.1406p pd=1.12u as=0.1406p ps=1.12u w=0.74u l=0.13u
X5 VDD A Y VDD sg13_lv_pmos ad=0.2128p pd=1.5u as=0.2128p ps=1.5u w=1.12u l=0.13u
X6 Y A VSS VSS sg13_lv_nmos ad=0.1406p pd=1.12u as=0.1406p ps=1.12u w=0.74u l=0.13u
X7 Y A VDD VDD sg13_lv_pmos ad=0.2128p pd=1.5u as=0.2128p ps=1.5u w=1.12u l=0.13u
X8 VSS A Y VSS sg13_lv_nmos ad=0.1406p pd=1.12u as=0.1406p ps=1.12u w=0.74u l=0.13u
X9 VDD A Y VDD sg13_lv_pmos ad=0.2128p pd=1.5u as=0.2128p ps=1.5u w=1.12u l=0.13u
X10 Y A VSS VSS sg13_lv_nmos ad=0.1406p pd=1.12u as=0.1406p ps=1.12u w=0.74u l=0.13u
X11 VSS A Y VSS sg13_lv_nmos ad=0.1406p pd=1.12u as=0.1406p ps=1.12u w=0.74u l=0.13u
X12 Y A VDD VDD sg13_lv_pmos ad=0.2128p pd=1.5u as=0.2128p ps=1.5u w=1.12u l=0.13u
X13 Y A VSS VSS sg13_lv_nmos ad=0.1406p pd=1.12u as=0.1406p ps=1.12u w=0.74u l=0.13u
X14 VDD A Y VDD sg13_lv_pmos ad=0.2128p pd=1.5u as=0.2128p ps=1.5u w=1.12u l=0.13u
X15 Y A VDD VDD sg13_lv_pmos ad=0.2128p pd=1.5u as=0.2128p ps=1.5u w=1.12u l=0.13u
X16 VSS A Y VSS sg13_lv_nmos ad=0.1406p pd=1.12u as=0.1406p ps=1.12u w=0.74u l=0.13u
X17 VDD A Y VDD sg13_lv_pmos ad=0.2128p pd=1.5u as=0.2128p ps=1.5u w=1.12u l=0.13u
X18 Y A VSS VSS sg13_lv_nmos ad=0.1406p pd=1.12u as=0.1406p ps=1.12u w=0.74u l=0.13u
X19 Y A VDD VDD sg13_lv_pmos ad=0.2128p pd=1.5u as=0.2128p ps=1.5u w=1.12u l=0.13u
X20 VSS A Y VSS sg13_lv_nmos ad=0.2516p pd=2.16u as=0.1406p ps=1.12u w=0.74u l=0.13u
X21 VDD A Y VDD sg13_lv_pmos ad=0.4368p pd=3.02u as=0.2128p ps=1.5u w=1.12u l=0.13u
X22 Y A VSS VSS sg13_lv_nmos ad=0.1406p pd=1.12u as=0.2516p ps=2.16u w=0.74u l=0.13u
X23 VSS A Y VSS sg13_lv_nmos ad=0.1406p pd=1.12u as=0.1406p ps=1.12u w=0.74u l=0.13u
X24 Y A VDD VDD sg13_lv_pmos ad=0.2128p pd=1.5u as=0.3808p ps=2.92u w=1.12u l=0.13u
X25 VDD A Y VDD sg13_lv_pmos ad=0.2128p pd=1.5u as=0.2128p ps=1.5u w=1.12u l=0.13u
X26 Y A VSS VSS sg13_lv_nmos ad=0.1406p pd=1.12u as=0.1406p ps=1.12u w=0.74u l=0.13u
X27 Y A VDD VDD sg13_lv_pmos ad=0.2128p pd=1.5u as=0.2128p ps=1.5u w=1.12u l=0.13u
X28 VSS A Y VSS sg13_lv_nmos ad=0.1406p pd=1.12u as=0.1406p ps=1.12u w=0.74u l=0.13u
X29 Y A VSS VSS sg13_lv_nmos ad=0.1406p pd=1.12u as=0.1406p ps=1.12u w=0.74u l=0.13u
X30 VDD A Y VDD sg13_lv_pmos ad=0.2128p pd=1.5u as=0.2128p ps=1.5u w=1.12u l=0.13u
X31 VSS A Y VSS sg13_lv_nmos ad=0.1406p pd=1.12u as=0.1406p ps=1.12u w=0.74u l=0.13u
.ends

.subckt sg13cmos5l_inv_1 Y A VDD VSS
X0 Y A VSS VSS sg13_lv_nmos ad=0.2516p pd=2.16u as=0.2516p ps=2.16u w=0.74u l=0.13u
X1 Y A VDD VDD sg13_lv_pmos ad=0.3808p pd=2.92u as=0.3808p ps=2.92u w=1.12u l=0.13u
.ends

.subckt sg13cmos5l_inv_8 Y A VDD VSS
X0 VSS A Y VSS sg13_lv_nmos ad=0.2516p pd=2.16u as=0.1443p ps=1.13u w=0.74u l=0.13u
X1 VDD A Y VDD sg13_lv_pmos ad=0.3808p pd=2.92u as=0.2184p ps=1.51u w=1.12u l=0.13u
X2 Y A VSS VSS sg13_lv_nmos ad=0.1406p pd=1.12u as=0.2516p ps=2.16u w=0.74u l=0.13u
X3 Y A VDD VDD sg13_lv_pmos ad=0.2128p pd=1.5u as=0.3808p ps=2.92u w=1.12u l=0.13u
X4 VSS A Y VSS sg13_lv_nmos ad=0.1406p pd=1.12u as=0.1406p ps=1.12u w=0.74u l=0.13u
X5 VDD A Y VDD sg13_lv_pmos ad=0.2128p pd=1.5u as=0.2128p ps=1.5u w=1.12u l=0.13u
X6 Y A VSS VSS sg13_lv_nmos ad=0.1406p pd=1.12u as=0.1406p ps=1.12u w=0.74u l=0.13u
X7 VSS A Y VSS sg13_lv_nmos ad=0.1406p pd=1.12u as=0.1406p ps=1.12u w=0.74u l=0.13u
X8 Y A VDD VDD sg13_lv_pmos ad=0.2128p pd=1.5u as=0.2128p ps=1.5u w=1.12u l=0.13u
X9 VDD A Y VDD sg13_lv_pmos ad=0.2128p pd=1.5u as=0.2128p ps=1.5u w=1.12u l=0.13u
X10 Y A VSS VSS sg13_lv_nmos ad=0.1406p pd=1.12u as=0.1406p ps=1.12u w=0.74u l=0.13u
X11 Y A VDD VDD sg13_lv_pmos ad=0.2128p pd=1.5u as=0.2128p ps=1.5u w=1.12u l=0.13u
X12 VSS A Y VSS sg13_lv_nmos ad=0.1406p pd=1.12u as=0.1406p ps=1.12u w=0.74u l=0.13u
X13 VDD A Y VDD sg13_lv_pmos ad=0.2128p pd=1.5u as=0.2128p ps=1.5u w=1.12u l=0.13u
X14 Y A VSS VSS sg13_lv_nmos ad=0.1443p pd=1.13u as=0.1406p ps=1.12u w=0.74u l=0.13u
X15 Y A VDD VDD sg13_lv_pmos ad=0.2184p pd=1.51u as=0.2128p ps=1.5u w=1.12u l=0.13u
.ends

.subckt gate_drive_1v2 in out dvss dvdd
Xsg13cmos5l_inv_2_0 sg13cmos5l_inv_8_0/A sg13cmos5l_inv_2_0/A dvdd dvss sg13cmos5l_inv_2
Xsg13cmos5l_antennanp_0 in dvdd dvss sg13cmos5l_antennanp
Xsg13cmos5l_inv_16_0 sg13cmos5l_inv_16_0/Y sg13cmos5l_inv_8_0/Y dvdd dvss sg13cmos5l_inv_16
Xsg13cmos5l_inv_1_0 sg13cmos5l_inv_2_0/A in dvdd dvss sg13cmos5l_inv_1
Xsg13cmos5l_decap_4_0 dvdd dvss sg13cmos5l_decap_4
Xsg13cmos5l_decap_4_1 dvdd dvss sg13cmos5l_decap_4
Xsg13cmos5l_inv_8_0 sg13cmos5l_inv_8_0/Y sg13cmos5l_inv_8_0/A dvdd dvss sg13cmos5l_inv_8
X0 dvdd sg13cmos5l_inv_16_0/Y out dvdd sg13_lv_pmos ad=0.2128p pd=1.5u as=0.2128p ps=1.5u w=1.12u l=0.13u
X1 out sg13cmos5l_inv_16_0/Y dvss dvss sg13_lv_nmos ad=0.1406p pd=1.12u as=0.1406p ps=1.12u w=0.74u l=0.13u
X2 out sg13cmos5l_inv_16_0/Y dvdd dvdd sg13_lv_pmos ad=0.2128p pd=1.5u as=0.2128p ps=1.5u w=1.12u l=0.13u
X3 dvss sg13cmos5l_inv_16_0/Y out dvss sg13_lv_nmos ad=0.1406p pd=1.12u as=0.1406p ps=1.12u w=0.74u l=0.13u
X4 out sg13cmos5l_inv_16_0/Y dvdd dvdd sg13_lv_pmos ad=0.2128p pd=1.5u as=0.2128p ps=1.5u w=1.12u l=0.13u
X5 out sg13cmos5l_inv_16_0/Y dvss dvss sg13_lv_nmos ad=0.1406p pd=1.12u as=0.2516p ps=2.16u w=0.74u l=0.13u
X6 out sg13cmos5l_inv_16_0/Y dvss dvss sg13_lv_nmos ad=0.1406p pd=1.12u as=0.1406p ps=1.12u w=0.74u l=0.13u
X7 out sg13cmos5l_inv_16_0/Y dvdd dvdd sg13_lv_pmos ad=0.2128p pd=1.5u as=0.4368p ps=3.02u w=1.12u l=0.13u
X8 out sg13cmos5l_inv_16_0/Y dvdd dvdd sg13_lv_pmos ad=0.2128p pd=1.5u as=0.2128p ps=1.5u w=1.12u l=0.13u
X9 dvdd sg13cmos5l_inv_16_0/Y out dvdd sg13_lv_pmos ad=0.2128p pd=1.5u as=0.2128p ps=1.5u w=1.12u l=0.13u
X10 dvss sg13cmos5l_inv_16_0/Y out dvss sg13_lv_nmos ad=0.1406p pd=1.12u as=0.1406p ps=1.12u w=0.74u l=0.13u
X11 out sg13cmos5l_inv_16_0/Y dvss dvss sg13_lv_nmos ad=0.1406p pd=1.12u as=0.1406p ps=1.12u w=0.74u l=0.13u
X12 dvss sg13cmos5l_inv_16_0/Y out dvss sg13_lv_nmos ad=0.1406p pd=1.12u as=0.1406p ps=1.12u w=0.74u l=0.13u
X13 dvdd sg13cmos5l_inv_16_0/Y out dvdd sg13_lv_pmos ad=0.2128p pd=1.5u as=0.2128p ps=1.5u w=1.12u l=0.13u
X14 out sg13cmos5l_inv_16_0/Y dvdd dvdd sg13_lv_pmos ad=0.2128p pd=1.5u as=0.2128p ps=1.5u w=1.12u l=0.13u
X15 out sg13cmos5l_inv_16_0/Y dvss dvss sg13_lv_nmos ad=0.1406p pd=1.12u as=0.1406p ps=1.12u w=0.74u l=0.13u
X16 dvss sg13cmos5l_inv_16_0/Y out dvss sg13_lv_nmos ad=0.1406p pd=1.12u as=0.1406p ps=1.12u w=0.74u l=0.13u
X17 dvdd sg13cmos5l_inv_16_0/Y out dvdd sg13_lv_pmos ad=0.2128p pd=1.5u as=0.2128p ps=1.5u w=1.12u l=0.13u
X18 out sg13cmos5l_inv_16_0/Y dvdd dvdd sg13_lv_pmos ad=0.2128p pd=1.5u as=0.2128p ps=1.5u w=1.12u l=0.13u
X19 dvdd sg13cmos5l_inv_16_0/Y out dvdd sg13_lv_pmos ad=0.2128p pd=1.5u as=0.2128p ps=1.5u w=1.12u l=0.13u
X20 dvss sg13cmos5l_inv_16_0/Y out dvss sg13_lv_nmos ad=0.1406p pd=1.12u as=0.1406p ps=1.12u w=0.74u l=0.13u
X21 dvss sg13cmos5l_inv_16_0/Y out dvss sg13_lv_nmos ad=0.2516p pd=2.16u as=0.1406p ps=1.12u w=0.74u l=0.13u
X22 out sg13cmos5l_inv_16_0/Y dvss dvss sg13_lv_nmos ad=0.1406p pd=1.12u as=0.1406p ps=1.12u w=0.74u l=0.13u
X23 dvdd sg13cmos5l_inv_16_0/Y out dvdd sg13_lv_pmos ad=0.2128p pd=1.5u as=0.2128p ps=1.5u w=1.12u l=0.13u
X24 dvdd sg13cmos5l_inv_16_0/Y out dvdd sg13_lv_pmos ad=0.3808p pd=2.92u as=0.2128p ps=1.5u w=1.12u l=0.13u
X25 dvss sg13cmos5l_inv_16_0/Y out dvss sg13_lv_nmos ad=0.1406p pd=1.12u as=0.1406p ps=1.12u w=0.74u l=0.13u
X26 out sg13cmos5l_inv_16_0/Y dvdd dvdd sg13_lv_pmos ad=0.2128p pd=1.5u as=0.2128p ps=1.5u w=1.12u l=0.13u
X27 dvss sg13cmos5l_inv_16_0/Y out dvss sg13_lv_nmos ad=0.1406p pd=1.12u as=0.1406p ps=1.12u w=0.74u l=0.13u
X28 dvdd sg13cmos5l_inv_16_0/Y out dvdd sg13_lv_pmos ad=0.2128p pd=1.5u as=0.2128p ps=1.5u w=1.12u l=0.13u
X29 out sg13cmos5l_inv_16_0/Y dvss dvss sg13_lv_nmos ad=0.1406p pd=1.12u as=0.1406p ps=1.12u w=0.74u l=0.13u
X30 out sg13cmos5l_inv_16_0/Y dvss dvss sg13_lv_nmos ad=0.1406p pd=1.12u as=0.1406p ps=1.12u w=0.74u l=0.13u
X31 dvdd sg13cmos5l_inv_16_0/Y out dvdd sg13_lv_pmos ad=0.2128p pd=1.5u as=0.2128p ps=1.5u w=1.12u l=0.13u
X32 out sg13cmos5l_inv_16_0/Y dvss dvss sg13_lv_nmos ad=0.1406p pd=1.12u as=0.1406p ps=1.12u w=0.74u l=0.13u
X33 out sg13cmos5l_inv_16_0/Y dvdd dvdd sg13_lv_pmos ad=0.2128p pd=1.5u as=0.2128p ps=1.5u w=1.12u l=0.13u
X34 out sg13cmos5l_inv_16_0/Y dvdd dvdd sg13_lv_pmos ad=0.2128p pd=1.5u as=0.2128p ps=1.5u w=1.12u l=0.13u
X35 dvss sg13cmos5l_inv_16_0/Y out dvss sg13_lv_nmos ad=0.1406p pd=1.12u as=0.1406p ps=1.12u w=0.74u l=0.13u
X36 dvdd sg13cmos5l_inv_16_0/Y out dvdd sg13_lv_pmos ad=0.2128p pd=1.5u as=0.2128p ps=1.5u w=1.12u l=0.13u
X37 out sg13cmos5l_inv_16_0/Y dvdd dvdd sg13_lv_pmos ad=0.2128p pd=1.5u as=0.2128p ps=1.5u w=1.12u l=0.13u
X38 out sg13cmos5l_inv_16_0/Y dvss dvss sg13_lv_nmos ad=0.1406p pd=1.12u as=0.1406p ps=1.12u w=0.74u l=0.13u
X39 dvss sg13cmos5l_inv_16_0/Y out dvss sg13_lv_nmos ad=0.1406p pd=1.12u as=0.1406p ps=1.12u w=0.74u l=0.13u
X40 out sg13cmos5l_inv_16_0/Y dvdd dvdd sg13_lv_pmos ad=0.2128p pd=1.5u as=0.2128p ps=1.5u w=1.12u l=0.13u
X41 out sg13cmos5l_inv_16_0/Y dvss dvss sg13_lv_nmos ad=0.1406p pd=1.12u as=0.1406p ps=1.12u w=0.74u l=0.13u
X42 dvss sg13cmos5l_inv_16_0/Y out dvss sg13_lv_nmos ad=0.1406p pd=1.12u as=0.1406p ps=1.12u w=0.74u l=0.13u
X43 dvdd sg13cmos5l_inv_16_0/Y out dvdd sg13_lv_pmos ad=0.2128p pd=1.5u as=0.2128p ps=1.5u w=1.12u l=0.13u
X44 out sg13cmos5l_inv_16_0/Y dvss dvss sg13_lv_nmos ad=0.1406p pd=1.12u as=0.1406p ps=1.12u w=0.74u l=0.13u
X45 out sg13cmos5l_inv_16_0/Y dvdd dvdd sg13_lv_pmos ad=0.2128p pd=1.5u as=0.2128p ps=1.5u w=1.12u l=0.13u
X46 dvdd sg13cmos5l_inv_16_0/Y out dvdd sg13_lv_pmos ad=0.2128p pd=1.5u as=0.2128p ps=1.5u w=1.12u l=0.13u
X47 dvss sg13cmos5l_inv_16_0/Y out dvss sg13_lv_nmos ad=0.1406p pd=1.12u as=0.1406p ps=1.12u w=0.74u l=0.13u
X48 out sg13cmos5l_inv_16_0/Y dvdd dvdd sg13_lv_pmos ad=0.2128p pd=1.5u as=0.2128p ps=1.5u w=1.12u l=0.13u
X49 out sg13cmos5l_inv_16_0/Y dvss dvss sg13_lv_nmos ad=0.1406p pd=1.12u as=0.1406p ps=1.12u w=0.74u l=0.13u
X50 dvss sg13cmos5l_inv_16_0/Y out dvss sg13_lv_nmos ad=0.1406p pd=1.12u as=0.1406p ps=1.12u w=0.74u l=0.13u
X51 dvdd sg13cmos5l_inv_16_0/Y out dvdd sg13_lv_pmos ad=0.2128p pd=1.5u as=0.2128p ps=1.5u w=1.12u l=0.13u
X52 out sg13cmos5l_inv_16_0/Y dvss dvss sg13_lv_nmos ad=0.1406p pd=1.12u as=0.1406p ps=1.12u w=0.74u l=0.13u
X53 dvdd sg13cmos5l_inv_16_0/Y out dvdd sg13_lv_pmos ad=0.2128p pd=1.5u as=0.2128p ps=1.5u w=1.12u l=0.13u
X54 out sg13cmos5l_inv_16_0/Y dvdd dvdd sg13_lv_pmos ad=0.2128p pd=1.5u as=0.2128p ps=1.5u w=1.12u l=0.13u
X55 out sg13cmos5l_inv_16_0/Y dvdd dvdd sg13_lv_pmos ad=0.2128p pd=1.5u as=0.2128p ps=1.5u w=1.12u l=0.13u
X56 dvss sg13cmos5l_inv_16_0/Y out dvss sg13_lv_nmos ad=0.1406p pd=1.12u as=0.1406p ps=1.12u w=0.74u l=0.13u
X57 dvdd sg13cmos5l_inv_16_0/Y out dvdd sg13_lv_pmos ad=0.2128p pd=1.5u as=0.2128p ps=1.5u w=1.12u l=0.13u
X58 dvss sg13cmos5l_inv_16_0/Y out dvss sg13_lv_nmos ad=0.1406p pd=1.12u as=0.1406p ps=1.12u w=0.74u l=0.13u
X59 out sg13cmos5l_inv_16_0/Y dvss dvss sg13_lv_nmos ad=0.1406p pd=1.12u as=0.1406p ps=1.12u w=0.74u l=0.13u
X60 dvss sg13cmos5l_inv_16_0/Y out dvss sg13_lv_nmos ad=0.1406p pd=1.12u as=0.1406p ps=1.12u w=0.74u l=0.13u
X61 dvdd sg13cmos5l_inv_16_0/Y out dvdd sg13_lv_pmos ad=0.2128p pd=1.5u as=0.2128p ps=1.5u w=1.12u l=0.13u
X62 out sg13cmos5l_inv_16_0/Y dvdd dvdd sg13_lv_pmos ad=0.2128p pd=1.5u as=0.2128p ps=1.5u w=1.12u l=0.13u
X63 out sg13cmos5l_inv_16_0/Y dvss dvss sg13_lv_nmos ad=0.1406p pd=1.12u as=0.1406p ps=1.12u w=0.74u l=0.13u
X64 dvss sg13cmos5l_inv_16_0/Y out dvss sg13_lv_nmos ad=0.1406p pd=1.12u as=0.1406p ps=1.12u w=0.74u l=0.13u
X65 dvdd sg13cmos5l_inv_16_0/Y out dvdd sg13_lv_pmos ad=0.2128p pd=1.5u as=0.2128p ps=1.5u w=1.12u l=0.13u
X66 out sg13cmos5l_inv_16_0/Y dvss dvss sg13_lv_nmos ad=0.1406p pd=1.12u as=0.1406p ps=1.12u w=0.74u l=0.13u
X67 out sg13cmos5l_inv_16_0/Y dvdd dvdd sg13_lv_pmos ad=0.2128p pd=1.5u as=0.2128p ps=1.5u w=1.12u l=0.13u
X68 dvdd sg13cmos5l_inv_16_0/Y out dvdd sg13_lv_pmos ad=0.2128p pd=1.5u as=0.2128p ps=1.5u w=1.12u l=0.13u
X69 dvss sg13cmos5l_inv_16_0/Y out dvss sg13_lv_nmos ad=0.1406p pd=1.12u as=0.1406p ps=1.12u w=0.74u l=0.13u
X70 out sg13cmos5l_inv_16_0/Y dvdd dvdd sg13_lv_pmos ad=0.2128p pd=1.5u as=0.2128p ps=1.5u w=1.12u l=0.13u
X71 out sg13cmos5l_inv_16_0/Y dvss dvss sg13_lv_nmos ad=0.1406p pd=1.12u as=0.1406p ps=1.12u w=0.74u l=0.13u
.ends

.subckt power_stage1v2 enable DVDD_OUT DVDD_IN DVSS
Xsg13_lv_pmos_5MXUJM_0[0] DVDD_IN DVDD_IN gate_drive_1v2_0/out DVDD_IN DVDD_IN DVDD_IN
+ DVDD_IN DVDD_IN DVDD_IN DVDD_IN DVDD_IN DVDD_IN DVDD_OUT DVDD_OUT DVDD_OUT DVDD_OUT
+ DVDD_OUT DVDD_OUT DVDD_OUT DVDD_OUT DVDD_OUT DVDD_OUT DVDD_IN DVDD_IN DVDD_IN DVDD_IN
+ DVDD_IN DVDD_IN DVDD_IN DVDD_IN DVDD_IN DVDD_IN DVDD_OUT DVDD_OUT DVDD_OUT DVDD_OUT
+ DVDD_OUT DVDD_OUT DVDD_OUT DVDD_OUT DVDD_OUT DVDD_OUT DVDD_IN DVDD_IN DVDD_IN DVDD_IN
+ DVDD_IN DVDD_IN DVDD_IN DVDD_IN DVDD_IN DVDD_IN DVDD_OUT DVDD_OUT DVDD_OUT DVDD_OUT
+ DVDD_OUT DVDD_OUT DVDD_OUT DVDD_OUT DVDD_OUT DVDD_OUT DVDD_IN DVDD_IN DVDD_IN DVDD_IN
+ DVDD_IN DVDD_IN DVDD_IN DVDD_IN DVDD_IN DVDD_IN DVDD_OUT DVDD_OUT DVDD_OUT DVDD_OUT
+ DVDD_OUT DVDD_OUT DVDD_OUT DVDD_OUT DVDD_OUT DVDD_OUT DVDD_IN DVDD_IN DVDD_IN DVDD_IN
+ DVDD_IN DVDD_IN DVDD_IN DVDD_IN DVDD_IN DVDD_IN DVDD_OUT DVDD_OUT DVDD_OUT DVDD_OUT
+ DVDD_OUT DVDD_OUT DVDD_OUT DVDD_OUT DVDD_OUT DVDD_OUT DVDD_IN DVDD_IN DVDD_IN DVDD_IN
+ DVDD_IN DVDD_IN DVDD_IN DVDD_IN DVDD_IN DVDD_IN sg13_lv_pmos_5MXUJM
Xsg13_lv_pmos_5MXUJM_0[1] DVDD_IN DVDD_IN gate_drive_1v2_0/out DVDD_IN DVDD_IN DVDD_IN
+ DVDD_IN DVDD_IN DVDD_IN DVDD_IN DVDD_IN DVDD_IN DVDD_OUT DVDD_OUT DVDD_OUT DVDD_OUT
+ DVDD_OUT DVDD_OUT DVDD_OUT DVDD_OUT DVDD_OUT DVDD_OUT DVDD_IN DVDD_IN DVDD_IN DVDD_IN
+ DVDD_IN DVDD_IN DVDD_IN DVDD_IN DVDD_IN DVDD_IN DVDD_OUT DVDD_OUT DVDD_OUT DVDD_OUT
+ DVDD_OUT DVDD_OUT DVDD_OUT DVDD_OUT DVDD_OUT DVDD_OUT DVDD_IN DVDD_IN DVDD_IN DVDD_IN
+ DVDD_IN DVDD_IN DVDD_IN DVDD_IN DVDD_IN DVDD_IN DVDD_OUT DVDD_OUT DVDD_OUT DVDD_OUT
+ DVDD_OUT DVDD_OUT DVDD_OUT DVDD_OUT DVDD_OUT DVDD_OUT DVDD_IN DVDD_IN DVDD_IN DVDD_IN
+ DVDD_IN DVDD_IN DVDD_IN DVDD_IN DVDD_IN DVDD_IN DVDD_OUT DVDD_OUT DVDD_OUT DVDD_OUT
+ DVDD_OUT DVDD_OUT DVDD_OUT DVDD_OUT DVDD_OUT DVDD_OUT DVDD_IN DVDD_IN DVDD_IN DVDD_IN
+ DVDD_IN DVDD_IN DVDD_IN DVDD_IN DVDD_IN DVDD_IN DVDD_OUT DVDD_OUT DVDD_OUT DVDD_OUT
+ DVDD_OUT DVDD_OUT DVDD_OUT DVDD_OUT DVDD_OUT DVDD_OUT DVDD_IN DVDD_IN DVDD_IN DVDD_IN
+ DVDD_IN DVDD_IN DVDD_IN DVDD_IN DVDD_IN DVDD_IN sg13_lv_pmos_5MXUJM
Xsg13_lv_pmos_5MXUJM_0[2] DVDD_IN DVDD_IN gate_drive_1v2_0/out DVDD_IN DVDD_IN DVDD_IN
+ DVDD_IN DVDD_IN DVDD_IN DVDD_IN DVDD_IN DVDD_IN DVDD_OUT DVDD_OUT DVDD_OUT DVDD_OUT
+ DVDD_OUT DVDD_OUT DVDD_OUT DVDD_OUT DVDD_OUT DVDD_OUT DVDD_IN DVDD_IN DVDD_IN DVDD_IN
+ DVDD_IN DVDD_IN DVDD_IN DVDD_IN DVDD_IN DVDD_IN DVDD_OUT DVDD_OUT DVDD_OUT DVDD_OUT
+ DVDD_OUT DVDD_OUT DVDD_OUT DVDD_OUT DVDD_OUT DVDD_OUT DVDD_IN DVDD_IN DVDD_IN DVDD_IN
+ DVDD_IN DVDD_IN DVDD_IN DVDD_IN DVDD_IN DVDD_IN DVDD_OUT DVDD_OUT DVDD_OUT DVDD_OUT
+ DVDD_OUT DVDD_OUT DVDD_OUT DVDD_OUT DVDD_OUT DVDD_OUT DVDD_IN DVDD_IN DVDD_IN DVDD_IN
+ DVDD_IN DVDD_IN DVDD_IN DVDD_IN DVDD_IN DVDD_IN DVDD_OUT DVDD_OUT DVDD_OUT DVDD_OUT
+ DVDD_OUT DVDD_OUT DVDD_OUT DVDD_OUT DVDD_OUT DVDD_OUT DVDD_IN DVDD_IN DVDD_IN DVDD_IN
+ DVDD_IN DVDD_IN DVDD_IN DVDD_IN DVDD_IN DVDD_IN DVDD_OUT DVDD_OUT DVDD_OUT DVDD_OUT
+ DVDD_OUT DVDD_OUT DVDD_OUT DVDD_OUT DVDD_OUT DVDD_OUT DVDD_IN DVDD_IN DVDD_IN DVDD_IN
+ DVDD_IN DVDD_IN DVDD_IN DVDD_IN DVDD_IN DVDD_IN sg13_lv_pmos_5MXUJM
Xsg13_lv_pmos_5MXUJM_0[3] DVDD_IN DVDD_IN gate_drive_1v2_0/out DVDD_IN DVDD_IN DVDD_IN
+ DVDD_IN DVDD_IN DVDD_IN DVDD_IN DVDD_IN DVDD_IN DVDD_OUT DVDD_OUT DVDD_OUT DVDD_OUT
+ DVDD_OUT DVDD_OUT DVDD_OUT DVDD_OUT DVDD_OUT DVDD_OUT DVDD_IN DVDD_IN DVDD_IN DVDD_IN
+ DVDD_IN DVDD_IN DVDD_IN DVDD_IN DVDD_IN DVDD_IN DVDD_OUT DVDD_OUT DVDD_OUT DVDD_OUT
+ DVDD_OUT DVDD_OUT DVDD_OUT DVDD_OUT DVDD_OUT DVDD_OUT DVDD_IN DVDD_IN DVDD_IN DVDD_IN
+ DVDD_IN DVDD_IN DVDD_IN DVDD_IN DVDD_IN DVDD_IN DVDD_OUT DVDD_OUT DVDD_OUT DVDD_OUT
+ DVDD_OUT DVDD_OUT DVDD_OUT DVDD_OUT DVDD_OUT DVDD_OUT DVDD_IN DVDD_IN DVDD_IN DVDD_IN
+ DVDD_IN DVDD_IN DVDD_IN DVDD_IN DVDD_IN DVDD_IN DVDD_OUT DVDD_OUT DVDD_OUT DVDD_OUT
+ DVDD_OUT DVDD_OUT DVDD_OUT DVDD_OUT DVDD_OUT DVDD_OUT DVDD_IN DVDD_IN DVDD_IN DVDD_IN
+ DVDD_IN DVDD_IN DVDD_IN DVDD_IN DVDD_IN DVDD_IN DVDD_OUT DVDD_OUT DVDD_OUT DVDD_OUT
+ DVDD_OUT DVDD_OUT DVDD_OUT DVDD_OUT DVDD_OUT DVDD_OUT DVDD_IN DVDD_IN DVDD_IN DVDD_IN
+ DVDD_IN DVDD_IN DVDD_IN DVDD_IN DVDD_IN DVDD_IN sg13_lv_pmos_5MXUJM
Xsg13_lv_pmos_5MXUJM_0[4] DVDD_IN DVDD_IN gate_drive_1v2_0/out DVDD_IN DVDD_IN DVDD_IN
+ DVDD_IN DVDD_IN DVDD_IN DVDD_IN DVDD_IN DVDD_IN DVDD_OUT DVDD_OUT DVDD_OUT DVDD_OUT
+ DVDD_OUT DVDD_OUT DVDD_OUT DVDD_OUT DVDD_OUT DVDD_OUT DVDD_IN DVDD_IN DVDD_IN DVDD_IN
+ DVDD_IN DVDD_IN DVDD_IN DVDD_IN DVDD_IN DVDD_IN DVDD_OUT DVDD_OUT DVDD_OUT DVDD_OUT
+ DVDD_OUT DVDD_OUT DVDD_OUT DVDD_OUT DVDD_OUT DVDD_OUT DVDD_IN DVDD_IN DVDD_IN DVDD_IN
+ DVDD_IN DVDD_IN DVDD_IN DVDD_IN DVDD_IN DVDD_IN DVDD_OUT DVDD_OUT DVDD_OUT DVDD_OUT
+ DVDD_OUT DVDD_OUT DVDD_OUT DVDD_OUT DVDD_OUT DVDD_OUT DVDD_IN DVDD_IN DVDD_IN DVDD_IN
+ DVDD_IN DVDD_IN DVDD_IN DVDD_IN DVDD_IN DVDD_IN DVDD_OUT DVDD_OUT DVDD_OUT DVDD_OUT
+ DVDD_OUT DVDD_OUT DVDD_OUT DVDD_OUT DVDD_OUT DVDD_OUT DVDD_IN DVDD_IN DVDD_IN DVDD_IN
+ DVDD_IN DVDD_IN DVDD_IN DVDD_IN DVDD_IN DVDD_IN DVDD_OUT DVDD_OUT DVDD_OUT DVDD_OUT
+ DVDD_OUT DVDD_OUT DVDD_OUT DVDD_OUT DVDD_OUT DVDD_OUT DVDD_IN DVDD_IN DVDD_IN DVDD_IN
+ DVDD_IN DVDD_IN DVDD_IN DVDD_IN DVDD_IN DVDD_IN sg13_lv_pmos_5MXUJM
Xgate_drive_1v2_0 enable gate_drive_1v2_0/out DVSS DVDD_IN gate_drive_1v2
.ends

.subckt sg13cmos5l_buf_8 X A VDD VSS
X0 VSS A a_27_118# VSS sg13_lv_nmos ad=0.1406p pd=1.12u as=0.1406p ps=1.12u w=0.74u l=0.13u
X1 VSS A a_27_118# VSS sg13_lv_nmos ad=0.1406p pd=1.12u as=0.2553p ps=2.17u w=0.74u l=0.13u
X2 VDD A a_27_118# VDD sg13_lv_pmos ad=0.2128p pd=1.5u as=0.2128p ps=1.5u w=1.12u l=0.13u
X3 X a_27_118# VSS VSS sg13_lv_nmos ad=0.1406p pd=1.12u as=0.1406p ps=1.12u w=0.74u l=0.13u
X4 VDD A a_27_118# VDD sg13_lv_pmos ad=0.2128p pd=1.5u as=0.3808p ps=2.92u w=1.12u l=0.13u
X5 X a_27_118# VDD VDD sg13_lv_pmos ad=0.2128p pd=1.5u as=0.2128p ps=1.5u w=1.12u l=0.13u
X6 VSS a_27_118# X VSS sg13_lv_nmos ad=0.1406p pd=1.12u as=0.1406p ps=1.12u w=0.74u l=0.13u
X7 VDD a_27_118# X VDD sg13_lv_pmos ad=0.2128p pd=1.5u as=0.2128p ps=1.5u w=1.12u l=0.13u
X8 X a_27_118# VSS VSS sg13_lv_nmos ad=0.1406p pd=1.12u as=0.1406p ps=1.12u w=0.74u l=0.13u
X9 X a_27_118# VDD VDD sg13_lv_pmos ad=0.2128p pd=1.5u as=0.2128p ps=1.5u w=1.12u l=0.13u
X10 VSS a_27_118# X VSS sg13_lv_nmos ad=0.1406p pd=1.12u as=0.1406p ps=1.12u w=0.74u l=0.13u
X11 X a_27_118# VSS VSS sg13_lv_nmos ad=0.1406p pd=1.12u as=0.1406p ps=1.12u w=0.74u l=0.13u
X12 VDD a_27_118# X VDD sg13_lv_pmos ad=0.2128p pd=1.5u as=0.2128p ps=1.5u w=1.12u l=0.13u
X13 X a_27_118# VDD VDD sg13_lv_pmos ad=0.2128p pd=1.5u as=0.2128p ps=1.5u w=1.12u l=0.13u
X14 VSS a_27_118# X VSS sg13_lv_nmos ad=0.1406p pd=1.12u as=0.1406p ps=1.12u w=0.74u l=0.13u
X15 VDD a_27_118# X VDD sg13_lv_pmos ad=0.2128p pd=1.5u as=0.2128p ps=1.5u w=1.12u l=0.13u
X16 X a_27_118# VSS VSS sg13_lv_nmos ad=0.1406p pd=1.12u as=0.1406p ps=1.12u w=0.74u l=0.13u
X17 VSS a_27_118# X VSS sg13_lv_nmos ad=0.2516p pd=2.16u as=0.1406p ps=1.12u w=0.74u l=0.13u
X18 X a_27_118# VDD VDD sg13_lv_pmos ad=0.2128p pd=1.5u as=0.2128p ps=1.5u w=1.12u l=0.13u
X19 VDD a_27_118# X VDD sg13_lv_pmos ad=0.3864p pd=2.93u as=0.2128p ps=1.5u w=1.12u l=0.13u
X20 a_27_118# A VSS VSS sg13_lv_nmos ad=0.1406p pd=1.12u as=0.1406p ps=1.12u w=0.74u l=0.13u
X21 a_27_118# A VDD VDD sg13_lv_pmos ad=0.2128p pd=1.5u as=0.2128p ps=1.5u w=1.12u l=0.13u
.ends

.subckt sg13cmos5l_decap_8 VDD VSS
X0 VSS VDD VSS VSS sg13_lv_nmos ad=0.1428p pd=1.52u as=0 ps=0 w=0.42u l=1u
X1 VDD VSS VDD VDD sg13_lv_pmos ad=0.19p pd=1.38u as=0 ps=0 w=1u l=1u
X2 VSS VDD VSS VSS sg13_lv_nmos ad=79.8f pd=0.8u as=0 ps=0 w=0.42u l=1u
X3 VDD VSS VDD VDD sg13_lv_pmos ad=0.34p pd=2.68u as=0 ps=0 w=1u l=1u
.ends

.subckt sg13cmos5l_mux2_1 X A0 A1 S VDD VSS
X0 a_559_412# A1 a_382_118# VDD sg13_lv_pmos ad=0.2975p pd=1.595u as=0.2225p ps=1.445u w=1u l=0.13u
X1 VDD S a_59_156# VDD sg13_lv_pmos ad=0.253p pd=1.53u as=0.2856p ps=2.36u w=0.84u l=0.13u
X2 VSS S a_59_156# VSS sg13_lv_nmos ad=0.18945p pd=1.27u as=0.187p ps=1.78u w=0.55u l=0.13u
X3 X a_382_118# VSS VSS sg13_lv_nmos ad=0.4033p pd=2.57u as=0.148p ps=1.14u w=0.74u l=0.13u
X4 X a_382_118# VDD VDD sg13_lv_pmos ad=0.6048p pd=3.32u as=0.2198p ps=1.52u w=1.12u l=0.13u
X5 a_285_118# S VSS VSS sg13_lv_nmos ad=0.13135p pd=1.095u as=0.18945p ps=1.27u w=0.74u l=0.13u
X6 a_285_412# S VDD VDD sg13_lv_pmos ad=0.3325p pd=1.665u as=0.253p ps=1.53u w=1u l=0.13u
X7 VSS a_59_156# a_496_118# VSS sg13_lv_nmos ad=0.148p pd=1.14u as=0.3367p ps=1.65u w=0.74u l=0.13u
X8 VDD a_59_156# a_559_412# VDD sg13_lv_pmos ad=0.2198p pd=1.52u as=0.2975p ps=1.595u w=1u l=0.13u
X9 a_382_118# A1 a_285_118# VSS sg13_lv_nmos ad=0.1628p pd=1.18u as=0.13135p ps=1.095u w=0.74u l=0.13u
X10 a_496_118# A0 a_382_118# VSS sg13_lv_nmos ad=0.3367p pd=1.65u as=0.1628p ps=1.18u w=0.74u l=0.13u
X11 a_382_118# A0 a_285_412# VDD sg13_lv_pmos ad=0.2225p pd=1.445u as=0.3325p ps=1.665u w=1u l=0.13u
.ends

.subckt sg13cmos5l_buf_1 X A VDD VSS
X0 X a_40_152# VSS VSS sg13_lv_nmos ad=0.2886p pd=2.26u as=0.14875p ps=1.16u w=0.74u l=0.13u
X1 X a_40_152# VDD VDD sg13_lv_pmos ad=0.42p pd=2.99u as=0.2114p ps=1.54u w=1.12u l=0.13u
X2 VDD A a_40_152# VDD sg13_lv_pmos ad=0.2114p pd=1.54u as=0.2856p ps=2.36u w=0.84u l=0.13u
X3 VSS A a_40_152# VSS sg13_lv_nmos ad=0.14875p pd=1.16u as=0.187p ps=1.78u w=0.55u l=0.13u
.ends

.subckt sg13cmos5l_buf_4 X A VDD VSS
X0 X a_111_82# VSS VSS sg13_lv_nmos ad=0.1406p pd=1.12u as=0.2516p ps=2.16u w=0.74u l=0.13u
X1 X a_111_82# VDD VDD sg13_lv_pmos ad=0.2128p pd=1.5u as=0.3808p ps=2.92u w=1.12u l=0.13u
X2 VSS a_111_82# X VSS sg13_lv_nmos ad=0.1406p pd=1.12u as=0.1406p ps=1.12u w=0.74u l=0.13u
X3 VDD a_111_82# X VDD sg13_lv_pmos ad=0.2128p pd=1.5u as=0.2128p ps=1.5u w=1.12u l=0.13u
X4 X a_111_82# VSS VSS sg13_lv_nmos ad=0.1406p pd=1.12u as=0.1406p ps=1.12u w=0.74u l=0.13u
X5 VSS a_111_82# X VSS sg13_lv_nmos ad=0.3293p pd=1.63u as=0.1406p ps=1.12u w=0.74u l=0.13u
X6 X a_111_82# VDD VDD sg13_lv_pmos ad=0.2128p pd=1.5u as=0.2128p ps=1.5u w=1.12u l=0.13u
X7 VDD a_111_82# X VDD sg13_lv_pmos ad=0.203p pd=1.5u as=0.2128p ps=1.5u w=1.12u l=0.13u
X8 a_111_82# A VSS VSS sg13_lv_nmos ad=0.2516p pd=2.16u as=0.3293p ps=1.63u w=0.74u l=0.13u
X9 a_111_82# A VDD VDD sg13_lv_pmos ad=0.1596p pd=1.22u as=0.203p ps=1.5u w=0.84u l=0.13u
X10 VDD A a_111_82# VDD sg13_lv_pmos ad=0.2856p pd=2.36u as=0.1596p ps=1.22u w=0.84u l=0.13u
.ends

.subckt sg13cmos5l_dlhrq_1 Q D GATE RESET_B VDD VSS
X0 a_815_103# a_264_468# a_689_103# VSS sg13_lv_nmos ad=47.25f pd=0.645u as=0.15175p ps=1.14u w=0.42u l=0.13u
X1 a_689_103# a_264_468# a_614_436# VDD sg13_lv_pmos ad=0.1897p pd=1.42u as=0.1375p ps=1.275u w=1u l=0.13u
X2 a_1095_118# a_689_103# a_860_67# VSS sg13_lv_nmos ad=88.8f pd=0.98u as=0.2516p ps=2.16u w=0.74u l=0.13u
X3 a_860_67# a_689_103# VDD VDD sg13_lv_pmos ad=0.19p pd=1.38u as=0.20165p ps=1.615u w=1u l=0.13u
X4 a_805_552# a_409_103# a_689_103# VDD sg13_lv_pmos ad=0.11025p pd=0.945u as=0.1897p ps=1.42u w=0.42u l=0.13u
X5 VDD RESET_B a_860_67# VDD sg13_lv_pmos ad=0.2038p pd=1.5u as=0.19p ps=1.38u w=1u l=0.13u
X6 VSS RESET_B a_1095_118# VSS sg13_lv_nmos ad=0.1406p pd=1.12u as=88.8f ps=0.98u w=0.74u l=0.13u
X7 Q a_860_67# VSS VSS sg13_lv_nmos ad=0.2516p pd=2.16u as=0.1406p ps=1.12u w=0.74u l=0.13u
X8 VSS D a_45_156# VSS sg13_lv_nmos ad=0.14875p pd=1.16u as=0.3025p ps=2.2u w=0.55u l=0.13u
X9 VDD a_264_468# a_409_103# VDD sg13_lv_pmos ad=0.2015p pd=1.415u as=0.2856p ps=2.36u w=0.84u l=0.13u
X10 VDD D a_45_156# VDD sg13_lv_pmos ad=0.1596p pd=1.22u as=0.2856p ps=2.36u w=0.84u l=0.13u
X11 Q a_860_67# VDD VDD sg13_lv_pmos ad=0.4368p pd=3.02u as=0.2038p ps=1.5u w=1.12u l=0.13u
X12 VDD a_860_67# a_805_552# VDD sg13_lv_pmos ad=0.20165p pd=1.615u as=0.11025p ps=0.945u w=0.42u l=0.13u
X13 a_264_468# GATE VDD VDD sg13_lv_pmos ad=0.46837p pd=3u as=0.1596p ps=1.22u w=0.84u l=0.13u
X14 a_614_436# a_45_156# VDD VDD sg13_lv_pmos ad=0.1375p pd=1.275u as=0.2015p ps=1.415u w=1u l=0.13u
X15 VSS a_860_67# a_815_103# VSS sg13_lv_nmos ad=0.1428p pd=1.52u as=47.25f ps=0.645u w=0.42u l=0.13u
X16 a_264_468# GATE VSS VSS sg13_lv_nmos ad=0.2516p pd=2.16u as=0.14875p ps=1.16u w=0.74u l=0.13u
X17 a_689_103# a_409_103# a_611_103# VSS sg13_lv_nmos ad=0.15175p pd=1.14u as=83.2f ps=0.9u w=0.64u l=0.13u
X18 VSS a_264_468# a_409_103# VSS sg13_lv_nmos ad=0.1393p pd=1.155u as=0.3458p ps=2.7u w=0.74u l=0.13u
X19 a_611_103# a_45_156# VSS VSS sg13_lv_nmos ad=83.2f pd=0.9u as=0.1393p ps=1.155u w=0.64u l=0.13u
.ends

.subckt sg13cmos5l_and2_1 X A B VDD VSS
X0 X a_45_160# VDD VDD sg13_lv_pmos ad=0.3808p pd=2.92u as=0.1918p ps=1.5u w=1.12u l=0.13u
X1 X a_45_160# VSS VSS sg13_lv_nmos ad=0.2516p pd=2.16u as=0.1331p ps=1.12u w=0.74u l=0.13u
X2 a_45_160# A VDD VDD sg13_lv_pmos ad=0.1596p pd=1.22u as=0.2856p ps=2.36u w=0.84u l=0.13u
X3 VDD B a_45_160# VDD sg13_lv_pmos ad=0.1918p pd=1.5u as=0.1596p ps=1.22u w=0.84u l=0.13u
X4 a_139_160# A a_45_160# VSS sg13_lv_nmos ad=0.1216p pd=1.02u as=0.2176p ps=1.96u w=0.64u l=0.13u
X5 VSS B a_139_160# VSS sg13_lv_nmos ad=0.1331p pd=1.12u as=0.1216p ps=1.02u w=0.64u l=0.13u
.ends

.subckt sg13cmos5l_nor3_1 Y A B C VDD VSS
X0 Y A VSS VSS sg13_lv_nmos ad=0.1694p pd=1.21u as=0.2618p ps=2.22u w=0.77u l=0.13u
X1 a_165_412# A VDD VDD sg13_lv_pmos ad=0.2464p pd=1.56u as=0.3808p ps=2.92u w=1.12u l=0.13u
X2 VSS B Y VSS sg13_lv_nmos ad=0.1463p pd=1.15u as=0.1694p ps=1.21u w=0.77u l=0.13u
X3 Y C VSS VSS sg13_lv_nmos ad=0.2618p pd=2.22u as=0.1463p ps=1.15u w=0.77u l=0.13u
X4 a_279_412# B a_165_412# VDD sg13_lv_pmos ad=0.2128p pd=1.5u as=0.2464p ps=1.56u w=1.12u l=0.13u
X5 Y C a_279_412# VDD sg13_lv_pmos ad=0.3808p pd=2.92u as=0.2128p ps=1.5u w=1.12u l=0.13u
.ends

.subckt sg13cmos5l_dlygate4sd3_1 X A VDD VSS
X0 VDD A a_56_118# VDD sg13_lv_pmos ad=0.1523p pd=1.38u as=0.1428p ps=1.52u w=0.42u l=0.13u
X1 VSS a_326_118# a_438_182# VSS sg13_lv_nmos ad=0.1426p pd=1.16u as=0.1428p ps=1.52u w=0.42u l=0.5u
X2 VDD a_326_118# a_438_182# VDD sg13_lv_pmos ad=0.2254p pd=1.53u as=0.34p ps=2.68u w=1u l=0.5u
X3 X a_438_182# VDD VDD sg13_lv_pmos ad=0.4256p pd=3u as=0.2254p ps=1.53u w=1.12u l=0.13u
X4 a_326_118# a_56_118# VDD VDD sg13_lv_pmos ad=0.34p pd=2.68u as=0.1523p ps=1.38u w=1u l=0.5u
X5 VSS A a_56_118# VSS sg13_lv_nmos ad=79.8f pd=0.8u as=0.1428p ps=1.52u w=0.42u l=0.13u
X6 X a_438_182# VSS VSS sg13_lv_nmos ad=0.2516p pd=2.16u as=0.1426p ps=1.16u w=0.74u l=0.13u
X7 a_326_118# a_56_118# VSS VSS sg13_lv_nmos ad=0.1428p pd=1.52u as=79.8f ps=0.8u w=0.42u l=0.5u
.ends

.subckt sg13cmos5l_nand4_1 Y A B C D VDD VSS
X0 Y D VDD VDD sg13_lv_pmos ad=0.2128p pd=1.5u as=0.3808p ps=2.92u w=1.12u l=0.13u
X1 VDD C Y VDD sg13_lv_pmos ad=0.2128p pd=1.5u as=0.2128p ps=1.5u w=1.12u l=0.13u
X2 Y B VDD VDD sg13_lv_pmos ad=0.2128p pd=1.5u as=0.2128p ps=1.5u w=1.12u l=0.13u
X3 VDD A Y VDD sg13_lv_pmos ad=0.3808p pd=2.92u as=0.2128p ps=1.5u w=1.12u l=0.13u
X4 a_146_122# D VSS VSS sg13_lv_nmos ad=0.1406p pd=1.12u as=0.2516p ps=2.16u w=0.74u l=0.13u
X5 a_248_122# C a_146_122# VSS sg13_lv_nmos ad=0.1406p pd=1.12u as=0.1406p ps=1.12u w=0.74u l=0.13u
X6 a_350_122# B a_248_122# VSS sg13_lv_nmos ad=0.1406p pd=1.12u as=0.1406p ps=1.12u w=0.74u l=0.13u
X7 Y A a_350_122# VSS sg13_lv_nmos ad=0.2516p pd=2.16u as=0.1406p ps=1.12u w=0.74u l=0.13u
.ends

.subckt sg13cmos5l_xor2_1 X A B VDD VSS
X0 VSS a_209_168# X VSS sg13_lv_nmos ad=0.3108p pd=2.32u as=0.1628p ps=1.18u w=0.74u l=0.13u
X1 VDD A a_380_412# VDD sg13_lv_pmos ad=0.2128p pd=1.5u as=0.3808p ps=2.92u w=1.12u l=0.13u
X2 a_380_412# B VDD VDD sg13_lv_pmos ad=0.2128p pd=1.5u as=0.2128p ps=1.5u w=1.12u l=0.13u
X3 X a_209_168# a_380_412# VDD sg13_lv_pmos ad=0.3808p pd=2.92u as=0.2128p ps=1.5u w=1.12u l=0.13u
X4 a_177_436# A VDD VDD sg13_lv_pmos ad=0.1225p pd=1.245u as=0.36p ps=2.72u w=1u l=0.13u
X5 a_209_168# A VSS VSS sg13_lv_nmos ad=0.17462p pd=1.185u as=0.374p ps=2.46u w=0.55u l=0.13u
X6 a_209_168# B a_177_436# VDD sg13_lv_pmos ad=0.34p pd=2.68u as=0.1225p ps=1.245u w=1u l=0.13u
X7 VSS B a_209_168# VSS sg13_lv_nmos ad=0.15245p pd=1.17u as=0.17462p ps=1.185u w=0.55u l=0.13u
X8 a_474_130# A VSS VSS sg13_lv_nmos ad=88.8f pd=0.98u as=0.15245p ps=1.17u w=0.74u l=0.13u
X9 X B a_474_130# VSS sg13_lv_nmos ad=0.1628p pd=1.18u as=88.8f ps=0.98u w=0.74u l=0.13u
.ends

.subckt sg13cmos5l_nand2b_1 Y A_N B VDD VSS
X0 VDD a_27_156# Y VDD sg13_lv_pmos ad=0.3808p pd=2.92u as=0.2128p ps=1.5u w=1.12u l=0.13u
X1 a_229_118# B VSS VSS sg13_lv_nmos ad=0.1406p pd=1.12u as=0.14505p ps=1.15u w=0.74u l=0.13u
X2 VDD A_N a_27_156# VDD sg13_lv_pmos ad=0.2198p pd=1.53u as=0.2856p ps=2.36u w=0.84u l=0.13u
X3 Y B VDD VDD sg13_lv_pmos ad=0.2128p pd=1.5u as=0.2198p ps=1.53u w=1.12u l=0.13u
X4 Y a_27_156# a_229_118# VSS sg13_lv_nmos ad=0.333p pd=2.38u as=0.1406p ps=1.12u w=0.74u l=0.13u
X5 VSS A_N a_27_156# VSS sg13_lv_nmos ad=0.14505p pd=1.15u as=0.187p ps=1.78u w=0.55u l=0.13u
.ends

.subckt sg13cmos5l_lgcp_1 GCLK CLK GATE VDD VSS
X0 a_357_380# a_363_86# VDD VDD sg13_lv_pmos ad=0.2856p pd=2.36u as=1.30835p ps=9.07u w=0.84u l=0.13u
X1 VSS CLK a_363_86# VSS sg13_lv_nmos ad=0.1371p pd=1.12u as=0.2516p ps=2.16u w=0.74u l=0.13u
X2 GCLK a_1034_435# VSS VSS sg13_lv_nmos ad=0.2516p pd=2.16u as=0.2516p ps=2.16u w=0.74u l=0.13u
X3 a_521_166# a_357_380# a_134_80# VSS sg13_lv_nmos ad=54.6f pd=0.68u as=0.141p ps=1.17u w=0.42u l=0.13u
X4 a_1028_158# CLK VSS VSS sg13_lv_nmos ad=71.99999f pd=0.865u as=0.1371p ps=1.12u w=0.64u l=0.13u
X5 VDD a_66_116# a_528_550# VDD sg13_lv_pmos ad=1.30835p pd=9.07u as=54.6f ps=0.68u w=0.42u l=0.13u
X6 GCLK a_1034_435# VDD VDD sg13_lv_pmos ad=0.3808p pd=2.92u as=0.3129p ps=1.75u w=1.12u l=0.13u
X7 a_357_380# a_363_86# VSS VSS sg13_lv_nmos ad=0.2516p pd=2.16u as=0.13557p ps=1.215u w=0.74u l=0.13u
X8 a_1034_435# a_66_116# a_1028_158# VSS sg13_lv_nmos ad=0.2176p pd=1.96u as=71.99999f ps=0.865u w=0.64u l=0.13u
X9 a_315_122# GATE VSS VSS sg13_lv_nmos ad=76.8f pd=0.88u as=0.23012p ps=1.445u w=0.64u l=0.13u
X10 a_134_80# a_357_380# a_302_434# VDD sg13_lv_pmos ad=0.20445p pd=1.58u as=0.145p ps=1.29u w=1u l=0.13u
X11 a_528_550# a_363_86# a_134_80# VDD sg13_lv_pmos ad=54.6f pd=0.68u as=0.20445p ps=1.58u w=0.42u l=0.13u
X12 VDD a_134_80# a_66_116# VDD sg13_lv_pmos ad=0.3102p pd=1.7u as=0.3808p ps=2.92u w=1.12u l=0.13u
X13 a_134_80# a_363_86# a_315_122# VSS sg13_lv_nmos ad=0.141p pd=1.17u as=76.8f ps=0.88u w=0.64u l=0.13u
X14 a_302_434# GATE VDD VDD sg13_lv_pmos ad=0.145p pd=1.29u as=0.3102p ps=1.7u w=1u l=0.13u
X15 VDD CLK a_363_86# VDD sg13_lv_pmos ad=0.1596p pd=1.22u as=0.2856p ps=2.36u w=0.84u l=0.13u
X16 VSS a_134_80# a_66_116# VSS sg13_lv_nmos ad=0.23012p pd=1.445u as=0.2516p ps=2.16u w=0.74u l=0.13u
X17 a_1034_435# CLK VDD VDD sg13_lv_pmos ad=0.1596p pd=1.22u as=0.1596p ps=1.22u w=0.84u l=0.13u
X18 VDD a_66_116# a_1034_435# VDD sg13_lv_pmos ad=0.3129p pd=1.75u as=0.1596p ps=1.22u w=0.84u l=0.13u
X19 VSS a_66_116# a_521_166# VSS sg13_lv_nmos ad=0.13557p pd=1.215u as=54.6f ps=0.68u w=0.42u l=0.13u
.ends

.subckt sg13cmos5l_or4_1 X A B C D VDD VSS
X0 VSS A a_72_436# VSS sg13_lv_nmos ad=0.14135p pd=1.14u as=0.1045p ps=0.93u w=0.55u l=0.13u
X1 a_166_436# D a_72_436# VDD sg13_lv_pmos ad=0.19p pd=1.38u as=0.34p ps=2.68u w=1u l=0.13u
X2 a_268_436# C a_166_436# VDD sg13_lv_pmos ad=0.2925p pd=1.585u as=0.19p ps=1.38u w=1u l=0.13u
X3 a_411_436# B a_268_436# VDD sg13_lv_pmos ad=0.19p pd=1.38u as=0.2925p ps=1.585u w=1u l=0.13u
X4 X a_72_436# VSS VSS sg13_lv_nmos ad=0.2516p pd=2.16u as=0.14135p ps=1.14u w=0.74u l=0.13u
X5 a_72_436# D VSS VSS sg13_lv_nmos ad=0.1045p pd=0.93u as=0.187p ps=1.78u w=0.55u l=0.13u
X6 VDD A a_411_436# VDD sg13_lv_pmos ad=0.2144p pd=1.52u as=0.19p ps=1.38u w=1u l=0.13u
X7 X a_72_436# VDD VDD sg13_lv_pmos ad=0.3808p pd=2.92u as=0.2144p ps=1.52u w=1.12u l=0.13u
X8 VSS C a_72_436# VSS sg13_lv_nmos ad=0.16755p pd=1.165u as=0.1045p ps=0.93u w=0.55u l=0.13u
X9 a_72_436# B VSS VSS sg13_lv_nmos ad=0.1045p pd=0.93u as=0.16755p ps=1.165u w=0.55u l=0.13u
.ends

.subckt sg13cmos5l_dfrbpq_1 Q CLK D RESET_B VDD VSS
X0 a_550_127# RESET_B VSS VSS sg13_lv_nmos ad=37.8f pd=0.6u as=0.1701p ps=1.65u w=0.42u l=0.13u
X1 a_298_337# a_741_93# a_681_505# VDD sg13_lv_pmos ad=79.8f pd=0.8u as=63f ps=0.72u w=0.42u l=0.13u
X2 a_1840_334# a_1583_191# a_2002_114# VSS sg13_lv_nmos ad=0.1428p pd=1.52u as=37.8f ps=0.6u w=0.42u l=0.13u
X3 a_38_114# a_843_236# a_298_337# VDD sg13_lv_pmos ad=0.1428p pd=1.52u as=79.8f ps=0.8u w=0.42u l=0.13u
X4 a_741_93# CLK VSS VSS sg13_lv_nmos ad=0.2516p pd=2.16u as=2.26778p ps=14.665u w=0.74u l=0.13u
X5 a_38_114# D VDD VDD sg13_lv_pmos ad=79.8f pd=0.8u as=0.1428p ps=1.52u w=0.42u l=0.13u
X6 a_741_93# CLK VDD VDD sg13_lv_pmos ad=0.4088p pd=2.97u as=1.12285p ps=7.26u w=1.12u l=0.13u
X7 VSS a_741_93# a_843_236# VSS sg13_lv_nmos ad=2.26778p pd=14.665u as=0.2516p ps=2.16u w=0.74u l=0.13u
X8 VSS a_1840_334# a_1489_191# VSS sg13_lv_nmos ad=79.8f pd=0.8u as=0.1428p ps=1.52u w=0.42u l=0.13u
X9 VDD RESET_B a_38_114# VDD sg13_lv_pmos ad=0.36237p pd=2.605u as=79.8f ps=0.8u w=0.42u l=0.13u
X10 a_324_432# a_298_337# VSS VSS sg13_lv_nmos ad=0.2516p pd=2.16u as=0.1626p ps=1.415u w=0.74u l=0.13u
X11 VDD a_741_93# a_843_236# VDD sg13_lv_pmos ad=1.12285p pd=7.26u as=0.3864p ps=2.93u w=1.12u l=0.13u
X12 a_2002_114# RESET_B VSS VSS sg13_lv_nmos ad=37.8f pd=0.6u as=79.8f ps=0.8u w=0.42u l=0.13u
X13 VDD a_1583_191# a_2250_412# VDD sg13_lv_pmos ad=0.2128p pd=1.5u as=0.3864p ps=2.93u w=1.12u l=0.13u
X14 Q a_2250_412# VDD VDD sg13_lv_pmos ad=0.3808p pd=2.92u as=0.2128p ps=1.5u w=1.12u l=0.13u
X15 a_132_114# D a_38_114# VSS sg13_lv_nmos ad=60.89999f pd=0.71u as=0.1428p ps=1.52u w=0.42u l=0.13u
X16 a_1785_429# a_843_236# a_1583_191# VDD sg13_lv_pmos ad=93.45f pd=0.865u as=0.2048p ps=1.63u w=0.42u l=0.13u
X17 VDD a_1583_191# a_1840_334# VDD sg13_lv_pmos ad=1.12285p pd=7.26u as=79.8f ps=0.8u w=0.42u l=0.13u
X18 a_1583_191# a_741_93# a_324_432# VDD sg13_lv_pmos ad=0.2048p pd=1.63u as=0.34p ps=2.68u w=1u l=0.13u
X19 a_1583_191# a_741_93# a_1489_191# VSS sg13_lv_nmos ad=0.12665p pd=1.145u as=0.1428p ps=1.52u w=0.42u l=0.13u
X20 VDD a_1840_334# a_1785_429# VDD sg13_lv_pmos ad=1.12285p pd=7.26u as=93.45f ps=0.865u w=0.42u l=0.13u
X21 a_1840_334# RESET_B VDD VDD sg13_lv_pmos ad=79.8f pd=0.8u as=1.12285p ps=7.26u w=0.42u l=0.13u
X22 a_324_432# a_843_236# a_1583_191# VSS sg13_lv_nmos ad=0.3473p pd=2.71u as=0.12665p ps=1.145u w=0.74u l=0.13u
X23 a_298_337# a_741_93# a_38_114# VSS sg13_lv_nmos ad=79.8f pd=0.8u as=0.1296p ps=1.52u w=0.42u l=0.13u
X24 a_612_127# a_324_432# a_550_127# VSS sg13_lv_nmos ad=0.1428p pd=1.52u as=37.8f ps=0.6u w=0.42u l=0.13u
X25 a_681_505# a_324_432# VDD VDD sg13_lv_pmos ad=63f pd=0.72u as=0.1563p ps=1.22u w=0.42u l=0.13u
X26 a_612_127# a_843_236# a_298_337# VSS sg13_lv_nmos ad=0.2373p pd=1.97u as=79.8f ps=0.8u w=0.42u l=0.13u
X27 VSS a_1583_191# a_2250_412# VSS sg13_lv_nmos ad=0.1406p pd=1.12u as=0.2516p ps=2.16u w=0.74u l=0.13u
X28 a_324_432# a_298_337# VDD VDD sg13_lv_pmos ad=0.34p pd=2.68u as=0.36237p ps=2.605u w=1u l=0.13u
X29 Q a_2250_412# VSS VSS sg13_lv_nmos ad=0.2516p pd=2.16u as=0.1406p ps=1.12u w=0.74u l=0.13u
X30 VDD RESET_B a_298_337# VDD sg13_lv_pmos ad=0.1563p pd=1.22u as=0.147p ps=1.54u w=0.42u l=0.13u
X31 VSS RESET_B a_132_114# VSS sg13_lv_nmos ad=0.1626p pd=1.415u as=60.89999f ps=0.71u w=0.42u l=0.13u
.ends

.subckt user_project_control analog_ena[0] analog_ena[1] analog_ena[2] analog_ena[3]
+ clk dig_ena dig_in[0] dig_in[10] dig_in[11] dig_in[12] dig_in[13] dig_in[14] dig_in[15]
+ dig_in[16] dig_in[17] dig_in[18] dig_in[19] dig_in[1] dig_in[20] dig_in[21] dig_in[22]
+ dig_in[23] dig_in[2] dig_in[3] dig_in[4] dig_in[5] dig_in[6] dig_in[7] dig_in[8]
+ dig_in[9] dig_out[0] dig_out[10] dig_out[11] dig_out[1] dig_out[2] dig_out[3] dig_out[4]
+ dig_out[5] dig_out[6] dig_out[7] dig_out[8] dig_out[9] dig_out_relay[0] dig_out_relay[10]
+ dig_out_relay[11] dig_out_relay[1] dig_out_relay[2] dig_out_relay[3] dig_out_relay[4]
+ dig_out_relay[5] dig_out_relay[6] dig_out_relay[7] dig_out_relay[8] dig_out_relay[9]
+ enable ibias_ena[0] ibias_ena[1] power_1v2_ena power_3v3_ena proj_1v2_ena proj_3v3_ena
+ proj_addr[0] proj_addr[1] proj_addr[2] proj_addr[3] proj_addr[4] proj_analog_ena[0]
+ proj_analog_ena[1] proj_analog_ena[2] proj_analog_ena[3] proj_clk proj_dig_in[0]
+ proj_dig_in[10] proj_dig_in[11] proj_dig_in[12] proj_dig_in[13] proj_dig_in[14]
+ proj_dig_in[15] proj_dig_in[16] proj_dig_in[17] proj_dig_in[18] proj_dig_in[19]
+ proj_dig_in[1] proj_dig_in[20] proj_dig_in[21] proj_dig_in[22] proj_dig_in[23] proj_dig_in[2]
+ proj_dig_in[3] proj_dig_in[4] proj_dig_in[5] proj_dig_in[6] proj_dig_in[7] proj_dig_in[8]
+ proj_dig_in[9] proj_dig_out[0] proj_dig_out[10] proj_dig_out[11] proj_dig_out[1]
+ proj_dig_out[2] proj_dig_out[3] proj_dig_out[4] proj_dig_out[5] proj_dig_out[6]
+ proj_dig_out[7] proj_dig_out[8] proj_dig_out[9] proj_ena proj_ibias_ena[0] proj_ibias_ena[1]
+ proj_reset proj_sel[0] proj_sel[1] proj_sel[2] proj_sel[3] proj_sel[4] proj_vbias_ena
+ reset vbias_ena vddd vssd
Xuserbuffers\[1\] proj_dig_in[1] userbuffers\[1\]/A vddd vssd sg13cmos5l_buf_8
XFILLER_12_21 vddd vssd sg13cmos5l_decap_8
XFILLER_10_158 vddd vssd sg13cmos5l_decap_8
Xtiedowns\[31\] dig_in[7] vddd vssd sg13cmos5l_antennanp
XFILLER_2_198 vddd vssd sg13cmos5l_decap_8
X_49_ _49_/X proj_dig_out[10] dig_out_relay[10] _50_/S vddd vssd sg13cmos5l_mux2_1
Xfanout7 fanout7/X fanout8/X vddd vssd sg13cmos5l_buf_1
Xoutbuffers\[6\] dig_out[6] _45_/X vddd vssd sg13cmos5l_buf_4
XFILLER_11_0 vddd vssd sg13cmos5l_decap_8
Xtiedowns\[61\] proj_sel[0] vddd vssd sg13cmos5l_antennanp
XFILLER_13_112 vddd vssd sg13cmos5l_decap_8
Xuserbuffers\[12\] proj_dig_in[12] userbuffers\[12\]/A vddd vssd sg13cmos5l_buf_8
XFILLER_8_193 vddd vssd sg13cmos5l_decap_8
XFILLER_12_99 vddd vssd sg13cmos5l_decap_8
XFILLER_12_77 vddd vssd sg13cmos5l_decap_8
XFILLER_10_137 vddd vssd sg13cmos5l_decap_8
Xdig_in_gen\[9\].dig_in_latch userbuffers\[9\]/A dig_in[9] _14_/A fanout6/X vddd vssd
+ sg13cmos5l_dlhrq_1
Xtiedowns\[24\] dig_in[0] vddd vssd sg13cmos5l_antennanp
X_48_ _48_/X proj_dig_out[9] dig_out_relay[9] _50_/S vddd vssd sg13cmos5l_mux2_1
Xtiedowns\[8\] proj_dig_out[8] vddd vssd sg13cmos5l_antennanp
Xfanout8 fanout8/X _26_/Y vddd vssd sg13cmos5l_buf_1
Xswitchbuffers\[2\] proj_ibias_ena[1] _37_/X vddd vssd sg13cmos5l_buf_4
XFILLER_9_117 vddd vssd sg13cmos5l_decap_8
Xdig_in_gen\[12\].dig_in_latch userbuffers\[12\]/A dig_in[12] _14_/A fanout5/X vddd
+ vssd sg13cmos5l_dlhrq_1
Xtiedowns\[54\] analog_ena[1] vddd vssd sg13cmos5l_antennanp
XFILLER_3_47 vddd vssd sg13cmos5l_decap_8
XFILLER_12_56 vddd vssd sg13cmos5l_decap_8
XFILLER_10_116 vddd vssd sg13cmos5l_decap_8
Xtiedowns\[17\] dig_out_relay[5] vddd vssd sg13cmos5l_antennanp
XFILLER_2_101 vddd vssd sg13cmos5l_decap_4
X_47_ _47_/X proj_dig_out[8] dig_out_relay[8] _50_/S vddd vssd sg13cmos5l_mux2_1
XFILLER_9_46 vddd vssd sg13cmos5l_decap_8
Xfanout9 fanout9/X fanout9/A vddd vssd sg13cmos5l_buf_1
XFILLER_1_0 vddd vssd sg13cmos5l_decap_8
XFILLER_13_147 vddd vssd sg13cmos5l_decap_8
Xtiedowns\[47\] dig_in[23] vddd vssd sg13cmos5l_antennanp
XFILLER_5_198 vddd vssd sg13cmos5l_decap_8
X_46_ _46_/X proj_dig_out[7] dig_out_relay[7] _50_/S vddd vssd sg13cmos5l_mux2_1
Xdig_in_gen\[5\].dig_in_latch userbuffers\[5\]/A dig_in[5] fanout12/X fanout6/X vddd
+ vssd sg13cmos5l_dlhrq_1
X_29_ _29_/X analog_ena[2] _37_/B vddd vssd sg13cmos5l_and2_1
XFILLER_0_200 vddd vssd sg13cmos5l_decap_4
Xoutbuffers\[4\] dig_out[4] _43_/X vddd vssd sg13cmos5l_buf_4
XFILLER_12_14 vddd vssd sg13cmos5l_decap_8
XFILLER_5_177 vddd vssd sg13cmos5l_decap_4
Xuserbuffers\[10\] proj_dig_in[10] userbuffers\[10\]/A vddd vssd sg13cmos5l_buf_8
X_45_ _45_/X proj_dig_out[6] dig_out_relay[6] _50_/S vddd vssd sg13cmos5l_mux2_1
Xclkload0 clkload0/X clkload0/A vddd vssd sg13cmos5l_buf_4
Xtiedowns\[22\] dig_out_relay[10] vddd vssd sg13cmos5l_antennanp
X_28_ _28_/X analog_ena[1] _37_/B vddd vssd sg13cmos5l_and2_1
Xtiedowns\[6\] proj_dig_out[6] vddd vssd sg13cmos5l_antennanp
XFILLER_6_49 vddd vssd sg13cmos5l_decap_4
Xswitchbuffers\[0\] proj_vbias_ena _35_/X vddd vssd sg13cmos5l_buf_4
XFILLER_13_7 vddd vssd sg13cmos5l_decap_8
XFILLER_13_105 vddd vssd sg13cmos5l_decap_8
Xtiedowns\[52\] ibias_ena[1] vddd vssd sg13cmos5l_antennanp
XFILLER_5_112 vddd vssd sg13cmos5l_decap_8
XFILLER_13_91 vddd vssd sg13cmos5l_decap_8
X_44_ _44_/X proj_dig_out[5] dig_out_relay[5] _44_/S vddd vssd sg13cmos5l_mux2_1
X_27_ _27_/X analog_ena[0] _37_/B vddd vssd sg13cmos5l_and2_1
Xtiedowns\[15\] dig_out_relay[3] vddd vssd sg13cmos5l_antennanp
Xdig_in_gen\[1\].dig_in_latch userbuffers\[1\]/A dig_in[1] fanout12/X fanout6/X vddd
+ vssd sg13cmos5l_dlhrq_1
XFILLER_10_81 vddd vssd sg13cmos5l_decap_8
XFILLER_7_82 vddd vssd sg13cmos5l_decap_4
XFILLER_12_150 vddd vssd sg13cmos5l_decap_8
XFILLER_8_121 vddd vssd sg13cmos5l_decap_8
XFILLER_10_109 vddd vssd sg13cmos5l_decap_8
Xtiedowns\[45\] dig_in[21] vddd vssd sg13cmos5l_antennanp
XFILLER_4_50 vddd vssd sg13cmos5l_decap_4
XFILLER_13_70 vddd vssd sg13cmos5l_decap_8
XFILLER_9_39 vddd vssd sg13cmos5l_decap_8
X_43_ _43_/X proj_dig_out[4] dig_out_relay[4] _44_/S vddd vssd sg13cmos5l_mux2_1
X_26_ _26_/Y _38_/B _38_/C _38_/D vddd vssd sg13cmos5l_nor3_1
Xhold14 hold16/A hold15/X vddd vssd sg13cmos5l_dlygate4sd3_1
XFILLER_10_60 vddd vssd sg13cmos5l_decap_8
Xuserbuffers\[8\] proj_dig_in[8] userbuffers\[8\]/A vddd vssd sg13cmos5l_buf_8
Xuserbuffers\[26\] proj_clk clockgate/GCLK vddd vssd sg13cmos5l_buf_8
Xdig_in_gen\[19\].dig_in_latch userbuffers\[19\]/A dig_in[19] fanout10/X _36_/B vddd
+ vssd sg13cmos5l_dlhrq_1
XFILLER_12_28 vddd vssd sg13cmos5l_decap_4
Xoutbuffers\[2\] dig_out[2] _41_/X vddd vssd sg13cmos5l_buf_4
Xtiedowns\[38\] dig_in[14] vddd vssd sg13cmos5l_antennanp
XFILLER_4_191 vddd vssd sg13cmos5l_decap_8
X_42_ _42_/X proj_dig_out[3] dig_out_relay[3] _44_/S vddd vssd sg13cmos5l_mux2_1
XFILLER_1_194 vddd vssd sg13cmos5l_decap_8
X_25_ _38_/D _25_/A _25_/B _25_/C _25_/D vddd vssd sg13cmos5l_nand4_1
Xtiedowns\[20\] dig_out_relay[8] vddd vssd sg13cmos5l_antennanp
Xhold15 hold15/X _51_/Q vddd vssd sg13cmos5l_dlygate4sd3_1
Xtiedowns\[4\] proj_dig_out[4] vddd vssd sg13cmos5l_antennanp
Xclkbuf_0_clk clkbuf_0_clk/X clk vddd vssd sg13cmos5l_buf_8
Xtiedowns\[68\] proj_addr[2] vddd vssd sg13cmos5l_antennanp
XFILLER_11_7 vddd vssd sg13cmos5l_decap_4
Xuserbuffers\[19\] proj_dig_in[19] userbuffers\[19\]/A vddd vssd sg13cmos5l_buf_8
XFILLER_13_119 vddd vssd sg13cmos5l_decap_8
XFILLER_5_126 vddd vssd sg13cmos5l_decap_8
X_41_ _41_/X proj_dig_out[2] dig_out_relay[2] _44_/S vddd vssd sg13cmos5l_mux2_1
Xtiedowns\[50\] vbias_ena vddd vssd sg13cmos5l_antennanp
X_24_ _38_/C _24_/A _24_/B _24_/C _24_/D vddd vssd sg13cmos5l_nand4_1
Xhold16 _52_/D hold16/A vddd vssd sg13cmos5l_dlygate4sd3_1
Xclkbuf_regs_0_clk clkbuf_regs_0_clk/X clk vddd vssd sg13cmos5l_buf_8
Xtiedowns\[13\] dig_out_relay[1] vddd vssd sg13cmos5l_antennanp
XFILLER_10_95 vddd vssd sg13cmos5l_decap_8
Xdig_in_gen\[22\].dig_in_latch userbuffers\[22\]/A dig_in[22] fanout9/X fanout8/X
+ vddd vssd sg13cmos5l_dlhrq_1
X_40_ _40_/X proj_dig_out[1] dig_out_relay[1] _50_/S vddd vssd sg13cmos5l_mux2_1
Xdig_in_gen\[15\].dig_in_latch userbuffers\[15\]/A dig_in[15] fanout9/X fanout5/X
+ vddd vssd sg13cmos5l_dlhrq_1
Xtiedowns\[43\] dig_in[19] vddd vssd sg13cmos5l_antennanp
XFILLER_13_84 vddd vssd sg13cmos5l_decap_8
XFILLER_8_0 vddd vssd sg13cmos5l_decap_8
X_23_ _38_/B proj_addr[0] proj_sel[0] vddd vssd sg13cmos5l_xor2_1
XFILLER_10_74 vddd vssd sg13cmos5l_decap_8
XFILLER_7_75 vddd vssd sg13cmos5l_decap_8
Xuserbuffers\[6\] proj_dig_in[6] userbuffers\[6\]/A vddd vssd sg13cmos5l_buf_8
Xuserbuffers\[24\] proj_reset _52_/Q vddd vssd sg13cmos5l_buf_8
XFILLER_8_114 vddd vssd sg13cmos5l_decap_8
XFILLER_7_191 vddd vssd sg13cmos5l_decap_8
Xoutbuffers\[0\] dig_out[0] _39_/X vddd vssd sg13cmos5l_buf_4
XFILLER_4_43 vddd vssd sg13cmos5l_decap_8
XFILLER_13_63 vddd vssd sg13cmos5l_decap_8
Xtiedowns\[36\] dig_in[12] vddd vssd sg13cmos5l_antennanp
X_22_ _24_/D proj_sel[2] proj_addr[2] vddd vssd sg13cmos5l_nand2b_1
XFILLER_10_53 vddd vssd sg13cmos5l_decap_8
Xdig_in_gen\[8\].dig_in_latch userbuffers\[8\]/A dig_in[8] _14_/A fanout6/X vddd vssd
+ sg13cmos5l_dlhrq_1
Xtiedowns\[2\] proj_dig_out[2] vddd vssd sg13cmos5l_antennanp
Xtiedowns\[66\] proj_addr[0] vddd vssd sg13cmos5l_antennanp
Xuserbuffers\[17\] proj_dig_in[17] userbuffers\[17\]/A vddd vssd sg13cmos5l_buf_8
Xfanout10 fanout10/X fanout9/A vddd vssd sg13cmos5l_buf_1
XFILLER_13_42 vddd vssd sg13cmos5l_decap_8
Xtiedowns\[29\] dig_in[5] vddd vssd sg13cmos5l_antennanp
X_21_ _25_/D proj_addr[4] proj_sel[4] vddd vssd sg13cmos5l_nand2b_1
Xdig_in_gen\[11\].dig_in_latch userbuffers\[11\]/A dig_in[11] _14_/A fanout5/X vddd
+ vssd sg13cmos5l_dlhrq_1
Xswitchbuffers\[7\] proj_1v2_ena _31_/X vddd vssd sg13cmos5l_buf_4
Xtiedowns\[11\] proj_dig_out[11] vddd vssd sg13cmos5l_antennanp
Xtiedowns\[59\] fanout9/X vddd vssd sg13cmos5l_antennanp
XFILLER_5_119 vddd vssd sg13cmos5l_decap_8
Xfanout11 _14_/A fanout9/A vddd vssd sg13cmos5l_buf_1
XFILLER_13_98 vddd vssd sg13cmos5l_decap_8
XFILLER_13_21 vddd vssd sg13cmos5l_decap_8
XFILLER_6_0 vddd vssd sg13cmos5l_decap_8
X_20_ _24_/C proj_sel[4] proj_addr[4] vddd vssd sg13cmos5l_nand2b_1
Xtiedowns\[41\] dig_in[17] vddd vssd sg13cmos5l_antennanp
XFILLER_10_88 vddd vssd sg13cmos5l_decap_8
XFILLER_12_157 vddd vssd sg13cmos5l_decap_4
XFILLER_8_128 vddd vssd sg13cmos5l_decap_8
Xdig_in_gen\[4\].dig_in_latch userbuffers\[4\]/A dig_in[4] fanout12/X fanout7/X vddd
+ vssd sg13cmos5l_dlhrq_1
Xuserbuffers\[4\] proj_dig_in[4] userbuffers\[4\]/A vddd vssd sg13cmos5l_buf_8
Xuserbuffers\[22\] proj_dig_in[22] userbuffers\[22\]/A vddd vssd sg13cmos5l_buf_8
Xfanout12 fanout12/X fanout9/A vddd vssd sg13cmos5l_buf_1
XFILLER_13_77 vddd vssd sg13cmos5l_decap_8
Xtiedowns\[34\] dig_in[10] vddd vssd sg13cmos5l_antennanp
XFILLER_10_67 vddd vssd sg13cmos5l_decap_8
Xclockgate clockgate/GCLK clockgate/CLK _36_/B vddd vssd sg13cmos5l_lgcp_1
Xoutbuffers\[9\] dig_out[9] _48_/X vddd vssd sg13cmos5l_buf_4
Xtiedowns\[0\] proj_dig_out[0] vddd vssd sg13cmos5l_antennanp
Xtiedowns\[64\] proj_sel[3] vddd vssd sg13cmos5l_antennanp
XFILLER_4_198 vddd vssd sg13cmos5l_decap_8
XFILLER_4_110 vddd vssd sg13cmos5l_decap_8
Xuserbuffers\[15\] proj_dig_in[15] userbuffers\[15\]/A vddd vssd sg13cmos5l_buf_8
Xfanout13 fanout9/A dig_ena vddd vssd sg13cmos5l_buf_1
XFILLER_13_56 vddd vssd sg13cmos5l_decap_8
Xtiedowns\[27\] dig_in[3] vddd vssd sg13cmos5l_antennanp
Xoutbuffers\[10\] dig_out[10] _49_/X vddd vssd sg13cmos5l_buf_4
XFILLER_10_46 vddd vssd sg13cmos5l_decap_8
Xswitchbuffers\[5\] proj_analog_ena[2] _29_/X vddd vssd sg13cmos5l_buf_4
Xdig_in_gen\[0\].dig_in_latch userbuffers\[0\]/A dig_in[0] _14_/A fanout6/X vddd vssd
+ sg13cmos5l_dlhrq_1
Xtiedowns\[57\] reset vddd vssd sg13cmos5l_antennanp
XFILLER_13_35 vddd vssd sg13cmos5l_decap_8
XFILLER_4_0 vddd vssd sg13cmos5l_decap_8
XFILLER_7_131 vddd vssd sg13cmos5l_decap_8
XFILLER_4_178 vddd vssd sg13cmos5l_decap_4
XFILLER_13_14 vddd vssd sg13cmos5l_decap_8
Xuserbuffers\[2\] proj_dig_in[2] userbuffers\[2\]/A vddd vssd sg13cmos5l_buf_8
XFILLER_8_7 vddd vssd sg13cmos5l_decap_8
Xuserbuffers\[20\] proj_dig_in[20] userbuffers\[20\]/A vddd vssd sg13cmos5l_buf_8
Xdig_in_gen\[18\].dig_in_latch userbuffers\[18\]/A dig_in[18] fanout10/X fanout5/X
+ vddd vssd sg13cmos5l_dlhrq_1
Xtiedowns\[32\] dig_in[8] vddd vssd sg13cmos5l_antennanp
XFILLER_12_106 vddd vssd sg13cmos5l_decap_4
XFILLER_7_198 vddd vssd sg13cmos5l_decap_8
XFILLER_7_110 vddd vssd sg13cmos5l_decap_8
Xoutbuffers\[7\] dig_out[7] _46_/X vddd vssd sg13cmos5l_buf_4
XFILLER_12_0 vddd vssd sg13cmos5l_decap_8
Xtiedowns\[62\] proj_sel[1] vddd vssd sg13cmos5l_antennanp
Xuserbuffers\[13\] proj_dig_in[13] userbuffers\[13\]/A vddd vssd sg13cmos5l_buf_8
XFILLER_0_193 vddd vssd sg13cmos5l_decap_8
Xtiedowns\[25\] dig_in[1] vddd vssd sg13cmos5l_antennanp
XFILLER_2_94 vddd vssd sg13cmos5l_decap_8
Xtiedowns\[9\] proj_dig_out[9] vddd vssd sg13cmos5l_antennanp
Xswitchbuffers\[3\] proj_analog_ena[0] _27_/X vddd vssd sg13cmos5l_buf_4
XFILLER_11_92 vddd vssd sg13cmos5l_decap_8
XFILLER_11_195 vddd vssd sg13cmos5l_decap_8
XFILLER_11_162 vddd vssd sg13cmos5l_decap_8
XFILLER_8_71 vddd vssd sg13cmos5l_decap_4
XFILLER_4_29 vddd vssd sg13cmos5l_decap_4
XFILLER_4_103 vddd vssd sg13cmos5l_decap_8
XFILLER_3_191 vddd vssd sg13cmos5l_decap_8
XFILLER_13_49 vddd vssd sg13cmos5l_decap_8
Xdig_in_gen\[21\].dig_in_latch userbuffers\[21\]/A dig_in[21] fanout9/X _36_/B vddd
+ vssd sg13cmos5l_dlhrq_1
Xtiedowns\[55\] analog_ena[2] vddd vssd sg13cmos5l_antennanp
XFILLER_10_39 vddd vssd sg13cmos5l_decap_8
Xtiedowns\[18\] dig_out_relay[6] vddd vssd sg13cmos5l_antennanp
Xdig_in_gen\[14\].dig_in_latch userbuffers\[14\]/A dig_in[14] fanout9/X fanout5/X
+ vddd vssd sg13cmos5l_dlhrq_1
XFILLER_11_71 vddd vssd sg13cmos5l_decap_8
XFILLER_2_0 vddd vssd sg13cmos5l_decap_8
XFILLER_11_141 vddd vssd sg13cmos5l_decap_8
XFILLER_8_50 vddd vssd sg13cmos5l_decap_8
XFILLER_13_28 vddd vssd sg13cmos5l_decap_8
Xtiedowns\[48\] power_1v2_ena vddd vssd sg13cmos5l_antennanp
Xuserbuffers\[0\] proj_dig_in[0] userbuffers\[0\]/A vddd vssd sg13cmos5l_buf_8
Xtiedowns\[30\] dig_in[6] vddd vssd sg13cmos5l_antennanp
XFILLER_11_50 vddd vssd sg13cmos5l_decap_8
X_39_ _39_/X proj_dig_out[0] dig_out_relay[0] _50_/S vddd vssd sg13cmos5l_mux2_1
Xclkbuf_1_0__f_clk clkload0/A clkbuf_0_clk/X vddd vssd sg13cmos5l_buf_8
XFILLER_7_179 vddd vssd sg13cmos5l_decap_4
XFILLER_7_124 vddd vssd sg13cmos5l_decap_8
Xoutbuffers\[5\] dig_out[5] _44_/X vddd vssd sg13cmos5l_buf_4
Xdig_in_gen\[7\].dig_in_latch userbuffers\[7\]/A dig_in[7] _14_/A fanout6/X vddd vssd
+ sg13cmos5l_dlhrq_1
XFILLER_10_0 vddd vssd sg13cmos5l_decap_8
Xtiedowns\[60\] clkload0/A vddd vssd sg13cmos5l_antennanp
Xuserbuffers\[11\] proj_dig_in[11] userbuffers\[11\]/A vddd vssd sg13cmos5l_buf_8
Xtiedowns\[23\] dig_out_relay[11] vddd vssd sg13cmos5l_antennanp
X_38_ _38_/X _38_/A _38_/B _38_/C _38_/D vddd vssd sg13cmos5l_or4_1
Xtiedowns\[7\] proj_dig_out[7] vddd vssd sg13cmos5l_antennanp
Xdig_in_gen\[10\].dig_in_latch userbuffers\[10\]/A dig_in[10] _14_/A fanout5/X vddd
+ vssd sg13cmos5l_dlhrq_1
XFILLER_7_103 vddd vssd sg13cmos5l_decap_8
Xswitchbuffers\[1\] proj_ibias_ena[0] _36_/X vddd vssd sg13cmos5l_buf_4
XFILLER_4_117 vddd vssd sg13cmos5l_decap_8
XFILLER_5_64 vddd vssd sg13cmos5l_decap_4
XFILLER_0_186 vddd vssd sg13cmos5l_decap_8
XFILLER_0_142 vddd vssd sg13cmos5l_decap_8
Xtiedowns\[53\] analog_ena[0] vddd vssd sg13cmos5l_antennanp
XFILLER_2_65 vddd vssd sg13cmos5l_decap_8
Xtiedowns\[16\] dig_out_relay[4] vddd vssd sg13cmos5l_antennanp
XFILLER_11_85 vddd vssd sg13cmos5l_decap_8
X_37_ _37_/X ibias_ena[1] _37_/B vddd vssd sg13cmos5l_and2_1
XFILLER_0_0 vddd vssd sg13cmos5l_decap_8
XFILLER_11_155 vddd vssd sg13cmos5l_decap_8
XFILLER_8_64 vddd vssd sg13cmos5l_decap_8
XFILLER_6_192 vddd vssd sg13cmos5l_decap_8
XFILLER_0_121 vddd vssd sg13cmos5l_decap_8
Xdig_in_gen\[3\].dig_in_latch userbuffers\[3\]/A dig_in[3] fanout12/X fanout6/X vddd
+ vssd sg13cmos5l_dlhrq_1
Xtiedowns\[46\] dig_in[22] vddd vssd sg13cmos5l_antennanp
XFILLER_4_7 vddd vssd sg13cmos5l_decap_8
XFILLER_11_64 vddd vssd sg13cmos5l_decap_8
X_36_ _36_/X ibias_ena[0] _36_/B vddd vssd sg13cmos5l_and2_1
XFILLER_7_138 vddd vssd sg13cmos5l_decap_4
XFILLER_11_134 vddd vssd sg13cmos5l_decap_8
XFILLER_8_43 vddd vssd sg13cmos5l_decap_8
X_19_ _25_/C proj_sel[3] proj_addr[3] vddd vssd sg13cmos5l_nand2b_1
Xuserbuffers\[9\] proj_dig_in[9] userbuffers\[9\]/A vddd vssd sg13cmos5l_buf_8
XFILLER_8_200 vddd vssd sg13cmos5l_decap_4
Xoutbuffers\[3\] dig_out[3] _42_/X vddd vssd sg13cmos5l_buf_4
Xtiedowns\[39\] dig_in[15] vddd vssd sg13cmos5l_antennanp
Xclkbuf_0_clk_regs clkbuf_0_clk_regs/X clkbuf_regs_0_clk/X vddd vssd sg13cmos5l_buf_8
X_52_ _52_/Q _52_/CLK _52_/D enable vddd vssd sg13cmos5l_dfrbpq_1
XFILLER_11_43 vddd vssd sg13cmos5l_decap_8
X_35_ _35_/X vbias_ena _36_/B vddd vssd sg13cmos5l_and2_1
XFILLER_9_191 vddd vssd sg13cmos5l_decap_8
XFILLER_7_117 vddd vssd sg13cmos5l_decap_8
Xtiedowns\[21\] dig_out_relay[9] vddd vssd sg13cmos5l_antennanp
X_18_ _25_/B proj_addr[1] proj_sel[1] vddd vssd sg13cmos5l_nand2b_1
Xtiedowns\[5\] proj_dig_out[5] vddd vssd sg13cmos5l_antennanp
Xtiedowns\[69\] proj_addr[3] vddd vssd sg13cmos5l_antennanp
XFILLER_12_7 vddd vssd sg13cmos5l_decap_8
XFILLER_5_34 vddd vssd sg13cmos5l_decap_4
Xtiedowns\[51\] ibias_ena[0] vddd vssd sg13cmos5l_antennanp
X_51_ _51_/Q _51_/CLK _51_/D enable vddd vssd sg13cmos5l_dfrbpq_1
XFILLER_11_99 vddd vssd sg13cmos5l_decap_8
X_34_ _51_/D reset _37_/B vddd vssd sg13cmos5l_and2_1
Xtiedowns\[14\] dig_out_relay[2] vddd vssd sg13cmos5l_antennanp
X_17_ _25_/A proj_addr[2] proj_sel[2] vddd vssd sg13cmos5l_nand2b_1
XFILLER_10_191 vddd vssd sg13cmos5l_decap_8
XFILLER_3_198 vddd vssd sg13cmos5l_decap_8
XFILLER_0_135 vddd vssd sg13cmos5l_decap_8
XFILLER_0_102 vddd vssd sg13cmos5l_decap_8
X_50_ _50_/X proj_dig_out[11] dig_out_relay[11] _50_/S vddd vssd sg13cmos5l_mux2_1
Xtiedowns\[44\] dig_in[20] vddd vssd sg13cmos5l_antennanp
XFILLER_9_0 vddd vssd sg13cmos5l_decap_8
XFILLER_2_58 vddd vssd sg13cmos5l_decap_8
XFILLER_11_78 vddd vssd sg13cmos5l_decap_8
XFILLER_2_7 vddd vssd sg13cmos5l_decap_8
X_33_ _33_/X enable _36_/B vddd vssd sg13cmos5l_and2_1
XFILLER_11_148 vddd vssd sg13cmos5l_decap_8
X_16_ _24_/B proj_sel[1] proj_addr[1] vddd vssd sg13cmos5l_nand2b_1
XFILLER_8_57 vddd vssd sg13cmos5l_decap_8
XFILLER_6_185 vddd vssd sg13cmos5l_decap_8
Xdig_in_gen\[17\].dig_in_latch userbuffers\[17\]/A dig_in[17] fanout10/X fanout5/X
+ vddd vssd sg13cmos5l_dlhrq_1
XFILLER_3_177 vddd vssd sg13cmos5l_decap_4
XFILLER_3_100 vddd vssd sg13cmos5l_decap_8
Xclkbuf_1_1__f_clk clockgate/CLK clkbuf_0_clk/X vddd vssd sg13cmos5l_buf_8
Xuserbuffers\[7\] proj_dig_in[7] userbuffers\[7\]/A vddd vssd sg13cmos5l_buf_8
XFILLER_0_114 vddd vssd sg13cmos5l_decap_8
Xuserbuffers\[25\] proj_ena _33_/X vddd vssd sg13cmos5l_buf_8
Xoutbuffers\[1\] dig_out[1] _40_/X vddd vssd sg13cmos5l_buf_4
Xtiedowns\[37\] dig_in[13] vddd vssd sg13cmos5l_antennanp
XFILLER_11_57 vddd vssd sg13cmos5l_decap_8
X_32_ _32_/X power_3v3_ena _37_/B vddd vssd sg13cmos5l_and2_1
X_15_ _24_/A proj_addr[3] proj_sel[3] vddd vssd sg13cmos5l_nand2b_1
Xtiedowns\[3\] proj_dig_out[3] vddd vssd sg13cmos5l_antennanp
Xtiedowns\[67\] proj_addr[1] vddd vssd sg13cmos5l_antennanp
XFILLER_10_7 vddd vssd sg13cmos5l_decap_4
Xuserbuffers\[18\] proj_dig_in[18] userbuffers\[18\]/A vddd vssd sg13cmos5l_buf_8
XFILLER_6_80 vddd vssd sg13cmos5l_decap_4
XFILLER_11_25 vddd vssd sg13cmos5l_decap_8
X_31_ _31_/X power_1v2_ena _37_/B vddd vssd sg13cmos5l_and2_1
Xdig_in_gen\[20\].dig_in_latch userbuffers\[20\]/A dig_in[20] fanout9/X _36_/B vddd
+ vssd sg13cmos5l_dlhrq_1
Xswitchbuffers\[8\] proj_3v3_ena _32_/X vddd vssd sg13cmos5l_buf_4
X_14_ _38_/A _14_/A vddd vssd sg13cmos5l_inv_1
Xtiedowns\[12\] dig_out_relay[0] vddd vssd sg13cmos5l_antennanp
XFILLER_0_60 vddd vssd sg13cmos5l_decap_8
Xdig_in_gen\[13\].dig_in_latch userbuffers\[13\]/A dig_in[13] fanout9/X fanout5/X
+ vddd vssd sg13cmos5l_dlhrq_1
X_30_ _30_/X analog_ena[3] _37_/B vddd vssd sg13cmos5l_and2_1
Xtiedowns\[42\] dig_in[18] vddd vssd sg13cmos5l_antennanp
XFILLER_7_0 vddd vssd sg13cmos5l_decap_4
XFILLER_0_7 vddd vssd sg13cmos5l_decap_8
XFILLER_6_199 vddd vssd sg13cmos5l_decap_4
XFILLER_10_151 vddd vssd sg13cmos5l_decap_8
XFILLER_2_191 vddd vssd sg13cmos5l_decap_8
XFILLER_0_128 vddd vssd sg13cmos5l_decap_8
Xuserbuffers\[5\] proj_dig_in[5] userbuffers\[5\]/A vddd vssd sg13cmos5l_buf_8
Xuserbuffers\[23\] proj_dig_in[23] userbuffers\[23\]/A vddd vssd sg13cmos5l_buf_8
XFILLER_1_201 vddd vssd sg13cmos5l_decap_4
Xdig_in_gen\[6\].dig_in_latch userbuffers\[6\]/A dig_in[6] fanout12/X fanout7/X vddd
+ vssd sg13cmos5l_dlhrq_1
Xtiedowns\[35\] dig_in[11] vddd vssd sg13cmos5l_antennanp
XFILLER_10_130 vddd vssd sg13cmos5l_decap_8
XFILLER_12_70 vddd vssd sg13cmos5l_decap_8
XFILLER_6_178 vddd vssd sg13cmos5l_decap_8
XFILLER_6_123 vddd vssd sg13cmos5l_decap_8
XFILLER_0_95 vddd vssd sg13cmos5l_decap_8
Xfanout1 _50_/S _38_/X vddd vssd sg13cmos5l_buf_1
Xtiedowns\[1\] proj_dig_out[1] vddd vssd sg13cmos5l_antennanp
Xclkbuf_1_1__f_clk_regs _52_/CLK clkbuf_0_clk_regs/X vddd vssd sg13cmos5l_buf_8
Xtiedowns\[65\] proj_sel[4] vddd vssd sg13cmos5l_antennanp
Xuserbuffers\[16\] proj_dig_in[16] userbuffers\[16\]/A vddd vssd sg13cmos5l_buf_8
Xtiedowns\[28\] dig_in[4] vddd vssd sg13cmos5l_antennanp
XFILLER_13_161 vddd vssd sg13cmos5l_decap_4
XFILLER_9_198 vddd vssd sg13cmos5l_decap_8
XFILLER_9_110 vddd vssd sg13cmos5l_decap_8
Xoutbuffers\[11\] dig_out[11] _50_/X vddd vssd sg13cmos5l_buf_4
XFILLER_8_29 vddd vssd sg13cmos5l_decap_4
Xswitchbuffers\[6\] proj_analog_ena[3] _30_/X vddd vssd sg13cmos5l_buf_4
XFILLER_0_74 vddd vssd sg13cmos5l_decap_8
Xclkbuf_1_0__f_clk_regs _51_/CLK clkbuf_0_clk_regs/X vddd vssd sg13cmos5l_buf_8
Xtiedowns\[10\] proj_dig_out[10] vddd vssd sg13cmos5l_antennanp
Xfanout2 _44_/S _38_/X vddd vssd sg13cmos5l_buf_1
Xtiedowns\[58\] enable vddd vssd sg13cmos5l_antennanp
XFILLER_13_195 vddd vssd sg13cmos5l_decap_8
XFILLER_13_140 vddd vssd sg13cmos5l_decap_8
Xdig_in_gen\[2\].dig_in_latch userbuffers\[2\]/A dig_in[2] fanout12/X fanout6/X vddd
+ vssd sg13cmos5l_dlhrq_1
Xtiedowns\[40\] dig_in[16] vddd vssd sg13cmos5l_antennanp
XFILLER_10_198 vddd vssd sg13cmos5l_decap_8
XFILLER_5_0 vddd vssd sg13cmos5l_decap_8
XFILLER_5_191 vddd vssd sg13cmos5l_decap_8
XFILLER_0_53 vddd vssd sg13cmos5l_decap_8
Xfanout3 _37_/B _36_/B vddd vssd sg13cmos5l_buf_1
Xuserbuffers\[3\] proj_dig_in[3] userbuffers\[3\]/A vddd vssd sg13cmos5l_buf_8
XFILLER_9_7 vddd vssd sg13cmos5l_decap_8
Xtiedowns\[70\] proj_addr[4] vddd vssd sg13cmos5l_antennanp
Xuserbuffers\[21\] proj_dig_in[21] userbuffers\[21\]/A vddd vssd sg13cmos5l_buf_8
Xtiedowns\[33\] dig_in[9] vddd vssd sg13cmos5l_antennanp
XFILLER_10_144 vddd vssd sg13cmos5l_decap_8
XFILLER_3_107 vddd vssd sg13cmos5l_decap_8
Xfanout4 _36_/B fanout8/X vddd vssd sg13cmos5l_buf_1
Xoutbuffers\[8\] dig_out[8] _47_/X vddd vssd sg13cmos5l_buf_4
XFILLER_13_0 vddd vssd sg13cmos5l_decap_8
Xtiedowns\[63\] proj_sel[2] vddd vssd sg13cmos5l_antennanp
Xuserbuffers\[14\] proj_dig_in[14] userbuffers\[14\]/A vddd vssd sg13cmos5l_buf_8
XFILLER_9_157 vddd vssd sg13cmos5l_decap_8
XFILLER_9_124 vddd vssd sg13cmos5l_decap_8
XFILLER_12_63 vddd vssd sg13cmos5l_decap_8
XFILLER_10_123 vddd vssd sg13cmos5l_decap_8
XFILLER_6_116 vddd vssd sg13cmos5l_decap_8
Xtiedowns\[26\] dig_in[2] vddd vssd sg13cmos5l_antennanp
Xswitchbuffers\[4\] proj_analog_ena[1] _28_/X vddd vssd sg13cmos5l_buf_4
XFILLER_9_53 vddd vssd sg13cmos5l_decap_8
Xfanout5 fanout5/X fanout7/X vddd vssd sg13cmos5l_buf_1
Xtiedowns\[56\] analog_ena[3] vddd vssd sg13cmos5l_antennanp
XFILLER_13_154 vddd vssd sg13cmos5l_decap_8
XFILLER_10_102 vddd vssd sg13cmos5l_decap_8
Xtiedowns\[19\] dig_out_relay[7] vddd vssd sg13cmos5l_antennanp
Xdig_in_gen\[23\].dig_in_latch userbuffers\[23\]/A dig_in[23] fanout9/X fanout8/X
+ vddd vssd sg13cmos5l_dlhrq_1
XFILLER_3_0 vddd vssd sg13cmos5l_decap_4
XFILLER_9_76 vddd vssd sg13cmos5l_decap_8
XFILLER_0_67 vddd vssd sg13cmos5l_decap_8
Xfanout6 fanout6/X fanout7/X vddd vssd sg13cmos5l_buf_1
Xdig_in_gen\[16\].dig_in_latch userbuffers\[16\]/A dig_in[16] fanout10/X fanout7/X
+ vddd vssd sg13cmos5l_dlhrq_1
Xtiedowns\[49\] power_3v3_ena vddd vssd sg13cmos5l_antennanp
.ends

.subckt project_control_area dig_in[20] user_project_control_0/proj_analog_ena[3]
+ user_project_control_0/proj_analog_ena[2] dig_out[7] user_project_control_0/proj_sel[2]
+ user_project_control_0/dig_out_relay[0] dig_in[2] dig_in[21] user_project_control_0/dig_in[22]
+ dig_out[8] user_project_control_0/proj_sel[1] dig_in[3] dig_in[22] dig_out[9] user_project_control_0/analog_ena[2]
+ analog_bus3 dig_in[4] user_project_control_0/proj_analog_ena[1] dig_in[23] user_project_control_0/dig_out[3]
+ user_project_control_0/dig_out[11] user_project_control_0/dig_out[4] analog_bus2
+ dig_in[5] user_project_control_0/analog_ena[1] analog_bus1 user_project_control_0/dig_in[5]
+ dig_in[6] user_project_control_0/dig_in[21] user_project_control_0/dig_in[9] user_project_control_0/dig_out[8]
+ analog_bus0 user_project_control_0/dig_out[9] dig_in[7] user_project_control_0/dig_out_relay[11]
+ dig_in[8] user_project_control_0/proj_ibias_ena[0] user_project_control_0/proj_sel[0]
+ user_project_control_0/dig_in[1] dig_in[9] user_project_control_0/dig_in[17] user_project_control_0/dig_in[2]
+ user_project_control_0/proj_addr[0] dig_out[10] user_project_control_0/dig_ena dig_out[11]
+ user_project_control_0/dig_in[10] user_project_control_0/proj_addr[1] user_project_control_0/proj_addr[3]
+ user_project_control_0/dig_out[5] user_project_control_0/ibias_ena[1] user_project_control_0/dig_in[23]
+ ibias1 user_project_control_0/dig_out[10] vdd_3v3 user_project_control_0/dig_in[6]
+ ibias0 dig_in[10] user_project_control_0/dig_out_relay[2] user_project_control_0/vbias_ena
+ dig_in[11] m2_207925_559863# enable user_project_control_0/dig_out_relay[1] user_project_control_0/dig_out_relay[3]
+ dig_in[12] dig_in[13] user_project_control_0/power_3v3_ena user_project_control_0/dig_out_relay[4]
+ vbias dig_in[14] user_project_control_0/analog_ena[3] user_project_control_0/ibias_ena[0]
+ user_project_control_0/dig_out_relay[5] dig_in[15] user_project_control_0/dig_in[20]
+ power_stage2_0/DVDD user_project_control_0/dig_in[19] dig_in[16] user_project_control_0/dig_out_relay[6]
+ user_project_control_0/proj_sel[4] user_project_control_0/dig_out[6] power_stage2_0/DVSS
+ user_project_control_0/reset user_project_control_0/dig_in[12] dig_in[17] user_project_control_0/analog_ena[0]
+ user_project_control_0/power_1v2_ena dig_in[18] user_project_control_0/enable dig_in[19]
+ DVDD user_project_control_0/dig_out_relay[9] AVDD user_project_control_0/dig_in[14]
+ user_project_control_0/proj_ibias_ena[1] user_project_control_0/dig_out_relay[10]
+ user_project_control_0/dig_in[16] user_project_control_0/dig_in[18] dig_out[0] user_project_control_0/clk
+ reset dig_out[1] user_project_control_0/dig_out[2] user_project_control_0/dig_in[0]
+ dig_out[2] user_project_control_0/dig_out[7] user_project_control_0/dig_out[0] clk
+ user_project_control_0/dig_out[1] user_project_control_0/dig_in[7] dig_out[3] user_project_control_0/dig_in[8]
+ user_project_control_0/dig_in[11] user_project_control_0/dig_out_relay[7] dig_out[4]
+ user_project_control_0/dig_in[3] user_project_control_0/proj_vbias_ena user_project_control_0/proj_sel[3]
+ dig_out[5] user_project_control_0/dig_out_relay[8] user_project_control_0/dig_in[4]
+ dig_in[0] user_project_control_0/dig_in[15] user_project_control_0/proj_addr[4]
+ user_project_control_0/proj_analog_ena[0] user_project_control_0/dig_in[13] dig_out[6]
+ AVSS vdd_1v2 user_project_control_0/proj_addr[2] DVSS dig_in[1]
Xpower_stage2_0 AVDD power_stage2_0/enable AVSS vdd_3v3 power_stage2_0/DVSS power_stage2_0/DVDD
+ power_stage2
Xpower_stage1v2_0 power_stage1v2_0/enable vdd_1v2 DVDD DVSS power_stage1v2
Xuser_project_control_0 user_project_control_0/analog_ena[0] user_project_control_0/analog_ena[1]
+ user_project_control_0/analog_ena[2] user_project_control_0/analog_ena[3] user_project_control_0/clk
+ user_project_control_0/dig_ena user_project_control_0/dig_in[0] user_project_control_0/dig_in[10]
+ user_project_control_0/dig_in[11] user_project_control_0/dig_in[12] user_project_control_0/dig_in[13]
+ user_project_control_0/dig_in[14] user_project_control_0/dig_in[15] user_project_control_0/dig_in[16]
+ user_project_control_0/dig_in[17] user_project_control_0/dig_in[18] user_project_control_0/dig_in[19]
+ user_project_control_0/dig_in[1] user_project_control_0/dig_in[20] user_project_control_0/dig_in[21]
+ user_project_control_0/dig_in[22] user_project_control_0/dig_in[23] user_project_control_0/dig_in[2]
+ user_project_control_0/dig_in[3] user_project_control_0/dig_in[4] user_project_control_0/dig_in[5]
+ user_project_control_0/dig_in[6] user_project_control_0/dig_in[7] user_project_control_0/dig_in[8]
+ user_project_control_0/dig_in[9] user_project_control_0/dig_out[0] user_project_control_0/dig_out[10]
+ user_project_control_0/dig_out[11] user_project_control_0/dig_out[1] user_project_control_0/dig_out[2]
+ user_project_control_0/dig_out[3] user_project_control_0/dig_out[4] user_project_control_0/dig_out[5]
+ user_project_control_0/dig_out[6] user_project_control_0/dig_out[7] user_project_control_0/dig_out[8]
+ user_project_control_0/dig_out[9] user_project_control_0/dig_out_relay[0] user_project_control_0/dig_out_relay[10]
+ user_project_control_0/dig_out_relay[11] user_project_control_0/dig_out_relay[1]
+ user_project_control_0/dig_out_relay[2] user_project_control_0/dig_out_relay[3]
+ user_project_control_0/dig_out_relay[4] user_project_control_0/dig_out_relay[5]
+ user_project_control_0/dig_out_relay[6] user_project_control_0/dig_out_relay[7]
+ user_project_control_0/dig_out_relay[8] user_project_control_0/dig_out_relay[9]
+ user_project_control_0/enable user_project_control_0/ibias_ena[0] user_project_control_0/ibias_ena[1]
+ user_project_control_0/power_1v2_ena user_project_control_0/power_3v3_ena power_stage1v2_0/enable
+ power_stage2_0/enable user_project_control_0/proj_addr[0] user_project_control_0/proj_addr[1]
+ user_project_control_0/proj_addr[2] user_project_control_0/proj_addr[3] user_project_control_0/proj_addr[4]
+ user_project_control_0/proj_analog_ena[0] user_project_control_0/proj_analog_ena[1]
+ user_project_control_0/proj_analog_ena[2] user_project_control_0/proj_analog_ena[3]
+ clk dig_in[0] dig_in[10] dig_in[11] dig_in[12] dig_in[13] dig_in[14] dig_in[15]
+ dig_in[16] dig_in[17] dig_in[18] dig_in[19] dig_in[1] dig_in[20] dig_in[21] dig_in[22]
+ dig_in[23] dig_in[2] dig_in[3] dig_in[4] dig_in[5] dig_in[6] dig_in[7] dig_in[8]
+ dig_in[9] dig_out[0] dig_out[10] dig_out[11] dig_out[1] dig_out[2] dig_out[3] dig_out[4]
+ dig_out[5] dig_out[6] dig_out[7] dig_out[8] dig_out[9] enable user_project_control_0/proj_ibias_ena[0]
+ user_project_control_0/proj_ibias_ena[1] reset user_project_control_0/proj_sel[0]
+ user_project_control_0/proj_sel[1] user_project_control_0/proj_sel[2] user_project_control_0/proj_sel[3]
+ user_project_control_0/proj_sel[4] user_project_control_0/proj_vbias_ena user_project_control_0/reset
+ user_project_control_0/vbias_ena DVDD DVSS user_project_control
.ends

* Black-box entry subcircuit for slot3_wrapper abstract view
.subckt slot3_wrapper vss_3v3 s3_an[0] s3_an[1] s3_an_0_esd vbias dig_in[23] dig_in[22]
+ dig_in[21] dig_in[20] dig_in[19] dig_in[18] dig_in[17] dig_in[16] dig_in[15] dig_in[14]
+ dig_in[13] dig_in[12] dig_in[11] dig_in[10] dig_in[9] dig_in[8] dig_in[7] dig_in[6]
+ dig_in[5] dig_in[4] dig_in[3] dig_in[2] dig_in[1] dig_in[0] dig_out[11] dig_out[10]
+ dig_out[9] dig_out[8] dig_out[7] dig_out[6] dig_out[5] dig_out[4] dig_out[3] dig_out[2]
+ dig_out[1] dig_out[0] ibias0 ibias1 analog_bus3 analog_bus2 analog_bus1 analog_bus0
+ vss_1v2 vdd_1v2 vdd_3v3 enable clk reset
.ends

.subckt rhigh_MGZFWD B R1_0 R2_0 R1_1 R2_1 R1_2 R2_2 R1_3 R2_3 R1_4 R2_4 R1_5 R2_5
+ R1_6 R2_6 R1_7 R2_7 R1_8 R2_8 R1_9 R2_9 R1_10 R2_10 R1_11 R2_11 R1_12 R2_12 R1_13
+ R2_13 R1_14 R2_14 R1_15 R2_15 R1_16 R2_16 R1_17 R2_17 R1_18 R2_18 R1_19 R2_19 R1_20
+ R2_20 R1_21 R2_21 R1_22 R2_22 R1_23 R2_23 R1_24 R2_24 R1_25 R2_25 R1_26 R2_26 R1_27
+ R2_27 R1_28 R2_28 R1_29 R2_29 R1_30 R2_30 R1_31 R2_31 R1_32 R2_32 R1_33 R2_33 R1_34
+ R2_34 R1_35 R2_35 R1_36 R2_36 R1_37 R2_37 R1_38 R2_38 R1_39 R2_39 R1_40 R2_40 R1_41
+ R2_41 R1_42 R2_42 R1_43 R2_43 R1_44 R2_44 R1_45 R2_45 R1_46 R2_46 R1_47 R2_47 R1_48
+ R2_48 R1_49 R2_49 R1_50 R2_50 R1_51 R2_51 R1_52 R2_52 R1_53 R2_53
X0 R1_28 R2_28 B rhigh l=16.82u w=0.5u
X1 R1_44 R2_44 B rhigh l=16.82u w=0.5u
X2 R1_52 R2_52 B rhigh l=16.82u w=0.5u
X3 R1_18 R2_18 B rhigh l=16.82u w=0.5u
X4 R1_19 R2_19 B rhigh l=16.82u w=0.5u
X5 R1_29 R2_29 B rhigh l=16.82u w=0.5u
X6 R1_4 R2_4 B rhigh l=16.82u w=0.5u
X7 R1_17 R2_17 B rhigh l=16.82u w=0.5u
X8 R1_42 R2_42 B rhigh l=16.82u w=0.5u
X9 R1_2 R2_2 B rhigh l=16.82u w=0.5u
X10 R1_3 R2_3 B rhigh l=16.82u w=0.5u
X11 R1_13 R2_13 B rhigh l=16.82u w=0.5u
X12 R1_14 R2_14 B rhigh l=16.82u w=0.5u
X13 R1_12 R2_12 B rhigh l=16.82u w=0.5u
X14 R1_25 R2_25 B rhigh l=16.82u w=0.5u
X15 R1_26 R2_26 B rhigh l=16.82u w=0.5u
X16 R1_15 R2_15 B rhigh l=16.82u w=0.5u
X17 R1_16 R2_16 B rhigh l=16.82u w=0.5u
X18 R1_1 R2_1 B rhigh l=16.82u w=0.5u
X19 R1_45 R2_45 B rhigh l=16.82u w=0.5u
X20 R1_0 R2_0 B rhigh l=16.82u w=0.5u
X21 R1_30 R2_30 B rhigh l=16.82u w=0.5u
X22 R1_46 R2_46 B rhigh l=16.82u w=0.5u
X23 R1_31 R2_31 B rhigh l=16.82u w=0.5u
X24 R1_10 R2_10 B rhigh l=16.82u w=0.5u
X25 R1_11 R2_11 B rhigh l=16.82u w=0.5u
X26 R1_27 R2_27 B rhigh l=16.82u w=0.5u
X27 R1_32 R2_32 B rhigh l=16.82u w=0.5u
X28 R1_33 R2_33 B rhigh l=16.82u w=0.5u
X29 R1_34 R2_34 B rhigh l=16.82u w=0.5u
X30 R1_48 R2_48 B rhigh l=16.82u w=0.5u
X31 R1_23 R2_23 B rhigh l=16.82u w=0.5u
X32 R1_24 R2_24 B rhigh l=16.82u w=0.5u
X33 R1_49 R2_49 B rhigh l=16.82u w=0.5u
X34 R1_22 R2_22 B rhigh l=16.82u w=0.5u
X35 R1_47 R2_47 B rhigh l=16.82u w=0.5u
X36 R1_8 R2_8 B rhigh l=16.82u w=0.5u
X37 R1_9 R2_9 B rhigh l=16.82u w=0.5u
X38 R1_7 R2_7 B rhigh l=16.82u w=0.5u
X39 R1_35 R2_35 B rhigh l=16.82u w=0.5u
X40 R1_36 R2_36 B rhigh l=16.82u w=0.5u
X41 R1_50 R2_50 B rhigh l=16.82u w=0.5u
X42 R1_20 R2_20 B rhigh l=16.82u w=0.5u
X43 R1_21 R2_21 B rhigh l=16.82u w=0.5u
X44 R1_51 R2_51 B rhigh l=16.82u w=0.5u
X45 R1_6 R2_6 B rhigh l=16.82u w=0.5u
X46 R1_40 R2_40 B rhigh l=16.82u w=0.5u
X47 R1_5 R2_5 B rhigh l=16.82u w=0.5u
X48 R1_41 R2_41 B rhigh l=16.82u w=0.5u
X49 R1_37 R2_37 B rhigh l=16.82u w=0.5u
X50 R1_38 R2_38 B rhigh l=16.82u w=0.5u
X51 R1_39 R2_39 B rhigh l=16.82u w=0.5u
X52 R1_53 R2_53 B rhigh l=16.82u w=0.5u
X53 R1_43 R2_43 B rhigh l=16.82u w=0.5u
.ends

.subckt sg13_lv_nmos_5X2BDS B D0 G0 S1 G1 D2 G2 S3 G3 D4 G4 S5 G5 D6 G6 S7 G7 D8 G8
+ S9 G9 D10 G10 S11 G11 D12 G12 S13 G13 D14 S14 G14
X0 S3 G2 D2 B sg13_lv_nmos ad=61.8f pd=0.74u as=61.8f ps=0.74u w=0.24u l=0.13u
X1 S9 G8 D8 B sg13_lv_nmos ad=61.8f pd=0.74u as=61.8f ps=0.74u w=0.24u l=0.13u
X2 D8 G7 S7 B sg13_lv_nmos ad=61.8f pd=0.74u as=61.8f ps=0.74u w=0.24u l=0.13u
X3 D2 G1 S1 B sg13_lv_nmos ad=61.8f pd=0.74u as=61.8f ps=0.74u w=0.24u l=0.13u
X4 D10 G9 S9 B sg13_lv_nmos ad=61.8f pd=0.74u as=61.8f ps=0.74u w=0.24u l=0.13u
X5 S11 G10 D10 B sg13_lv_nmos ad=61.8f pd=0.74u as=61.8f ps=0.74u w=0.24u l=0.13u
X6 D12 G11 S11 B sg13_lv_nmos ad=61.8f pd=0.74u as=61.8f ps=0.74u w=0.24u l=0.13u
X7 S7 G6 D6 B sg13_lv_nmos ad=61.8f pd=0.74u as=61.8f ps=0.74u w=0.24u l=0.13u
X8 S1 G0 D0 B sg13_lv_nmos ad=61.8f pd=0.74u as=0.1068p ps=1.34u w=0.24u l=0.13u
X9 D6 G5 S5 B sg13_lv_nmos ad=61.8f pd=0.74u as=61.8f ps=0.74u w=0.24u l=0.13u
X10 S13 G12 D12 B sg13_lv_nmos ad=61.8f pd=0.74u as=61.8f ps=0.74u w=0.24u l=0.13u
X11 D14 G13 S13 B sg13_lv_nmos ad=61.8f pd=0.74u as=61.8f ps=0.74u w=0.24u l=0.13u
X12 S5 G4 D4 B sg13_lv_nmos ad=61.8f pd=0.74u as=61.8f ps=0.74u w=0.24u l=0.13u
X13 S14 G14 D14 B sg13_lv_nmos ad=0.1068p pd=1.34u as=61.8f ps=0.74u w=0.24u l=0.13u
X14 D4 G3 S3 B sg13_lv_nmos ad=61.8f pd=0.74u as=61.8f ps=0.74u w=0.24u l=0.13u
.ends

.subckt sg13_lv_nmos_VHRE9V B D0 G0 S1 G1 D2 G2 S3 G3 D4 G4 S5 G5 D6 G6 S7 G7 a_370_n47#
X0 D6 G5 S5 B sg13_lv_nmos ad=89.3f pd=0.85u as=89.3f ps=0.85u w=0.47u l=0.13u
X1 S7 G6 D6 B sg13_lv_nmos ad=89.3f pd=0.85u as=89.3f ps=0.85u w=0.47u l=0.13u
X2 a_370_n47# G7 S7 B sg13_lv_nmos ad=0.1598p pd=1.62u as=89.3f ps=0.85u w=0.47u l=0.13u
X3 D4 G3 S3 B sg13_lv_nmos ad=89.3f pd=0.85u as=89.3f ps=0.85u w=0.47u l=0.13u
X4 S5 G4 D4 B sg13_lv_nmos ad=89.3f pd=0.85u as=89.3f ps=0.85u w=0.47u l=0.13u
X5 S3 G2 D2 B sg13_lv_nmos ad=89.3f pd=0.85u as=89.3f ps=0.85u w=0.47u l=0.13u
X6 D2 G1 S1 B sg13_lv_nmos ad=89.3f pd=0.85u as=89.3f ps=0.85u w=0.47u l=0.13u
X7 S1 G0 D0 B sg13_lv_nmos ad=89.3f pd=0.85u as=0.1598p ps=1.62u w=0.47u l=0.13u
.ends

.subckt sg13_lv_pmos_4AKZGL B D0 G0 S1 G1 D2 G2 S3 G3 D4 G4 S5 G5 D6 G6 S7 G7 D8 G8
+ S9 G9 D10 G10 S11 G11 D12 G12 S13 G13 D14 S14 G14
X0 S3 G2 D2 B sg13_lv_pmos ad=61.8f pd=0.74u as=61.8f ps=0.74u w=0.24u l=0.13u
X1 S9 G8 D8 B sg13_lv_pmos ad=61.8f pd=0.74u as=61.8f ps=0.74u w=0.24u l=0.13u
X2 D8 G7 S7 B sg13_lv_pmos ad=61.8f pd=0.74u as=61.8f ps=0.74u w=0.24u l=0.13u
X3 D2 G1 S1 B sg13_lv_pmos ad=61.8f pd=0.74u as=61.8f ps=0.74u w=0.24u l=0.13u
X4 D10 G9 S9 B sg13_lv_pmos ad=61.8f pd=0.74u as=61.8f ps=0.74u w=0.24u l=0.13u
X5 S11 G10 D10 B sg13_lv_pmos ad=61.8f pd=0.74u as=61.8f ps=0.74u w=0.24u l=0.13u
X6 D12 G11 S11 B sg13_lv_pmos ad=61.8f pd=0.74u as=61.8f ps=0.74u w=0.24u l=0.13u
X7 S7 G6 D6 B sg13_lv_pmos ad=61.8f pd=0.74u as=61.8f ps=0.74u w=0.24u l=0.13u
X8 S1 G0 D0 B sg13_lv_pmos ad=61.8f pd=0.74u as=0.1068p ps=1.34u w=0.24u l=0.13u
X9 D6 G5 S5 B sg13_lv_pmos ad=61.8f pd=0.74u as=61.8f ps=0.74u w=0.24u l=0.13u
X10 S13 G12 D12 B sg13_lv_pmos ad=61.8f pd=0.74u as=61.8f ps=0.74u w=0.24u l=0.13u
X11 S5 G4 D4 B sg13_lv_pmos ad=61.8f pd=0.74u as=61.8f ps=0.74u w=0.24u l=0.13u
X12 D14 G13 S13 B sg13_lv_pmos ad=61.8f pd=0.74u as=61.8f ps=0.74u w=0.24u l=0.13u
X13 S14 G14 D14 B sg13_lv_pmos ad=0.1068p pd=1.34u as=61.8f ps=0.74u w=0.24u l=0.13u
X14 D4 G3 S3 B sg13_lv_pmos ad=61.8f pd=0.74u as=61.8f ps=0.74u w=0.24u l=0.13u
.ends

.subckt sg13_lv_pmos_JRRYKH B D0 G0 S1 G1 D2 G2 S3 G3 D4 G4 S5 G5 D6 G6 S7 G7 D8 G8
+ S9 G9 D10 S10 G10
X0 S1 G0 D0 B sg13_lv_pmos ad=61.8f pd=0.74u as=0.1068p ps=1.34u w=0.24u l=0.13u
X1 S7 G6 D6 B sg13_lv_pmos ad=61.8f pd=0.74u as=61.8f ps=0.74u w=0.24u l=0.13u
X2 D6 G5 S5 B sg13_lv_pmos ad=61.8f pd=0.74u as=61.8f ps=0.74u w=0.24u l=0.13u
X3 D8 G7 S7 B sg13_lv_pmos ad=61.8f pd=0.74u as=61.8f ps=0.74u w=0.24u l=0.13u
X4 S9 G8 D8 B sg13_lv_pmos ad=61.8f pd=0.74u as=61.8f ps=0.74u w=0.24u l=0.13u
X5 D10 G9 S9 B sg13_lv_pmos ad=61.8f pd=0.74u as=61.8f ps=0.74u w=0.24u l=0.13u
X6 S5 G4 D4 B sg13_lv_pmos ad=61.8f pd=0.74u as=61.8f ps=0.74u w=0.24u l=0.13u
X7 D4 G3 S3 B sg13_lv_pmos ad=61.8f pd=0.74u as=61.8f ps=0.74u w=0.24u l=0.13u
X8 S10 G10 D10 B sg13_lv_pmos ad=0.1068p pd=1.34u as=61.8f ps=0.74u w=0.24u l=0.13u
X9 S3 G2 D2 B sg13_lv_pmos ad=61.8f pd=0.74u as=61.8f ps=0.74u w=0.24u l=0.13u
X10 D2 G1 S1 B sg13_lv_pmos ad=61.8f pd=0.74u as=61.8f ps=0.74u w=0.24u l=0.13u
.ends

.subckt por_stepdown vref nbias vpb vfb vcap vss vdd1v2
Xsg13_lv_nmos_5X2BDS_0 vss vss vss sg13_lv_nmos_5X2BDS_0/S9 sg13_lv_nmos_5X2BDS_0/S9
+ sg13_lv_nmos_5X2BDS_1/G9 sg13_lv_nmos_5X2BDS_0/S9 sg13_lv_nmos_5X2BDS_0/S9 sg13_lv_nmos_5X2BDS_0/S9
+ sg13_lv_nmos_5X2BDS_1/G9 sg13_lv_nmos_5X2BDS_0/S9 sg13_lv_nmos_5X2BDS_0/S9 sg13_lv_nmos_5X2BDS_0/S9
+ sg13_lv_nmos_5X2BDS_1/G9 sg13_lv_nmos_5X2BDS_0/S9 sg13_lv_nmos_5X2BDS_0/S9 sg13_lv_nmos_5X2BDS_0/S9
+ sg13_lv_nmos_5X2BDS_1/G9 sg13_lv_nmos_5X2BDS_0/S9 sg13_lv_nmos_5X2BDS_0/S9 sg13_lv_nmos_5X2BDS_0/S9
+ sg13_lv_nmos_5X2BDS_1/G9 sg13_lv_nmos_5X2BDS_0/S9 sg13_lv_nmos_5X2BDS_0/S9 sg13_lv_nmos_5X2BDS_0/S9
+ sg13_lv_nmos_5X2BDS_1/G9 sg13_lv_nmos_5X2BDS_0/S9 sg13_lv_nmos_5X2BDS_0/S9 vss sg13_lv_nmos_5X2BDS_1/D14
+ sg13_lv_pmos_JRRYKH_1/S9 sg13_lv_nmos_5X2BDS_0/S9 sg13_lv_nmos_5X2BDS
Xsg13_lv_nmos_5X2BDS_1 vss vss vss vss sg13_lv_nmos_5X2BDS_1/G9 sg13_lv_nmos_5X2BDS_1/G9
+ sg13_lv_nmos_5X2BDS_1/G9 vss sg13_lv_nmos_5X2BDS_1/G9 sg13_lv_nmos_5X2BDS_1/G9 sg13_lv_nmos_5X2BDS_1/G9
+ vss sg13_lv_nmos_5X2BDS_1/G9 sg13_lv_nmos_5X2BDS_1/G9 sg13_lv_nmos_5X2BDS_1/G9 vss
+ sg13_lv_nmos_5X2BDS_1/G9 sg13_lv_nmos_5X2BDS_1/G9 sg13_lv_nmos_5X2BDS_1/G9 vss sg13_lv_nmos_5X2BDS_1/G9
+ sg13_lv_nmos_5X2BDS_1/G9 sg13_lv_nmos_5X2BDS_1/G9 vss sg13_lv_nmos_5X2BDS_1/G9 sg13_lv_nmos_5X2BDS_1/G9
+ sg13_lv_nmos_5X2BDS_1/G9 vss sg13_lv_nmos_5X2BDS_1/G9 sg13_lv_nmos_5X2BDS_1/D14
+ vss vss sg13_lv_nmos_5X2BDS
Xsg13_lv_nmos_VHRE9V_0 vss nbias vref vref vref nbias vref vref vref nbias vref vref
+ vref nbias vref vref vref nbias sg13_lv_nmos_VHRE9V
Xsg13_lv_nmos_VHRE9V_1 vss nbias nbias vss nbias nbias nbias vss nbias nbias nbias
+ vss nbias nbias nbias vss nbias nbias sg13_lv_nmos_VHRE9V
Xsg13_lv_pmos_4AKZGL_0 vdd1v2 vdd1v2 vdd1v2 vdd1v2 vpb sg13_lv_pmos_4AKZGL_1/D8 vpb
+ vdd1v2 vpb sg13_lv_pmos_4AKZGL_1/D8 vpb vdd1v2 vpb sg13_lv_pmos_4AKZGL_1/D8 vpb
+ vdd1v2 vpb sg13_lv_pmos_4AKZGL_1/D8 vpb vdd1v2 vpb sg13_lv_pmos_4AKZGL_1/D8 vpb
+ vdd1v2 vpb sg13_lv_pmos_4AKZGL_1/D8 vpb vdd1v2 vpb sg13_lv_pmos_4AKZGL_1/D14 vdd1v2
+ vdd1v2 sg13_lv_pmos_4AKZGL
Xsg13_lv_pmos_JRRYKH_0 vdd1v2 vdd1v2 vdd1v2 vdd1v2 sg13_lv_pmos_JRRYKH_1/D8 sg13_lv_pmos_JRRYKH_1/D8
+ sg13_lv_pmos_JRRYKH_1/D8 vdd1v2 sg13_lv_pmos_JRRYKH_1/D8 sg13_lv_pmos_JRRYKH_1/D8
+ sg13_lv_pmos_JRRYKH_1/D8 vdd1v2 sg13_lv_pmos_JRRYKH_1/D8 sg13_lv_pmos_JRRYKH_1/D8
+ sg13_lv_pmos_JRRYKH_1/D8 vdd1v2 sg13_lv_pmos_JRRYKH_1/D8 sg13_lv_pmos_JRRYKH_1/D8
+ sg13_lv_pmos_JRRYKH_1/D8 vdd1v2 sg13_lv_pmos_JRRYKH_1/D8 sg13_lv_pmos_JRRYKH_1/D10
+ vdd1v2 vdd1v2 sg13_lv_pmos_JRRYKH
Xsg13_lv_pmos_4AKZGL_1 vdd1v2 vdd1v2 vdd1v2 vfb vfb sg13_lv_pmos_4AKZGL_1/D8 vfb vfb
+ vfb sg13_lv_pmos_4AKZGL_1/D8 vfb vfb vfb sg13_lv_pmos_4AKZGL_1/D8 vfb vfb vfb sg13_lv_pmos_4AKZGL_1/D8
+ vfb vfb vfb sg13_lv_pmos_4AKZGL_1/D8 vfb vfb vfb sg13_lv_pmos_4AKZGL_1/D8 vfb vfb
+ vdd1v2 sg13_lv_pmos_4AKZGL_1/D14 sg13_lv_nmos_5X2BDS_0/S9 vfb sg13_lv_pmos_4AKZGL
Xsg13_lv_pmos_JRRYKH_1 vdd1v2 vdd1v2 vdd1v2 sg13_lv_pmos_JRRYKH_1/S9 sg13_lv_pmos_JRRYKH_1/S9
+ sg13_lv_pmos_JRRYKH_1/D8 sg13_lv_pmos_JRRYKH_1/S9 sg13_lv_pmos_JRRYKH_1/S9 sg13_lv_pmos_JRRYKH_1/S9
+ sg13_lv_pmos_JRRYKH_1/D8 sg13_lv_pmos_JRRYKH_1/S9 sg13_lv_pmos_JRRYKH_1/S9 sg13_lv_pmos_JRRYKH_1/S9
+ sg13_lv_pmos_JRRYKH_1/D8 sg13_lv_pmos_JRRYKH_1/S9 sg13_lv_pmos_JRRYKH_1/S9 sg13_lv_pmos_JRRYKH_1/S9
+ sg13_lv_pmos_JRRYKH_1/D8 sg13_lv_pmos_JRRYKH_1/S9 sg13_lv_pmos_JRRYKH_1/S9 vdd1v2
+ sg13_lv_pmos_JRRYKH_1/D10 vcap sg13_lv_pmos_JRRYKH_1/S9 sg13_lv_pmos_JRRYKH
.ends

.subckt cap_cmomf_MKAUQG c1 c2
X0 c1 c2 cap_cmomf mm_ok=1 subblock=0 mmax=4 mmin=1 l=20u w=20u
.ends

.subckt cap_cmomf_7YMNSS c1 c2
X0 c1 c2 cap_cmomf mm_ok=1 subblock=0 mmax=4 mmin=3 l=14u w=50u
.ends

.subckt dantenna_WMFCS7 D2 D1
X0 D2 D1 dantenna l=0.78u w=0.78u
.ends

.subckt sg13_lv_pmos_KE4EUN B D S G
X0 S G D B sg13_lv_pmos ad=0.476p pd=3.48u as=0.476p ps=3.48u w=1.4u l=0.26u
.ends

.subckt sg13_lv_pmos_KPMAU6 B D0 G0 S1 G1 D2 G2 S3 G3 a_166_n16#
X0 D2 G1 S1 B sg13_lv_pmos ad=66.49999f pd=0.73u as=66.49999f ps=0.73u w=0.35u l=0.13u
X1 S3 G2 D2 B sg13_lv_pmos ad=66.49999f pd=0.73u as=66.49999f ps=0.73u w=0.35u l=0.13u
X2 S1 G0 D0 B sg13_lv_pmos ad=66.49999f pd=0.73u as=0.119p ps=1.38u w=0.35u l=0.13u
X3 a_166_n16# G3 S3 B sg13_lv_pmos ad=0.119p pd=1.38u as=66.49999f ps=0.73u w=0.35u l=0.13u
.ends

.subckt sg13_lv_pmos_RWAJH3 B D S G
X0 S G D B sg13_lv_pmos ad=0.119p pd=1.38u as=0.119p ps=1.38u w=0.35u l=0.13u
.ends

.subckt sg13_lv_nmos_LT8DKY B D0 G0 S1 G1 a_64_n54#
X0 S1 G0 D0 B sg13_lv_nmos ad=66.49999f pd=0.73u as=0.119p ps=1.38u w=0.35u l=0.13u
X1 a_64_n54# G1 S1 B sg13_lv_nmos ad=0.119p pd=1.38u as=66.49999f ps=0.73u w=0.35u l=0.13u
.ends

.subckt sg13_lv_nmos_GT3QPP B D S G
X0 S G D B sg13_lv_nmos ad=0.952p pd=6.28u as=0.952p ps=6.28u w=2.8u l=0.26u
.ends

.subckt por_1v2_schmitt_inv vdd1v2 in out vss
Xsg13_lv_pmos_KE4EUN_0 vdd1v2 sg13_lv_pmos_RWAJH3_0/D vss out sg13_lv_pmos_KE4EUN
Xsg13_lv_pmos_KPMAU6_0 vdd1v2 vdd1v2 in sg13_lv_pmos_RWAJH3_0/D in vdd1v2 in sg13_lv_pmos_RWAJH3_0/D
+ in vdd1v2 sg13_lv_pmos_KPMAU6
Xsg13_lv_pmos_RWAJH3_0 vdd1v2 sg13_lv_pmos_RWAJH3_0/D out in sg13_lv_pmos_RWAJH3
Xsg13_lv_nmos_LT8DKY_0 vss vss in sg13_lv_nmos_GT3QPP_0/D in vss sg13_lv_nmos_LT8DKY
Xsg13_lv_nmos_LT8DKY_1 vss sg13_lv_nmos_GT3QPP_0/D in out in sg13_lv_nmos_GT3QPP_0/D
+ sg13_lv_nmos_LT8DKY
Xsg13_lv_nmos_GT3QPP_0 vss sg13_lv_nmos_GT3QPP_0/D vdd1v2 out sg13_lv_nmos_GT3QPP
.ends

.subckt cap_cmomf_T2STT2 sub c1 c2
X0 c1 c2 cap_cmomf mm_ok=1 subblock=1 mmax=4 mmin=1 l=14u w=50u
.ends

.subckt sg13_lv_nmos_AGXAPYY B D0 G0 S1 G1 D2 G2 S3 G3 D4 G4 S5 G5 D6 G6 S7 G7 D8
+ G8 S9 G9 D10 G10 S11 G11 D12 G12 S13 G13 D14 G14 S15 G15 D16 G16 S17 G17 D18 G18
+ S19 G19 D20 G20 S21 G21 D22 G22 S23 G23 D24 G24 S25 G25 a_1288_n47#
X0 D6 G5 S5 B sg13_lv_nmos ad=89.3f pd=0.85u as=89.3f ps=0.85u w=0.47u l=0.13u
X1 S3 G2 D2 B sg13_lv_nmos ad=89.3f pd=0.85u as=89.3f ps=0.85u w=0.47u l=0.13u
X2 D4 G3 S3 B sg13_lv_nmos ad=89.3f pd=0.85u as=89.3f ps=0.85u w=0.47u l=0.13u
X3 S5 G4 D4 B sg13_lv_nmos ad=89.3f pd=0.85u as=89.3f ps=0.85u w=0.47u l=0.13u
X4 D2 G1 S1 B sg13_lv_nmos ad=89.3f pd=0.85u as=89.3f ps=0.85u w=0.47u l=0.13u
X5 S1 G0 D0 B sg13_lv_nmos ad=89.3f pd=0.85u as=0.1598p ps=1.62u w=0.47u l=0.13u
X6 S15 G14 D14 B sg13_lv_nmos ad=89.3f pd=0.85u as=89.3f ps=0.85u w=0.47u l=0.13u
X7 D16 G15 S15 B sg13_lv_nmos ad=89.3f pd=0.85u as=89.3f ps=0.85u w=0.47u l=0.13u
X8 S17 G16 D16 B sg13_lv_nmos ad=89.3f pd=0.85u as=89.3f ps=0.85u w=0.47u l=0.13u
X9 D18 G17 S17 B sg13_lv_nmos ad=89.3f pd=0.85u as=89.3f ps=0.85u w=0.47u l=0.13u
X10 S13 G12 D12 B sg13_lv_nmos ad=89.3f pd=0.85u as=89.3f ps=0.85u w=0.47u l=0.13u
X11 S19 G18 D18 B sg13_lv_nmos ad=89.3f pd=0.85u as=89.3f ps=0.85u w=0.47u l=0.13u
X12 D20 G19 S19 B sg13_lv_nmos ad=89.3f pd=0.85u as=89.3f ps=0.85u w=0.47u l=0.13u
X13 S21 G20 D20 B sg13_lv_nmos ad=89.3f pd=0.85u as=89.3f ps=0.85u w=0.47u l=0.13u
X14 D14 G13 S13 B sg13_lv_nmos ad=89.3f pd=0.85u as=89.3f ps=0.85u w=0.47u l=0.13u
X15 D22 G21 S21 B sg13_lv_nmos ad=89.3f pd=0.85u as=89.3f ps=0.85u w=0.47u l=0.13u
X16 S23 G22 D22 B sg13_lv_nmos ad=89.3f pd=0.85u as=89.3f ps=0.85u w=0.47u l=0.13u
X17 D12 G11 S11 B sg13_lv_nmos ad=89.3f pd=0.85u as=89.3f ps=0.85u w=0.47u l=0.13u
X18 S11 G10 D10 B sg13_lv_nmos ad=89.3f pd=0.85u as=89.3f ps=0.85u w=0.47u l=0.13u
X19 S9 G8 D8 B sg13_lv_nmos ad=89.3f pd=0.85u as=89.3f ps=0.85u w=0.47u l=0.13u
X20 D10 G9 S9 B sg13_lv_nmos ad=89.3f pd=0.85u as=89.3f ps=0.85u w=0.47u l=0.13u
X21 D24 G23 S23 B sg13_lv_nmos ad=89.3f pd=0.85u as=89.3f ps=0.85u w=0.47u l=0.13u
X22 S25 G24 D24 B sg13_lv_nmos ad=89.3f pd=0.85u as=89.3f ps=0.85u w=0.47u l=0.13u
X23 D8 G7 S7 B sg13_lv_nmos ad=89.3f pd=0.85u as=89.3f ps=0.85u w=0.47u l=0.13u
X24 a_1288_n47# G25 S25 B sg13_lv_nmos ad=0.1598p pd=1.62u as=89.3f ps=0.85u w=0.47u l=0.13u
X25 S7 G6 D6 B sg13_lv_nmos ad=89.3f pd=0.85u as=89.3f ps=0.85u w=0.47u l=0.13u
.ends

.subckt sg13_lv_pmos_X27YSC B D0 G0 S1 G1 D2 G2 S3 G3 D4 G4 S5 G5 D6 G6 S7 G7 a_370_n47#
X0 D6 G5 S5 B sg13_lv_pmos ad=89.3f pd=0.85u as=89.3f ps=0.85u w=0.47u l=0.13u
X1 S7 G6 D6 B sg13_lv_pmos ad=89.3f pd=0.85u as=89.3f ps=0.85u w=0.47u l=0.13u
X2 a_370_n47# G7 S7 B sg13_lv_pmos ad=0.1598p pd=1.62u as=89.3f ps=0.85u w=0.47u l=0.13u
X3 D4 G3 S3 B sg13_lv_pmos ad=89.3f pd=0.85u as=89.3f ps=0.85u w=0.47u l=0.13u
X4 S5 G4 D4 B sg13_lv_pmos ad=89.3f pd=0.85u as=89.3f ps=0.85u w=0.47u l=0.13u
X5 S3 G2 D2 B sg13_lv_pmos ad=89.3f pd=0.85u as=89.3f ps=0.85u w=0.47u l=0.13u
X6 D2 G1 S1 B sg13_lv_pmos ad=89.3f pd=0.85u as=89.3f ps=0.85u w=0.47u l=0.13u
X7 S1 G0 D0 B sg13_lv_pmos ad=89.3f pd=0.85u as=0.1598p ps=1.62u w=0.47u l=0.13u
.ends

.subckt sg13_lv_nmos_AGXAPYX B D0 G0 S1 G1 D2 G2 S3 G3 D4 G4 S5 G5 D6 G6 S7 G7 D8
+ G8 S9 G9 D10 G10 S11 G11 D12 G12 S13 G13 D14 G14 S15 G15 D16 G16 S17 G17 D18 G18
+ S19 G19 D20 G20 S21 G21 D22 G22 S23 G23 D24 G24 S25 G25 a_1288_n47#
X0 D6 G5 S5 B sg13_lv_nmos ad=89.3f pd=0.85u as=89.3f ps=0.85u w=0.47u l=0.13u
X1 S3 G2 D2 B sg13_lv_nmos ad=89.3f pd=0.85u as=89.3f ps=0.85u w=0.47u l=0.13u
X2 D4 G3 S3 B sg13_lv_nmos ad=89.3f pd=0.85u as=89.3f ps=0.85u w=0.47u l=0.13u
X3 S5 G4 D4 B sg13_lv_nmos ad=89.3f pd=0.85u as=89.3f ps=0.85u w=0.47u l=0.13u
X4 D2 G1 S1 B sg13_lv_nmos ad=89.3f pd=0.85u as=89.3f ps=0.85u w=0.47u l=0.13u
X5 S1 G0 D0 B sg13_lv_nmos ad=89.3f pd=0.85u as=0.1598p ps=1.62u w=0.47u l=0.13u
X6 S15 G14 D14 B sg13_lv_nmos ad=89.3f pd=0.85u as=89.3f ps=0.85u w=0.47u l=0.13u
X7 D16 G15 S15 B sg13_lv_nmos ad=89.3f pd=0.85u as=89.3f ps=0.85u w=0.47u l=0.13u
X8 S17 G16 D16 B sg13_lv_nmos ad=89.3f pd=0.85u as=89.3f ps=0.85u w=0.47u l=0.13u
X9 D18 G17 S17 B sg13_lv_nmos ad=89.3f pd=0.85u as=89.3f ps=0.85u w=0.47u l=0.13u
X10 S13 G12 D12 B sg13_lv_nmos ad=89.3f pd=0.85u as=89.3f ps=0.85u w=0.47u l=0.13u
X11 S19 G18 D18 B sg13_lv_nmos ad=89.3f pd=0.85u as=89.3f ps=0.85u w=0.47u l=0.13u
X12 D20 G19 S19 B sg13_lv_nmos ad=89.3f pd=0.85u as=89.3f ps=0.85u w=0.47u l=0.13u
X13 S21 G20 D20 B sg13_lv_nmos ad=89.3f pd=0.85u as=89.3f ps=0.85u w=0.47u l=0.13u
X14 D14 G13 S13 B sg13_lv_nmos ad=89.3f pd=0.85u as=89.3f ps=0.85u w=0.47u l=0.13u
X15 D22 G21 S21 B sg13_lv_nmos ad=89.3f pd=0.85u as=89.3f ps=0.85u w=0.47u l=0.13u
X16 S23 G22 D22 B sg13_lv_nmos ad=89.3f pd=0.85u as=89.3f ps=0.85u w=0.47u l=0.13u
X17 D12 G11 S11 B sg13_lv_nmos ad=89.3f pd=0.85u as=89.3f ps=0.85u w=0.47u l=0.13u
X18 S11 G10 D10 B sg13_lv_nmos ad=89.3f pd=0.85u as=89.3f ps=0.85u w=0.47u l=0.13u
X19 S9 G8 D8 B sg13_lv_nmos ad=89.3f pd=0.85u as=89.3f ps=0.85u w=0.47u l=0.13u
X20 D10 G9 S9 B sg13_lv_nmos ad=89.3f pd=0.85u as=89.3f ps=0.85u w=0.47u l=0.13u
X21 D24 G23 S23 B sg13_lv_nmos ad=89.3f pd=0.85u as=89.3f ps=0.85u w=0.47u l=0.13u
X22 S25 G24 D24 B sg13_lv_nmos ad=89.3f pd=0.85u as=89.3f ps=0.85u w=0.47u l=0.13u
X23 D8 G7 S7 B sg13_lv_nmos ad=89.3f pd=0.85u as=89.3f ps=0.85u w=0.47u l=0.13u
X24 a_1288_n47# G25 S25 B sg13_lv_nmos ad=0.1598p pd=1.62u as=89.3f ps=0.85u w=0.47u l=0.13u
X25 S7 G6 D6 B sg13_lv_nmos ad=89.3f pd=0.85u as=89.3f ps=0.85u w=0.47u l=0.13u
.ends

.subckt por_amp vdd1v2 inp ena nbias out inn vss
Xsg13_lv_nmos_AGXAPYY_0 vss vss vss vss nbias sg13_lv_nmos_AGXAPYY_0/D8 ena sg13_lv_nmos_AGXAPYY_0/S7
+ ena sg13_lv_nmos_AGXAPYY_0/D8 nbias vss nbias sg13_lv_nmos_AGXAPYY_0/D8 ena sg13_lv_nmos_AGXAPYY_0/S7
+ ena sg13_lv_nmos_AGXAPYY_0/D8 nbias vss nbias sg13_lv_nmos_AGXAPYY_0/D8 ena sg13_lv_nmos_AGXAPYY_0/S7
+ ena sg13_lv_nmos_AGXAPYY_0/D8 nbias vss nbias sg13_lv_nmos_AGXAPYY_0/D8 ena sg13_lv_nmos_AGXAPYY_0/S7
+ ena sg13_lv_nmos_AGXAPYY_0/D8 nbias vss nbias sg13_lv_nmos_AGXAPYY_0/D8 ena sg13_lv_nmos_AGXAPYY_0/S7
+ ena sg13_lv_nmos_AGXAPYY_0/D8 nbias vss nbias sg13_lv_nmos_AGXAPYY_0/D8 ena sg13_lv_nmos_AGXAPYY_0/S7
+ ena sg13_lv_nmos_AGXAPYY_0/D8 nbias vss vss vss sg13_lv_nmos_AGXAPYY
Xsg13_lv_pmos_X27YSC_0 vdd1v2 vdd1v2 vdd1v2 vdd1v2 sg13_lv_pmos_X27YSC_1/G6 out sg13_lv_pmos_X27YSC_1/G6
+ vdd1v2 sg13_lv_pmos_X27YSC_1/G6 sg13_lv_pmos_X27YSC_1/G6 sg13_lv_pmos_X27YSC_1/G6
+ vdd1v2 sg13_lv_pmos_X27YSC_1/G6 out sg13_lv_pmos_X27YSC_1/G6 vdd1v2 vdd1v2 vdd1v2
+ sg13_lv_pmos_X27YSC
Xsg13_lv_pmos_X27YSC_1 vdd1v2 vdd1v2 vdd1v2 vdd1v2 sg13_lv_pmos_X27YSC_1/G6 sg13_lv_pmos_X27YSC_1/G6
+ sg13_lv_pmos_X27YSC_1/G6 vdd1v2 sg13_lv_pmos_X27YSC_1/G6 out sg13_lv_pmos_X27YSC_1/G6
+ vdd1v2 sg13_lv_pmos_X27YSC_1/G6 sg13_lv_pmos_X27YSC_1/G6 sg13_lv_pmos_X27YSC_1/G6
+ vdd1v2 vdd1v2 vdd1v2 sg13_lv_pmos_X27YSC
Xsg13_lv_nmos_AGXAPYX_0 vss vss vss sg13_lv_nmos_AGXAPYY_0/S7 inn out inn sg13_lv_nmos_AGXAPYY_0/S7
+ inp sg13_lv_pmos_X27YSC_1/G6 inp sg13_lv_nmos_AGXAPYY_0/S7 inn out inn sg13_lv_nmos_AGXAPYY_0/S7
+ inp sg13_lv_pmos_X27YSC_1/G6 inp sg13_lv_nmos_AGXAPYY_0/S7 inn out inn sg13_lv_nmos_AGXAPYY_0/S7
+ inp sg13_lv_pmos_X27YSC_1/G6 inp sg13_lv_nmos_AGXAPYY_0/S7 inn out inn sg13_lv_nmos_AGXAPYY_0/S7
+ inp sg13_lv_pmos_X27YSC_1/G6 inp sg13_lv_nmos_AGXAPYY_0/S7 inn out inn sg13_lv_nmos_AGXAPYY_0/S7
+ inp sg13_lv_pmos_X27YSC_1/G6 inp sg13_lv_nmos_AGXAPYY_0/S7 inn out inn sg13_lv_nmos_AGXAPYY_0/S7
+ inp sg13_lv_pmos_X27YSC_1/G6 inp sg13_lv_nmos_AGXAPYY_0/S7 vss vss sg13_lv_nmos_AGXAPYX
.ends

.subckt sg13cmos5l_buf_16 X A VDD VSS
X0 VDD a_116_82# X VDD sg13_lv_pmos ad=0.2128p pd=1.5u as=0.2128p ps=1.5u w=1.12u l=0.13u
X1 X a_116_82# VSS VSS sg13_lv_nmos ad=0.1406p pd=1.12u as=0.1406p ps=1.12u w=0.74u l=0.13u
X2 X a_116_82# VDD VDD sg13_lv_pmos ad=0.2128p pd=1.5u as=0.2128p ps=1.5u w=1.12u l=0.13u
X3 VSS a_116_82# X VSS sg13_lv_nmos ad=0.1406p pd=1.12u as=0.1406p ps=1.12u w=0.74u l=0.13u
X4 X a_116_82# VSS VSS sg13_lv_nmos ad=0.1406p pd=1.12u as=0.1406p ps=1.12u w=0.74u l=0.13u
X5 VDD a_116_82# X VDD sg13_lv_pmos ad=0.2128p pd=1.5u as=0.2128p ps=1.5u w=1.12u l=0.13u
X6 VSS a_116_82# X VSS sg13_lv_nmos ad=0.1406p pd=1.12u as=0.1406p ps=1.12u w=0.74u l=0.13u
X7 X a_116_82# VDD VDD sg13_lv_pmos ad=0.2128p pd=1.5u as=0.2128p ps=1.5u w=1.12u l=0.13u
X8 VDD a_116_82# X VDD sg13_lv_pmos ad=0.2128p pd=1.5u as=0.2128p ps=1.5u w=1.12u l=0.13u
X9 X a_116_82# VSS VSS sg13_lv_nmos ad=0.1406p pd=1.12u as=0.1406p ps=1.12u w=0.74u l=0.13u
X10 VSS A a_116_82# VSS sg13_lv_nmos ad=0.1406p pd=1.12u as=0.1406p ps=1.12u w=0.74u l=0.13u
X11 X a_116_82# VDD VDD sg13_lv_pmos ad=0.2128p pd=1.5u as=0.2128p ps=1.5u w=1.12u l=0.13u
X12 VDD A a_116_82# VDD sg13_lv_pmos ad=0.2128p pd=1.5u as=0.2128p ps=1.5u w=1.12u l=0.13u
X13 VSS a_116_82# X VSS sg13_lv_nmos ad=0.1406p pd=1.12u as=0.1406p ps=1.12u w=0.74u l=0.13u
X14 a_116_82# A VSS VSS sg13_lv_nmos ad=0.1406p pd=1.12u as=0.1406p ps=1.12u w=0.74u l=0.13u
X15 VDD a_116_82# X VDD sg13_lv_pmos ad=0.2128p pd=1.5u as=0.2128p ps=1.5u w=1.12u l=0.13u
X16 a_116_82# A VDD VDD sg13_lv_pmos ad=0.2128p pd=1.5u as=0.2128p ps=1.5u w=1.12u l=0.13u
X17 a_116_82# A VSS VSS sg13_lv_nmos ad=0.1406p pd=1.12u as=0.1406p ps=1.12u w=0.74u l=0.13u
X18 VSS A a_116_82# VSS sg13_lv_nmos ad=0.1406p pd=1.12u as=0.1406p ps=1.12u w=0.74u l=0.13u
X19 VSS A a_116_82# VSS sg13_lv_nmos ad=0.2516p pd=2.16u as=0.1406p ps=1.12u w=0.74u l=0.13u
X20 a_116_82# A VDD VDD sg13_lv_pmos ad=0.2128p pd=1.5u as=0.2128p ps=1.5u w=1.12u l=0.13u
X21 VDD A a_116_82# VDD sg13_lv_pmos ad=0.2128p pd=1.5u as=0.2128p ps=1.5u w=1.12u l=0.13u
X22 VDD A a_116_82# VDD sg13_lv_pmos ad=0.3808p pd=2.92u as=0.2128p ps=1.5u w=1.12u l=0.13u
X23 a_116_82# A VSS VSS sg13_lv_nmos ad=0.1406p pd=1.12u as=0.1406p ps=1.12u w=0.74u l=0.13u
X24 X a_116_82# VSS VSS sg13_lv_nmos ad=0.1406p pd=1.12u as=0.2516p ps=2.16u w=0.74u l=0.13u
X25 a_116_82# A VDD VDD sg13_lv_pmos ad=0.2128p pd=1.5u as=0.2128p ps=1.5u w=1.12u l=0.13u
X26 VSS a_116_82# X VSS sg13_lv_nmos ad=0.1406p pd=1.12u as=0.1406p ps=1.12u w=0.74u l=0.13u
X27 X a_116_82# VDD VDD sg13_lv_pmos ad=0.2128p pd=1.5u as=0.3976p ps=2.95u w=1.12u l=0.13u
X28 X a_116_82# VSS VSS sg13_lv_nmos ad=0.1406p pd=1.12u as=0.1406p ps=1.12u w=0.74u l=0.13u
X29 VDD a_116_82# X VDD sg13_lv_pmos ad=0.2128p pd=1.5u as=0.2128p ps=1.5u w=1.12u l=0.13u
X30 X a_116_82# VDD VDD sg13_lv_pmos ad=0.2128p pd=1.5u as=0.2128p ps=1.5u w=1.12u l=0.13u
X31 VSS a_116_82# X VSS sg13_lv_nmos ad=0.1406p pd=1.12u as=0.1406p ps=1.12u w=0.74u l=0.13u
X32 VDD a_116_82# X VDD sg13_lv_pmos ad=0.2128p pd=1.5u as=0.2128p ps=1.5u w=1.12u l=0.13u
X33 X a_116_82# VSS VSS sg13_lv_nmos ad=0.1406p pd=1.12u as=0.1406p ps=1.12u w=0.74u l=0.13u
X34 VSS a_116_82# X VSS sg13_lv_nmos ad=0.1406p pd=1.12u as=0.1406p ps=1.12u w=0.74u l=0.13u
X35 X a_116_82# VDD VDD sg13_lv_pmos ad=0.2128p pd=1.5u as=0.2128p ps=1.5u w=1.12u l=0.13u
X36 VDD a_116_82# X VDD sg13_lv_pmos ad=0.2128p pd=1.5u as=0.2128p ps=1.5u w=1.12u l=0.13u
X37 X a_116_82# VSS VSS sg13_lv_nmos ad=0.1406p pd=1.12u as=0.1406p ps=1.12u w=0.74u l=0.13u
X38 VSS a_116_82# X VSS sg13_lv_nmos ad=0.1406p pd=1.12u as=0.1406p ps=1.12u w=0.74u l=0.13u
X39 X a_116_82# VDD VDD sg13_lv_pmos ad=0.2128p pd=1.5u as=0.2128p ps=1.5u w=1.12u l=0.13u
X40 VDD a_116_82# X VDD sg13_lv_pmos ad=0.2128p pd=1.5u as=0.2128p ps=1.5u w=1.12u l=0.13u
X41 X a_116_82# VSS VSS sg13_lv_nmos ad=0.1406p pd=1.12u as=0.1406p ps=1.12u w=0.74u l=0.13u
X42 X a_116_82# VDD VDD sg13_lv_pmos ad=0.2128p pd=1.5u as=0.2128p ps=1.5u w=1.12u l=0.13u
X43 VSS a_116_82# X VSS sg13_lv_nmos ad=0.1406p pd=1.12u as=0.1406p ps=1.12u w=0.74u l=0.13u
.ends

.subckt sg13cmos5l_ocd_ip__por vdd1v2 ena por_unbuf porb por vss
Xrhigh_MGZFWD_0 vss rhigh_MGZFWD_0/R1_1 por_amp_0/inn rhigh_MGZFWD_0/R1_1 rhigh_MGZFWD_0/R2_2
+ rhigh_MGZFWD_0/R1_3 rhigh_MGZFWD_0/R2_2 rhigh_MGZFWD_0/R1_3 rhigh_MGZFWD_0/R2_4
+ rhigh_MGZFWD_0/R1_5 rhigh_MGZFWD_0/R2_4 rhigh_MGZFWD_0/R1_5 rhigh_MGZFWD_0/R2_6
+ rhigh_MGZFWD_0/R1_7 rhigh_MGZFWD_0/R2_6 rhigh_MGZFWD_0/R1_7 rhigh_MGZFWD_0/R2_8
+ rhigh_MGZFWD_0/R1_9 rhigh_MGZFWD_0/R2_8 rhigh_MGZFWD_0/R1_9 rhigh_MGZFWD_0/R2_9
+ rhigh_MGZFWD_0/R1_11 rhigh_MGZFWD_0/R2_9 rhigh_MGZFWD_0/R1_11 rhigh_MGZFWD_0/R2_12
+ rhigh_MGZFWD_0/R1_13 rhigh_MGZFWD_0/R2_12 rhigh_MGZFWD_0/R1_13 rhigh_MGZFWD_0/R2_14
+ rhigh_MGZFWD_0/R1_15 rhigh_MGZFWD_0/R2_14 rhigh_MGZFWD_0/R1_15 rhigh_MGZFWD_0/R2_16
+ rhigh_MGZFWD_0/R1_17 rhigh_MGZFWD_0/R2_16 rhigh_MGZFWD_0/R1_17 rhigh_MGZFWD_0/R2_18
+ rhigh_MGZFWD_0/R1_19 rhigh_MGZFWD_0/R2_18 rhigh_MGZFWD_0/R1_19 rhigh_MGZFWD_0/R2_20
+ rhigh_MGZFWD_0/R1_21 rhigh_MGZFWD_0/R2_20 rhigh_MGZFWD_0/R1_21 rhigh_MGZFWD_0/R2_22
+ rhigh_MGZFWD_0/R1_23 rhigh_MGZFWD_0/R2_22 rhigh_MGZFWD_0/R1_23 rhigh_MGZFWD_0/R2_24
+ rhigh_MGZFWD_0/R1_25 rhigh_MGZFWD_0/R2_24 rhigh_MGZFWD_0/R1_25 rhigh_MGZFWD_0/R2_26
+ rhigh_MGZFWD_0/R1_27 rhigh_MGZFWD_0/R2_26 rhigh_MGZFWD_0/R1_27 rhigh_MGZFWD_0/R2_28
+ rhigh_MGZFWD_0/R1_29 rhigh_MGZFWD_0/R2_28 rhigh_MGZFWD_0/R1_29 rhigh_MGZFWD_0/R2_30
+ rhigh_MGZFWD_0/R1_31 rhigh_MGZFWD_0/R2_30 rhigh_MGZFWD_0/R1_31 rhigh_MGZFWD_0/R2_32
+ rhigh_MGZFWD_0/R1_33 rhigh_MGZFWD_0/R2_32 rhigh_MGZFWD_0/R1_33 rhigh_MGZFWD_0/R2_34
+ rhigh_MGZFWD_0/R1_35 rhigh_MGZFWD_0/R2_34 rhigh_MGZFWD_0/R1_35 rhigh_MGZFWD_0/R2_36
+ rhigh_MGZFWD_0/R1_37 rhigh_MGZFWD_0/R2_36 rhigh_MGZFWD_0/R1_37 rhigh_MGZFWD_0/R2_38
+ rhigh_MGZFWD_0/R1_39 rhigh_MGZFWD_0/R2_38 rhigh_MGZFWD_0/R1_39 rhigh_MGZFWD_0/R2_40
+ rhigh_MGZFWD_0/R1_41 rhigh_MGZFWD_0/R2_40 rhigh_MGZFWD_0/R1_41 rhigh_MGZFWD_0/R2_42
+ rhigh_MGZFWD_0/R1_43 rhigh_MGZFWD_0/R2_42 rhigh_MGZFWD_0/R1_43 rhigh_MGZFWD_0/R2_44
+ rhigh_MGZFWD_0/R1_45 rhigh_MGZFWD_0/R2_44 rhigh_MGZFWD_0/R1_45 rhigh_MGZFWD_0/R2_46
+ rhigh_MGZFWD_0/R1_47 rhigh_MGZFWD_0/R2_46 rhigh_MGZFWD_0/R1_47 rhigh_MGZFWD_0/R2_48
+ rhigh_MGZFWD_0/R1_49 rhigh_MGZFWD_0/R2_48 rhigh_MGZFWD_0/R1_49 rhigh_MGZFWD_0/R2_50
+ rhigh_MGZFWD_0/R1_51 rhigh_MGZFWD_0/R2_50 rhigh_MGZFWD_0/R1_51 rhigh_MGZFWD_0/R2_52
+ rhigh_MGZFWD_0/R1_53 rhigh_MGZFWD_0/R2_52 rhigh_MGZFWD_0/R1_53 vdd1v2 rhigh_MGZFWD
Xrhigh_MGZFWD_1 vss por_amp_0/inp rhigh_MGZFWD_1/R2_1 rhigh_MGZFWD_1/R1_2 rhigh_MGZFWD_1/R2_1
+ rhigh_MGZFWD_1/R1_2 rhigh_MGZFWD_1/R2_3 rhigh_MGZFWD_1/R1_4 rhigh_MGZFWD_1/R2_3
+ rhigh_MGZFWD_1/R1_4 rhigh_MGZFWD_1/R2_5 rhigh_MGZFWD_1/R1_6 rhigh_MGZFWD_1/R2_5
+ rhigh_MGZFWD_1/R1_6 rhigh_MGZFWD_1/R2_7 rhigh_MGZFWD_1/R1_8 rhigh_MGZFWD_1/R2_7
+ rhigh_MGZFWD_1/R1_8 rhigh_MGZFWD_1/R2_9 rhigh_MGZFWD_1/R1_9 rhigh_MGZFWD_1/R2_9
+ rhigh_MGZFWD_1/R1_9 rhigh_MGZFWD_1/R2_11 rhigh_MGZFWD_1/R1_12 rhigh_MGZFWD_1/R2_11
+ rhigh_MGZFWD_1/R1_12 rhigh_MGZFWD_1/R2_13 rhigh_MGZFWD_1/R1_14 rhigh_MGZFWD_1/R2_13
+ rhigh_MGZFWD_1/R1_14 rhigh_MGZFWD_1/R2_15 rhigh_MGZFWD_1/R1_16 rhigh_MGZFWD_1/R2_15
+ rhigh_MGZFWD_1/R1_16 rhigh_MGZFWD_1/R2_17 rhigh_MGZFWD_1/R1_18 rhigh_MGZFWD_1/R2_17
+ rhigh_MGZFWD_1/R1_18 rhigh_MGZFWD_1/R2_19 rhigh_MGZFWD_1/R1_20 rhigh_MGZFWD_1/R2_19
+ rhigh_MGZFWD_1/R1_20 rhigh_MGZFWD_1/R2_21 rhigh_MGZFWD_1/R1_22 rhigh_MGZFWD_1/R2_21
+ rhigh_MGZFWD_1/R1_22 rhigh_MGZFWD_1/R2_23 rhigh_MGZFWD_1/R1_24 rhigh_MGZFWD_1/R2_23
+ rhigh_MGZFWD_1/R1_24 rhigh_MGZFWD_1/R2_25 rhigh_MGZFWD_1/R1_26 rhigh_MGZFWD_1/R2_25
+ rhigh_MGZFWD_1/R1_26 rhigh_MGZFWD_1/R2_27 rhigh_MGZFWD_1/R1_28 rhigh_MGZFWD_1/R2_27
+ rhigh_MGZFWD_1/R1_28 rhigh_MGZFWD_1/R2_29 rhigh_MGZFWD_1/R1_30 rhigh_MGZFWD_1/R2_29
+ rhigh_MGZFWD_1/R1_30 rhigh_MGZFWD_1/R2_31 rhigh_MGZFWD_1/R1_32 rhigh_MGZFWD_1/R2_31
+ rhigh_MGZFWD_1/R1_32 rhigh_MGZFWD_1/R2_33 rhigh_MGZFWD_1/R1_34 rhigh_MGZFWD_1/R2_33
+ rhigh_MGZFWD_1/R1_34 rhigh_MGZFWD_1/R2_35 rhigh_MGZFWD_1/R1_36 rhigh_MGZFWD_1/R2_35
+ rhigh_MGZFWD_1/R1_36 rhigh_MGZFWD_1/R2_37 rhigh_MGZFWD_1/R1_38 rhigh_MGZFWD_1/R2_37
+ rhigh_MGZFWD_1/R1_38 rhigh_MGZFWD_1/R2_39 rhigh_MGZFWD_1/R1_40 rhigh_MGZFWD_1/R2_39
+ rhigh_MGZFWD_1/R1_40 rhigh_MGZFWD_1/R2_41 rhigh_MGZFWD_1/R1_42 rhigh_MGZFWD_1/R2_41
+ rhigh_MGZFWD_1/R1_42 rhigh_MGZFWD_1/R2_43 rhigh_MGZFWD_1/R1_44 rhigh_MGZFWD_1/R2_43
+ rhigh_MGZFWD_1/R1_44 rhigh_MGZFWD_1/R2_45 rhigh_MGZFWD_1/R1_46 rhigh_MGZFWD_1/R2_45
+ rhigh_MGZFWD_1/R1_46 rhigh_MGZFWD_1/R2_47 rhigh_MGZFWD_1/R1_48 rhigh_MGZFWD_1/R2_47
+ rhigh_MGZFWD_1/R1_48 rhigh_MGZFWD_1/R2_49 rhigh_MGZFWD_1/R1_50 rhigh_MGZFWD_1/R2_49
+ rhigh_MGZFWD_1/R1_50 rhigh_MGZFWD_1/R2_51 rhigh_MGZFWD_1/R1_52 rhigh_MGZFWD_1/R2_51
+ rhigh_MGZFWD_1/R1_52 rhigh_MGZFWD_1/R2_53 vss rhigh_MGZFWD_1/R2_53 rhigh_MGZFWD
Xpor_stepdown_0 por_amp_0/inn por_amp_0/nbias por_amp_0/out por_amp_0/inp por_stepdown_0/vcap
+ vss vdd1v2 por_stepdown
Xcap_cmomf_MKAUQG_0[0] por_stepdown_0/vcap vss cap_cmomf_MKAUQG
Xcap_cmomf_MKAUQG_0[1] por_stepdown_0/vcap vss cap_cmomf_MKAUQG
Xcap_cmomf_MKAUQG_0[2] por_stepdown_0/vcap vss cap_cmomf_MKAUQG
Xcap_cmomf_MKAUQG_0[3] por_stepdown_0/vcap vss cap_cmomf_MKAUQG
Xcap_cmomf_MKAUQG_0[4] por_stepdown_0/vcap vss cap_cmomf_MKAUQG
Xcap_cmomf_MKAUQG_0[5] por_stepdown_0/vcap vss cap_cmomf_MKAUQG
Xcap_cmomf_MKAUQG_0[6] por_stepdown_0/vcap vss cap_cmomf_MKAUQG
Xcap_cmomf_MKAUQG_0[7] por_stepdown_0/vcap vss cap_cmomf_MKAUQG
Xcap_cmomf_MKAUQG_1[0] por_stepdown_0/vcap vss cap_cmomf_MKAUQG
Xcap_cmomf_MKAUQG_1[1] por_stepdown_0/vcap vss cap_cmomf_MKAUQG
Xcap_cmomf_MKAUQG_1[2] por_stepdown_0/vcap vss cap_cmomf_MKAUQG
Xcap_cmomf_MKAUQG_1[3] por_stepdown_0/vcap vss cap_cmomf_MKAUQG
Xcap_cmomf_MKAUQG_1[4] por_stepdown_0/vcap vss cap_cmomf_MKAUQG
Xcap_cmomf_MKAUQG_1[5] por_stepdown_0/vcap vss cap_cmomf_MKAUQG
Xcap_cmomf_MKAUQG_1[6] por_stepdown_0/vcap vss cap_cmomf_MKAUQG
Xcap_cmomf_MKAUQG_1[7] por_stepdown_0/vcap vss cap_cmomf_MKAUQG
Xcap_cmomf_7YMNSS_0 por_amp_0/inn por_amp_0/out cap_cmomf_7YMNSS
Xdantenna_WMFCS7_0 vss ena dantenna_WMFCS7
Xcap_cmomf_7YMNSS_1 vss vdd1v2 cap_cmomf_7YMNSS
Xpor_1v2_schmitt_inv_0 vdd1v2 por_stepdown_0/vcap por_unbuf vss por_1v2_schmitt_inv
Xcap_cmomf_T2STT2_0 vss vss por_stepdown_0/vcap cap_cmomf_T2STT2
Xcap_cmomf_T2STT2_1 vss por_stepdown_0/vcap vss cap_cmomf_T2STT2
Xsg13cmos5l_decap_4_0 vdd1v2 vss sg13cmos5l_decap_4
Xpor_amp_0 vdd1v2 por_amp_0/inp ena por_amp_0/nbias por_amp_0/out por_amp_0/inn vss
+ por_amp
Xsg13cmos5l_inv_4_0 sg13cmos5l_inv_4_0/Y por_unbuf vdd1v2 vss sg13cmos5l_inv_4
Xsg13cmos5l_buf_16_0 por por_unbuf vdd1v2 vss sg13cmos5l_buf_16
Xsg13cmos5l_buf_16_1 porb sg13cmos5l_inv_4_0/Y vdd1v2 vss sg13cmos5l_buf_16
.ends

* Black-box entry subcircuit for slot7_wrapper abstract view
.subckt slot7_wrapper vss_1v2 s7_an[0] s7_an[1] s7_an_0_esd vbias dig_in[23] dig_in[22]
+ dig_in[21] dig_in[20] dig_in[19] dig_in[18] dig_in[17] dig_in[16] dig_in[15] dig_in[14]
+ dig_in[13] dig_in[12] dig_in[11] dig_in[10] dig_in[9] dig_in[8] dig_in[7] dig_in[6]
+ dig_in[5] dig_in[4] dig_in[3] dig_in[2] dig_in[1] dig_in[0] dig_out[11] dig_out[10]
+ dig_out[9] dig_out[8] dig_out[7] dig_out[6] dig_out[5] dig_out[4] dig_out[3] dig_out[2]
+ dig_out[1] dig_out[0] ibias0 ibias1 analog_bus3 analog_bus2 analog_bus1 analog_bus0
+ vdd_1v2 vss_3v3 vdd_3v3 enable clk reset
.ends

* Black-box entry subcircuit for slot11_wrapper abstract view
.subckt slot11_wrapper vss_1v2 s11_an[0] s11_an_0_esd vbias dig_in[23] dig_in[22]
+ dig_in[21] dig_in[20] dig_in[19] dig_in[18] dig_in[17] dig_in[16] dig_in[15] dig_in[14]
+ dig_in[13] dig_in[12] dig_in[11] dig_in[10] dig_in[9] dig_in[8] dig_in[7] dig_in[6]
+ dig_in[5] dig_in[4] dig_in[3] dig_in[2] dig_in[1] dig_in[0] dig_out[11] dig_out[10]
+ dig_out[9] dig_out[8] dig_out[7] dig_out[6] dig_out[5] dig_out[4] dig_out[3] dig_out[2]
+ dig_out[1] dig_out[0] ibias0 ibias1 analog_bus3 analog_bus2 analog_bus1 analog_bus0
+ vdd_1v2 vss_3v3 vdd_3v3 enable clk reset
.ends

* Black-box entry subcircuit for slot15_wrapper abstract view
.subckt slot15_wrapper vss_3v3 s15_an[0] s15_an_0_esd vbias dig_in[23] dig_in[22]
+ dig_in[21] dig_in[20] dig_in[19] dig_in[18] dig_in[17] dig_in[16] dig_in[15] dig_in[14]
+ dig_in[13] dig_in[12] dig_in[11] dig_in[10] dig_in[9] dig_in[8] dig_in[7] dig_in[6]
+ dig_in[5] dig_in[4] dig_in[3] dig_in[2] dig_in[1] dig_in[0] dig_out[11] dig_out[10]
+ dig_out[9] dig_out[8] dig_out[7] dig_out[6] dig_out[5] dig_out[4] dig_out[3] dig_out[2]
+ dig_out[1] dig_out[0] ibias0 ibias1 analog_bus3 analog_bus2 analog_bus1 analog_bus0
+ vss_1v2 vdd_1v2 vdd_3v3 enable clk reset
.ends

.subckt capacitor_KK7B53 c1 c2
X0 c1 c2 cap_cmomf mm_ok=1 subblock=0 mmax=4 mmin=1 l=23u w=8u
.ends

.subckt sg13_hv_pmos_CVGX38 D S G w_n232_n305#
X0 S G D w_n232_n305# sg13_hv_pmos ad=0.68p pd=4.68u as=0.68p ps=4.68u w=2u l=0.4u
.ends

.subckt sg13_hv_nmos_83DLAQ D S G sub
X0 S G D sub sg13_hv_nmos ad=0.34p pd=2.68u as=0.34p ps=2.68u w=1u l=0.45u
.ends

.subckt hv_inv_1 vdd X vss A
XXM1 X vdd A vdd sg13_hv_pmos_CVGX38
XXM2 vss X A vss sg13_hv_nmos_83DLAQ
.ends

.subckt sg13_hv_pmos_NNMDLU D0 S0 G0 D1 S1 G1 D2 S2 G2 D3 S3 G3 w_n292_n2006#
X0 S2 G2 D2 w_n292_n2006# sg13_hv_pmos ad=1.36p pd=8.68u as=1.36p ps=8.68u w=4u l=1u
X1 S1 G1 D1 w_n292_n2006# sg13_hv_pmos ad=1.36p pd=8.68u as=1.36p ps=8.68u w=4u l=1u
X2 S0 G0 D0 w_n292_n2006# sg13_hv_pmos ad=1.36p pd=8.68u as=1.36p ps=8.68u w=4u l=1u
X3 S3 G3 D3 w_n292_n2006# sg13_hv_pmos ad=1.36p pd=8.68u as=1.36p ps=8.68u w=4u l=1u
.ends

.subckt sg13_hv_pmos_ZKTCY2 D0 S0 G0 D1 S1 G1 D2 S2 G2 D3 S3 G3 D4 S4 G4 D5 S5 G5
+ D6 S6 G6 D7 S7 G7 D8 S8 G8 D9 S9 G9 D10 S10 G10 D11 S11 G11 D12 S12 G12 D13 S13
+ G13 D14 S14 G14 D15 S15 G15 w_n3127_n224#
X0 D7 G7 S7 w_n3127_n224# sg13_hv_pmos ad=0.34p pd=2.68u as=0.34p ps=2.68u w=1u l=1u
X1 D15 G15 S15 w_n3127_n224# sg13_hv_pmos ad=0.34p pd=2.68u as=0.34p ps=2.68u w=1u l=1u
X2 S8 G8 D8 w_n3127_n224# sg13_hv_pmos ad=0.34p pd=2.68u as=0.34p ps=2.68u w=1u l=1u
X3 S14 G14 D14 w_n3127_n224# sg13_hv_pmos ad=0.34p pd=2.68u as=0.34p ps=2.68u w=1u l=1u
X4 S0 G0 D0 w_n3127_n224# sg13_hv_pmos ad=0.34p pd=2.68u as=0.34p ps=2.68u w=1u l=1u
X5 D1 G1 S1 w_n3127_n224# sg13_hv_pmos ad=0.34p pd=2.68u as=0.34p ps=2.68u w=1u l=1u
X6 S2 G2 D2 w_n3127_n224# sg13_hv_pmos ad=0.34p pd=2.68u as=0.34p ps=2.68u w=1u l=1u
X7 D13 G13 S13 w_n3127_n224# sg13_hv_pmos ad=0.34p pd=2.68u as=0.34p ps=2.68u w=1u l=1u
X8 S10 G10 D10 w_n3127_n224# sg13_hv_pmos ad=0.34p pd=2.68u as=0.34p ps=2.68u w=1u l=1u
X9 S12 G12 D12 w_n3127_n224# sg13_hv_pmos ad=0.34p pd=2.68u as=0.34p ps=2.68u w=1u l=1u
X10 D9 G9 S9 w_n3127_n224# sg13_hv_pmos ad=0.34p pd=2.68u as=0.34p ps=2.68u w=1u l=1u
X11 D11 G11 S11 w_n3127_n224# sg13_hv_pmos ad=0.34p pd=2.68u as=0.34p ps=2.68u w=1u l=1u
X12 D3 G3 S3 w_n3127_n224# sg13_hv_pmos ad=0.34p pd=2.68u as=0.34p ps=2.68u w=1u l=1u
X13 S4 G4 D4 w_n3127_n224# sg13_hv_pmos ad=0.34p pd=2.68u as=0.34p ps=2.68u w=1u l=1u
X14 D5 G5 S5 w_n3127_n224# sg13_hv_pmos ad=0.34p pd=2.68u as=0.34p ps=2.68u w=1u l=1u
X15 S6 G6 D6 w_n3127_n224# sg13_hv_pmos ad=0.34p pd=2.68u as=0.34p ps=2.68u w=1u l=1u
.ends

.subckt sg13_hv_pmos_NWNELU D0_0 S0_0 G0_0 D0_1 S0_1 G0_1 D0_2 S0_2 G0_2 D0_3 S0_3
+ G0_3 D1_0 S1_0 G1_0 D1_1 S1_1 G1_1 D1_2 S1_2 G1_2 D1_3 S1_3 G1_3 w_n481_n2006#
X0 S0_0 G0_0 D0_0 w_n481_n2006# sg13_hv_pmos ad=1.36p pd=8.68u as=1.36p ps=8.68u w=4u l=1u
X1 S0_2 G0_2 D0_2 w_n481_n2006# sg13_hv_pmos ad=1.36p pd=8.68u as=1.36p ps=8.68u w=4u l=1u
X2 S0_1 G0_1 D0_1 w_n481_n2006# sg13_hv_pmos ad=1.36p pd=8.68u as=1.36p ps=8.68u w=4u l=1u
X3 D1_1 G1_1 S1_1 w_n481_n2006# sg13_hv_pmos ad=1.36p pd=8.68u as=1.36p ps=8.68u w=4u l=1u
X4 D1_0 G1_0 S1_0 w_n481_n2006# sg13_hv_pmos ad=1.36p pd=8.68u as=1.36p ps=8.68u w=4u l=1u
X5 D1_2 G1_2 S1_2 w_n481_n2006# sg13_hv_pmos ad=1.36p pd=8.68u as=1.36p ps=8.68u w=4u l=1u
X6 D1_3 G1_3 S1_3 w_n481_n2006# sg13_hv_pmos ad=1.36p pd=8.68u as=1.36p ps=8.68u w=4u l=1u
X7 S0_3 G0_3 D0_3 w_n481_n2006# sg13_hv_pmos ad=1.36p pd=8.68u as=1.36p ps=8.68u w=4u l=1u
.ends

.subckt sg13_hv_nmos_XAAXMC D0 S0 G0 D1 S1 G1 D2 S2 G2 D3 S3 G3 D4 S4 G4 D5 S5 G5
+ D6 S6 G6 D7 S7 G7 D8 S8 G8 D9 S9 G9 D10 S10 G10 D11 S11 G11 D12 S12 G12 D13 S13
+ G13 D14 S14 G14 D15 S15 G15 sub
X0 D15 G15 S15 sub sg13_hv_nmos ad=0.34p pd=2.68u as=0.34p ps=2.68u w=1u l=1u
X1 S8 G8 D8 sub sg13_hv_nmos ad=0.34p pd=2.68u as=0.34p ps=2.68u w=1u l=1u
X2 S14 G14 D14 sub sg13_hv_nmos ad=0.34p pd=2.68u as=0.34p ps=2.68u w=1u l=1u
X3 S0 G0 D0 sub sg13_hv_nmos ad=0.34p pd=2.68u as=0.34p ps=2.68u w=1u l=1u
X4 D1 G1 S1 sub sg13_hv_nmos ad=0.34p pd=2.68u as=0.34p ps=2.68u w=1u l=1u
X5 S2 G2 D2 sub sg13_hv_nmos ad=0.34p pd=2.68u as=0.34p ps=2.68u w=1u l=1u
X6 D13 G13 S13 sub sg13_hv_nmos ad=0.34p pd=2.68u as=0.34p ps=2.68u w=1u l=1u
X7 S10 G10 D10 sub sg13_hv_nmos ad=0.34p pd=2.68u as=0.34p ps=2.68u w=1u l=1u
X8 S12 G12 D12 sub sg13_hv_nmos ad=0.34p pd=2.68u as=0.34p ps=2.68u w=1u l=1u
X9 D9 G9 S9 sub sg13_hv_nmos ad=0.34p pd=2.68u as=0.34p ps=2.68u w=1u l=1u
X10 D11 G11 S11 sub sg13_hv_nmos ad=0.34p pd=2.68u as=0.34p ps=2.68u w=1u l=1u
X11 D3 G3 S3 sub sg13_hv_nmos ad=0.34p pd=2.68u as=0.34p ps=2.68u w=1u l=1u
X12 S4 G4 D4 sub sg13_hv_nmos ad=0.34p pd=2.68u as=0.34p ps=2.68u w=1u l=1u
X13 D5 G5 S5 sub sg13_hv_nmos ad=0.34p pd=2.68u as=0.34p ps=2.68u w=1u l=1u
X14 S6 G6 D6 sub sg13_hv_nmos ad=0.34p pd=2.68u as=0.34p ps=2.68u w=1u l=1u
X15 D7 G7 S7 sub sg13_hv_nmos ad=0.34p pd=2.68u as=0.34p ps=2.68u w=1u l=1u
.ends

.subckt sg13_hv_nmos_TYJME3 D0 S0 G0 D1 S1 G1 D2 S2 G2 D3 S3 G3 D4 S4 G4 D5 S5 G5
+ D6 S6 G6 D7 S7 G7 sub
X0 S4 G4 D4 sub sg13_hv_nmos ad=0.34p pd=2.68u as=0.34p ps=2.68u w=1u l=4u
X1 S0 G0 D0 sub sg13_hv_nmos ad=0.34p pd=2.68u as=0.34p ps=2.68u w=1u l=4u
X2 D1 G1 S1 sub sg13_hv_nmos ad=0.34p pd=2.68u as=0.34p ps=2.68u w=1u l=4u
X3 D3 G3 S3 sub sg13_hv_nmos ad=0.34p pd=2.68u as=0.34p ps=2.68u w=1u l=4u
X4 S2 G2 D2 sub sg13_hv_nmos ad=0.34p pd=2.68u as=0.34p ps=2.68u w=1u l=4u
X5 D7 G7 S7 sub sg13_hv_nmos ad=0.34p pd=2.68u as=0.34p ps=2.68u w=1u l=4u
X6 S6 G6 D6 sub sg13_hv_nmos ad=0.34p pd=2.68u as=0.34p ps=2.68u w=1u l=4u
X7 D5 G5 S5 sub sg13_hv_nmos ad=0.34p pd=2.68u as=0.34p ps=2.68u w=1u l=4u
.ends

.subckt sg13_hv_pmos_H5F6DG D0_0 S0_0 G0_0 D0_1 S0_1 G0_1 D1_0 S1_0 G1_0 D1_1 S1_1
+ G1_1 w_n1081_n618#
X0 S0_0 G0_0 D0_0 w_n1081_n618# sg13_hv_pmos ad=0.68p pd=4.68u as=0.68p ps=4.68u w=2u l=4u
X1 D1_1 G1_1 S1_1 w_n1081_n618# sg13_hv_pmos ad=0.68p pd=4.68u as=0.68p ps=4.68u w=2u l=4u
X2 D1_0 G1_0 S1_0 w_n1081_n618# sg13_hv_pmos ad=0.68p pd=4.68u as=0.68p ps=4.68u w=2u l=4u
X3 S0_1 G0_1 D0_1 w_n1081_n618# sg13_hv_pmos ad=0.68p pd=4.68u as=0.68p ps=4.68u w=2u l=4u
.ends

.subckt sg13_hv_pmos_HLS6DG D0 S0 G0 D1 S1 G1 D2 S2 G2 D3 S3 G3 D4 S4 G4 D5 S5 G5
+ D6 S6 G6 D7 S7 G7 w_n4015_n324#
X0 S2 G2 D2 w_n4015_n324# sg13_hv_pmos ad=0.68p pd=4.68u as=0.68p ps=4.68u w=2u l=4u
X1 D1 G1 S1 w_n4015_n324# sg13_hv_pmos ad=0.68p pd=4.68u as=0.68p ps=4.68u w=2u l=4u
X2 S0 G0 D0 w_n4015_n324# sg13_hv_pmos ad=0.68p pd=4.68u as=0.68p ps=4.68u w=2u l=4u
X3 D3 G3 S3 w_n4015_n324# sg13_hv_pmos ad=0.68p pd=4.68u as=0.68p ps=4.68u w=2u l=4u
X4 S4 G4 D4 w_n4015_n324# sg13_hv_pmos ad=0.68p pd=4.68u as=0.68p ps=4.68u w=2u l=4u
X5 D5 G5 S5 w_n4015_n324# sg13_hv_pmos ad=0.68p pd=4.68u as=0.68p ps=4.68u w=2u l=4u
X6 S6 G6 D6 w_n4015_n324# sg13_hv_pmos ad=0.68p pd=4.68u as=0.68p ps=4.68u w=2u l=4u
X7 D7 G7 S7 w_n4015_n324# sg13_hv_pmos ad=0.68p pd=4.68u as=0.68p ps=4.68u w=2u l=4u
.ends

.subckt sg13_hv_pmos_NQUDLU D0 S0 G0 D1 S1 G1 D2 S2 G2 D3 S3 G3 w_n859_n224#
X0 D1 G1 S1 w_n859_n224# sg13_hv_pmos ad=0.34p pd=2.68u as=0.34p ps=2.68u w=1u l=1u
X1 S2 G2 D2 w_n859_n224# sg13_hv_pmos ad=0.34p pd=2.68u as=0.34p ps=2.68u w=1u l=1u
X2 D3 G3 S3 w_n859_n224# sg13_hv_pmos ad=0.34p pd=2.68u as=0.34p ps=2.68u w=1u l=1u
X3 S0 G0 D0 w_n859_n224# sg13_hv_pmos ad=0.34p pd=2.68u as=0.34p ps=2.68u w=1u l=1u
.ends

.subckt sg13_hv_nmos_TGUME3 D0_0 S0_0 G0_0 D0_1 S0_1 G0_1 D1_0 S1_0 G1_0 D1_1 S1_1
+ G1_1 sub
X0 D1_0 G1_0 S1_0 sub sg13_hv_nmos ad=0.34p pd=2.68u as=0.34p ps=2.68u w=1u l=4u
X1 D1_1 G1_1 S1_1 sub sg13_hv_nmos ad=0.34p pd=2.68u as=0.34p ps=2.68u w=1u l=4u
X2 S0_1 G0_1 D0_1 sub sg13_hv_nmos ad=0.34p pd=2.68u as=0.34p ps=2.68u w=1u l=4u
X3 S0_0 G0_0 D0_0 sub sg13_hv_nmos ad=0.34p pd=2.68u as=0.34p ps=2.68u w=1u l=4u
.ends

.subckt sg13_hv_nmos_BE9VUZ D0_0 S0_0 G0_0 D0_1 S0_1 G0_1 D1_0 S1_0 G1_0 D1_1 S1_1
+ G1_1 sub
X0 D1_0 G1_0 S1_0 sub sg13_hv_nmos ad=0.34p pd=2.68u as=0.34p ps=2.68u w=1u l=1u
X1 S0_1 G0_1 D0_1 sub sg13_hv_nmos ad=0.34p pd=2.68u as=0.34p ps=2.68u w=1u l=1u
X2 S0_0 G0_0 D0_0 sub sg13_hv_nmos ad=0.34p pd=2.68u as=0.34p ps=2.68u w=1u l=1u
X3 D1_1 G1_1 S1_1 sub sg13_hv_nmos ad=0.34p pd=2.68u as=0.34p ps=2.68u w=1u l=1u
.ends

.subckt sg13_hv_nmos_BEMUUZ D0_0 S0_0 G0_0 D0_1 S0_1 G0_1 D1_0 S1_0 G1_0 D1_1 S1_1
+ G1_1 D2_0 S2_0 G2_0 D2_1 S2_1 G2_1 sub
X0 D1_0 G1_0 S1_0 sub sg13_hv_nmos ad=0.34p pd=2.68u as=0.34p ps=2.68u w=1u l=1u
X1 D1_1 G1_1 S1_1 sub sg13_hv_nmos ad=0.34p pd=2.68u as=0.34p ps=2.68u w=1u l=1u
X2 S0_0 G0_0 D0_0 sub sg13_hv_nmos ad=0.34p pd=2.68u as=0.34p ps=2.68u w=1u l=1u
X3 S2_1 G2_1 D2_1 sub sg13_hv_nmos ad=0.34p pd=2.68u as=0.34p ps=2.68u w=1u l=1u
X4 S0_1 G0_1 D0_1 sub sg13_hv_nmos ad=0.34p pd=2.68u as=0.34p ps=2.68u w=1u l=1u
X5 S2_0 G2_0 D2_0 sub sg13_hv_nmos ad=0.34p pd=2.68u as=0.34p ps=2.68u w=1u l=1u
.ends

.subckt sg13_hv_pmos_N8UDLU D0 S0 G0 D1 S1 G1 w_n481_n224#
X0 S0 G0 D0 w_n481_n224# sg13_hv_pmos ad=0.34p pd=2.68u as=0.34p ps=2.68u w=1u l=1u
X1 D1 G1 S1 w_n481_n224# sg13_hv_pmos ad=0.34p pd=2.68u as=0.34p ps=2.68u w=1u l=1u
.ends

.subckt sg13_hv_nmos_BEDTUZ D0_0 S0_0 G0_0 D0_1 S0_1 G0_1 D1_0 S1_0 G1_0 D1_1 S1_1
+ G1_1 D2_0 S2_0 G2_0 D2_1 S2_1 G2_1 D3_0 S3_0 G3_0 D3_1 S3_1 G3_1 D4_0 S4_0 G4_0
+ D4_1 S4_1 G4_1 sub
X0 S2_0 G2_0 D2_0 sub sg13_hv_nmos ad=0.34p pd=2.68u as=0.34p ps=2.68u w=1u l=1u
X1 S2_1 G2_1 D2_1 sub sg13_hv_nmos ad=0.34p pd=2.68u as=0.34p ps=2.68u w=1u l=1u
X2 S4_1 G4_1 D4_1 sub sg13_hv_nmos ad=0.34p pd=2.68u as=0.34p ps=2.68u w=1u l=1u
X3 S0_1 G0_1 D0_1 sub sg13_hv_nmos ad=0.34p pd=2.68u as=0.34p ps=2.68u w=1u l=1u
X4 D1_0 G1_0 S1_0 sub sg13_hv_nmos ad=0.34p pd=2.68u as=0.34p ps=2.68u w=1u l=1u
X5 S0_0 G0_0 D0_0 sub sg13_hv_nmos ad=0.34p pd=2.68u as=0.34p ps=2.68u w=1u l=1u
X6 D3_1 G3_1 S3_1 sub sg13_hv_nmos ad=0.34p pd=2.68u as=0.34p ps=2.68u w=1u l=1u
X7 D1_1 G1_1 S1_1 sub sg13_hv_nmos ad=0.34p pd=2.68u as=0.34p ps=2.68u w=1u l=1u
X8 D3_0 G3_0 S3_0 sub sg13_hv_nmos ad=0.34p pd=2.68u as=0.34p ps=2.68u w=1u l=1u
X9 S4_0 G4_0 D4_0 sub sg13_hv_nmos ad=0.34p pd=2.68u as=0.34p ps=2.68u w=1u l=1u
.ends

.subckt se_folded_cascode_p out bias ena_b inn inp vdd vss
XXM3DUM vdd vdd vdd vdd vdd vdd vdd vdd vdd vdd vdd vdd vdd sg13_hv_pmos_NNMDLU
XXM1 vdd XM1/S8 vbp1 XM1/S8 vdd vbp1 vdd XM1/S8 vbp1 XM1/S8 vdd vbp1 vdd XM1/S8 vbp1
+ XM1/S8 vdd vbp1 vdd XM1/S8 vbp1 XM1/S8 vdd vbp1 vdd XM1/S8 vbp1 XM1/S8 vdd vbp1
+ vdd XM1/S8 vbp1 XM1/S8 vdd vbp1 vdd XM1/S8 vbp1 XM1/S8 vdd vbp1 vdd XM1/S8 vbp1
+ XM1/S8 vdd vbp1 vdd sg13_hv_pmos_ZKTCY2
XXM2 XM1/S8 out1n inp XM1/S8 out1p inn XM1/S8 out1n inp XM1/S8 out1p inn out1p XM1/S8
+ inn out1n XM1/S8 inp out1p XM1/S8 inn out1n XM1/S8 inp vdd sg13_hv_pmos_NWNELU
XXM3 XM1/S8 out1n inp XM1/S8 out1p inn XM1/S8 out1n inp XM1/S8 out1p inn out1p XM1/S8
+ inn out1n XM1/S8 inp out1p XM1/S8 inn out1n XM1/S8 inp vdd sg13_hv_pmos_NWNELU
XXM4 vss out1p vbn1 out1n vss vbn1 vss out1p vbn1 out1n vss vbn1 vss out1p vbn1 out1n
+ vss vbn1 vss out1p vbn1 out1n vss vbn1 vss out1p vbn1 out1n vss vbn1 vss out1p vbn1
+ out1n vss vbn1 vss out1p vbn1 out1n vss vbn1 vss out1p vbn1 out1n vss vbn1 vss sg13_hv_nmos_XAAXMC
XXM5 vss out1n vbn1 out1p vss vbn1 vss out1n vbn1 out1p vss vbn1 vss out1n vbn1 out1p
+ vss vbn1 vss out1n vbn1 out1p vss vbn1 vss out1n vbn1 out1p vss vbn1 vss out1n vbn1
+ out1p vss vbn1 vss out1n vbn1 out1p vss vbn1 vss out1n vbn1 out1p vss vbn1 vss sg13_hv_nmos_XAAXMC
XXM6 out1n XM9/S6 vbn2 out out1p vbn2 out1n XM9/S6 vbn2 out out1p vbn2 out1n XM9/S6
+ vbn2 out out1p vbn2 out1n XM9/S6 vbn2 out out1p vbn2 vss sg13_hv_nmos_TYJME3
XXM7 out1p out vbn2 XM9/S6 out1n vbn2 out1p out vbn2 XM9/S6 out1n vbn2 out1p out vbn2
+ XM9/S6 out1n vbn2 out1p out vbn2 XM9/S6 out1n vbn2 vss sg13_hv_nmos_TYJME3
XXMB1 vbp2 vbp1 vbp2 vbp2 vbp1 vbp2 vbp1 vbp2 vbp2 vbp1 vbp2 vbp2 vdd sg13_hv_pmos_H5F6DG
XXM8 XM9/S7 out vbp2 XM9/S6 XM9/D6 vbp2 XM9/S7 out vbp2 XM9/S6 XM9/D6 vbp2 XM9/S7
+ out vbp2 XM9/S6 XM9/D6 vbp2 XM9/S7 out vbp2 XM9/S6 XM9/D6 vbp2 vdd sg13_hv_pmos_HLS6DG
XXMB2 vdd vbp1 vbp1 vbn2 vdd vbp1 vdd vbp1 vbp1 vbn2 vdd vbp1 vdd sg13_hv_pmos_NQUDLU
XXM9 XM9/D6 XM9/S6 vbp2 out XM9/S7 vbp2 XM9/D6 XM9/S6 vbp2 out XM9/S7 vbp2 XM9/D6
+ XM9/S6 vbp2 out XM9/S7 vbp2 XM9/D6 XM9/S6 vbp2 out XM9/S7 vbp2 vdd sg13_hv_pmos_HLS6DG
XXMB3 vdd vbp1 vbp1 vbn2 vdd vbp1 vdd vbp1 vbp1 vbn2 vdd vbp1 vdd sg13_hv_pmos_NQUDLU
XXMB4 vbn2 vbn1 vbn2 vbn2 vbn1 vbn2 vbn1 vbn2 vbn2 vbn1 vbn2 vbn2 vss sg13_hv_nmos_TGUME3
XXMB5 vss vss vss vss vss vss vss vss vss vss vss vss vss sg13_hv_nmos_BE9VUZ
XXMB5DUM vss vbn1 vbn1 vss vbn1 vbn1 vbn1 vss vbn1 vbn1 vss vbn1 vss vss vss vss vss
+ vss vss sg13_hv_nmos_BEMUUZ
XXM1DUM vdd vdd vdd vdd vdd vdd vdd sg13_hv_pmos_N8UDLU
XXMB6 vbp2 bias ena_b vbp2 bias ena_b bias vbp2 ena_b bias vbp2 ena_b vdd sg13_hv_pmos_H5F6DG
XXM4DUM vss vss vss vss vss vss vss vss vss vss vss vss vss vss vss vss vss vss vss
+ vss vss vss vss vss vss vss vss vss vss vss vss sg13_hv_nmos_BEDTUZ
XXM10 XM9/S7 vdd XM9/S6 vdd XM9/D6 XM9/S6 XM9/S7 vdd XM9/S6 vdd XM9/D6 XM9/S6 XM9/S7
+ vdd XM9/S6 vdd XM9/D6 XM9/S6 XM9/S7 vdd XM9/S6 vdd XM9/D6 XM9/S6 vdd sg13_hv_pmos_HLS6DG
XXM2DUM vdd vdd vdd vdd vdd vdd vdd vdd vdd vdd vdd vdd vdd sg13_hv_pmos_NNMDLU
XXM11 XM9/D6 vdd XM9/S6 vdd XM9/S7 XM9/S6 XM9/D6 vdd XM9/S6 vdd XM9/S7 XM9/S6 XM9/D6
+ vdd XM9/S6 vdd XM9/S7 XM9/S6 XM9/D6 vdd XM9/S6 vdd XM9/S7 XM9/S6 vdd sg13_hv_pmos_HLS6DG
.ends

.subckt sg13_hv_pmos_XLVYT6 B D S G
X0 S G D B sg13_hv_pmos ad=0.68p pd=4.68u as=0.68p ps=4.68u w=2u l=0.5u
.ends

.subckt sg13_hv_nmos_MRZNPN B D S G
X0 S G D B sg13_hv_nmos ad=0.68p pd=4.68u as=0.68p ps=4.68u w=2u l=0.5u
.ends

.subckt xgate ena_b in out ena vss vdd
XXM1 vdd in out ena_b sg13_hv_pmos_XLVYT6
XXM2 vss in out ena sg13_hv_nmos_MRZNPN
.ends

.subckt rhigh_NFPZ4T B R1_0 R2_0 R1_1 R2_1 R1_2 R2_2 R1_3 R2_3 R1_4 R2_4 R1_5 R2_5
+ R1_6 R2_6 R1_7 R2_7 R1_8 R2_8 R1_9 R2_9
X0 R1_3 R2_3 B rhigh l=2.5u w=0.5u
X1 R1_6 R2_6 B rhigh l=2.5u w=0.5u
X2 R1_5 R2_5 B rhigh l=2.5u w=0.5u
X3 R1_2 R2_2 B rhigh l=2.5u w=0.5u
X4 R1_0 R2_0 B rhigh l=2.5u w=0.5u
X5 R1_9 R2_9 B rhigh l=2.5u w=0.5u
X6 R1_4 R2_4 B rhigh l=2.5u w=0.5u
X7 R1_7 R2_7 B rhigh l=2.5u w=0.5u
X8 R1_1 R2_1 B rhigh l=2.5u w=0.5u
X9 R1_8 R2_8 B rhigh l=2.5u w=0.5u
.ends

.subckt sg13_hv_pmos_QH8WBX B D S G
X0 S G D B sg13_hv_pmos ad=0.68p pd=4.68u as=0.68p ps=4.68u w=2u l=0.5u
.ends

.subckt sg13cmos5l_nand3_1 Y A B C VDD VSS
X0 Y C VDD VDD sg13_lv_pmos ad=0.2128p pd=1.5u as=0.3808p ps=2.92u w=1.12u l=0.13u
X1 VDD B Y VDD sg13_lv_pmos ad=0.2128p pd=1.5u as=0.2128p ps=1.5u w=1.12u l=0.13u
X2 Y A VDD VDD sg13_lv_pmos ad=0.3808p pd=2.92u as=0.2128p ps=1.5u w=1.12u l=0.13u
X3 a_146_122# C VSS VSS sg13_lv_nmos ad=0.1406p pd=1.12u as=0.2886p ps=2.26u w=0.74u l=0.13u
X4 a_248_122# B a_146_122# VSS sg13_lv_nmos ad=0.1406p pd=1.12u as=0.1406p ps=1.12u w=0.74u l=0.13u
X5 Y A a_248_122# VSS sg13_lv_nmos ad=0.2516p pd=2.16u as=0.1406p ps=1.12u w=0.74u l=0.13u
.ends

.subckt capacitor_BCZJG3 c1 c2
X0 c1 c2 cap_cmomf mm_ok=1 subblock=0 mmax=4 mmin=1 l=26.261u w=26.261u
.ends

.subckt sg13_hv_pmos_MW6CUW D0 G0 S1 G1 D2 G2 S3 G3 D4 G4 S5 G5 D6 G6 S7 G7 D8 G8
+ S9 G9 D10 G10 S11 G11 D12 G12 S13 G13 D14 G14 S15 G15 D16 G16 S17 G17 D18 G18 S19
+ G19 w_n1914_n224# a_1722_n100#
X0 D12 G11 S11 w_n1914_n224# sg13_hv_pmos ad=0.19p pd=1.38u as=0.19p ps=1.38u w=1u l=0.5u
X1 D4 G3 S3 w_n1914_n224# sg13_hv_pmos ad=0.19p pd=1.38u as=0.19p ps=1.38u w=1u l=0.5u
X2 S19 G18 D18 w_n1914_n224# sg13_hv_pmos ad=0.19p pd=1.38u as=0.19p ps=1.38u w=1u l=0.5u
X3 S5 G4 D4 w_n1914_n224# sg13_hv_pmos ad=0.19p pd=1.38u as=0.19p ps=1.38u w=1u l=0.5u
X4 S11 G10 D10 w_n1914_n224# sg13_hv_pmos ad=0.19p pd=1.38u as=0.19p ps=1.38u w=1u l=0.5u
X5 D14 G13 S13 w_n1914_n224# sg13_hv_pmos ad=0.19p pd=1.38u as=0.19p ps=1.38u w=1u l=0.5u
X6 a_1722_n100# G19 S19 w_n1914_n224# sg13_hv_pmos ad=0.34p pd=2.68u as=0.19p ps=1.38u w=1u l=0.5u
X7 S3 G2 D2 w_n1914_n224# sg13_hv_pmos ad=0.19p pd=1.38u as=0.19p ps=1.38u w=1u l=0.5u
X8 D10 G9 S9 w_n1914_n224# sg13_hv_pmos ad=0.19p pd=1.38u as=0.19p ps=1.38u w=1u l=0.5u
X9 S15 G14 D14 w_n1914_n224# sg13_hv_pmos ad=0.19p pd=1.38u as=0.19p ps=1.38u w=1u l=0.5u
X10 D2 G1 S1 w_n1914_n224# sg13_hv_pmos ad=0.19p pd=1.38u as=0.19p ps=1.38u w=1u l=0.5u
X11 D8 G7 S7 w_n1914_n224# sg13_hv_pmos ad=0.19p pd=1.38u as=0.19p ps=1.38u w=1u l=0.5u
X12 S9 G8 D8 w_n1914_n224# sg13_hv_pmos ad=0.19p pd=1.38u as=0.19p ps=1.38u w=1u l=0.5u
X13 D16 G15 S15 w_n1914_n224# sg13_hv_pmos ad=0.19p pd=1.38u as=0.19p ps=1.38u w=1u l=0.5u
X14 S17 G16 D16 w_n1914_n224# sg13_hv_pmos ad=0.19p pd=1.38u as=0.19p ps=1.38u w=1u l=0.5u
X15 S1 G0 D0 w_n1914_n224# sg13_hv_pmos ad=0.19p pd=1.38u as=0.34p ps=2.68u w=1u l=0.5u
X16 S7 G6 D6 w_n1914_n224# sg13_hv_pmos ad=0.19p pd=1.38u as=0.19p ps=1.38u w=1u l=0.5u
X17 D18 G17 S17 w_n1914_n224# sg13_hv_pmos ad=0.19p pd=1.38u as=0.19p ps=1.38u w=1u l=0.5u
X18 S13 G12 D12 w_n1914_n224# sg13_hv_pmos ad=0.19p pd=1.38u as=0.19p ps=1.38u w=1u l=0.5u
X19 D6 G5 S5 w_n1914_n224# sg13_hv_pmos ad=0.19p pd=1.38u as=0.19p ps=1.38u w=1u l=0.5u
.ends

.subckt sg13_hv_nmos_6DERAL D0 S0 G0 D1 S1 G1 D2 S2 G2 D3 S3 G3 D4 S4 G4 D5 S5 G5
+ D6 S6 G6 D7 S7 G7 D8 S8 G8 D9 S9 G9 D10 S10 G10 D11 S11 G11 sub
X0 S6 G6 D6 sub sg13_hv_nmos ad=0.34p pd=2.68u as=0.34p ps=2.68u w=1u l=0.5u
X1 S8 G8 D8 sub sg13_hv_nmos ad=0.34p pd=2.68u as=0.34p ps=2.68u w=1u l=0.5u
X2 D1 G1 S1 sub sg13_hv_nmos ad=0.34p pd=2.68u as=0.34p ps=2.68u w=1u l=0.5u
X3 S0 G0 D0 sub sg13_hv_nmos ad=0.34p pd=2.68u as=0.34p ps=2.68u w=1u l=0.5u
X4 D5 G5 S5 sub sg13_hv_nmos ad=0.34p pd=2.68u as=0.34p ps=2.68u w=1u l=0.5u
X5 D9 G9 S9 sub sg13_hv_nmos ad=0.34p pd=2.68u as=0.34p ps=2.68u w=1u l=0.5u
X6 S4 G4 D4 sub sg13_hv_nmos ad=0.34p pd=2.68u as=0.34p ps=2.68u w=1u l=0.5u
X7 D3 G3 S3 sub sg13_hv_nmos ad=0.34p pd=2.68u as=0.34p ps=2.68u w=1u l=0.5u
X8 S10 G10 D10 sub sg13_hv_nmos ad=0.34p pd=2.68u as=0.34p ps=2.68u w=1u l=0.5u
X9 D11 G11 S11 sub sg13_hv_nmos ad=0.34p pd=2.68u as=0.34p ps=2.68u w=1u l=0.5u
X10 D7 G7 S7 sub sg13_hv_nmos ad=0.34p pd=2.68u as=0.34p ps=2.68u w=1u l=0.5u
X11 S2 G2 D2 sub sg13_hv_nmos ad=0.34p pd=2.68u as=0.34p ps=2.68u w=1u l=0.5u
.ends

.subckt sg13_hv_pmos_W338R3 D0_0 S0_0 G0_0 D0_1 S0_1 G0_1 D1_0 S1_0 G1_0 D1_1 S1_1
+ G1_1 D2_0 S2_0 G2_0 D2_1 S2_1 G2_1 D3_0 S3_0 G3_0 D3_1 S3_1 G3_1 D4_0 S4_0 G4_0
+ D4_1 S4_1 G4_1 D5_0 S5_0 G5_0 D5_1 S5_1 G5_1 D6_0 S6_0 G6_0 D6_1 S6_1 G6_1 D7_0
+ S7_0 G7_0 D7_1 S7_1 G7_1 D8_0 S8_0 G8_0 D8_1 S8_1 G8_1 D9_0 S9_0 G9_0 D9_1 S9_1
+ G9_1 w_n1993_n416#
X0 D7_1 G7_1 S7_1 w_n1993_n416# sg13_hv_pmos ad=0.34p pd=2.68u as=0.34p ps=2.68u w=1u l=1u
X1 S2_0 G2_0 D2_0 w_n1993_n416# sg13_hv_pmos ad=0.34p pd=2.68u as=0.34p ps=2.68u w=1u l=1u
X2 S6_0 G6_0 D6_0 w_n1993_n416# sg13_hv_pmos ad=0.34p pd=2.68u as=0.34p ps=2.68u w=1u l=1u
X3 D1_0 G1_0 S1_0 w_n1993_n416# sg13_hv_pmos ad=0.34p pd=2.68u as=0.34p ps=2.68u w=1u l=1u
X4 D1_1 G1_1 S1_1 w_n1993_n416# sg13_hv_pmos ad=0.34p pd=2.68u as=0.34p ps=2.68u w=1u l=1u
X5 D9_1 G9_1 S9_1 w_n1993_n416# sg13_hv_pmos ad=0.34p pd=2.68u as=0.34p ps=2.68u w=1u l=1u
X6 S0_0 G0_0 D0_0 w_n1993_n416# sg13_hv_pmos ad=0.34p pd=2.68u as=0.34p ps=2.68u w=1u l=1u
X7 D7_0 G7_0 S7_0 w_n1993_n416# sg13_hv_pmos ad=0.34p pd=2.68u as=0.34p ps=2.68u w=1u l=1u
X8 S6_1 G6_1 D6_1 w_n1993_n416# sg13_hv_pmos ad=0.34p pd=2.68u as=0.34p ps=2.68u w=1u l=1u
X9 D3_1 G3_1 S3_1 w_n1993_n416# sg13_hv_pmos ad=0.34p pd=2.68u as=0.34p ps=2.68u w=1u l=1u
X10 S8_0 G8_0 D8_0 w_n1993_n416# sg13_hv_pmos ad=0.34p pd=2.68u as=0.34p ps=2.68u w=1u l=1u
X11 S2_1 G2_1 D2_1 w_n1993_n416# sg13_hv_pmos ad=0.34p pd=2.68u as=0.34p ps=2.68u w=1u l=1u
X12 D9_0 G9_0 S9_0 w_n1993_n416# sg13_hv_pmos ad=0.34p pd=2.68u as=0.34p ps=2.68u w=1u l=1u
X13 S8_1 G8_1 D8_1 w_n1993_n416# sg13_hv_pmos ad=0.34p pd=2.68u as=0.34p ps=2.68u w=1u l=1u
X14 D5_0 G5_0 S5_0 w_n1993_n416# sg13_hv_pmos ad=0.34p pd=2.68u as=0.34p ps=2.68u w=1u l=1u
X15 S4_1 G4_1 D4_1 w_n1993_n416# sg13_hv_pmos ad=0.34p pd=2.68u as=0.34p ps=2.68u w=1u l=1u
X16 S4_0 G4_0 D4_0 w_n1993_n416# sg13_hv_pmos ad=0.34p pd=2.68u as=0.34p ps=2.68u w=1u l=1u
X17 D3_0 G3_0 S3_0 w_n1993_n416# sg13_hv_pmos ad=0.34p pd=2.68u as=0.34p ps=2.68u w=1u l=1u
X18 S0_1 G0_1 D0_1 w_n1993_n416# sg13_hv_pmos ad=0.34p pd=2.68u as=0.34p ps=2.68u w=1u l=1u
X19 D5_1 G5_1 S5_1 w_n1993_n416# sg13_hv_pmos ad=0.34p pd=2.68u as=0.34p ps=2.68u w=1u l=1u
.ends

.subckt p_amp_large avss out inn inp avdd ena_b ibias
Xsg13_hv_pmos_MW6CUW_1 sg13_hv_pmos_MW6CUW_2/D8 inp sg13_hv_pmos_MW6CUW_2/S7 inp sg13_hv_pmos_MW6CUW_2/D8
+ inn out inn sg13_hv_pmos_MW6CUW_2/D8 inp sg13_hv_pmos_MW6CUW_2/S7 inp sg13_hv_pmos_MW6CUW_2/D8
+ inn out inn sg13_hv_pmos_MW6CUW_2/D8 inp sg13_hv_pmos_MW6CUW_2/S7 inp sg13_hv_pmos_MW6CUW_2/D8
+ inn out inn sg13_hv_pmos_MW6CUW_2/D8 inp sg13_hv_pmos_MW6CUW_2/S7 inp sg13_hv_pmos_MW6CUW_2/D8
+ inn out inn sg13_hv_pmos_MW6CUW_2/D8 inp sg13_hv_pmos_MW6CUW_2/S7 inp sg13_hv_pmos_MW6CUW_2/D8
+ inn out inn avdd sg13_hv_pmos_MW6CUW_2/D8 sg13_hv_pmos_MW6CUW
Xsg13_hv_pmos_MW6CUW_2 sg13_hv_pmos_MW6CUW_2/D8 inn out inn sg13_hv_pmos_MW6CUW_2/D8
+ inp sg13_hv_pmos_MW6CUW_2/S7 inp sg13_hv_pmos_MW6CUW_2/D8 inn out inn sg13_hv_pmos_MW6CUW_2/D8
+ inp sg13_hv_pmos_MW6CUW_2/S7 inp sg13_hv_pmos_MW6CUW_2/D8 inn out inn sg13_hv_pmos_MW6CUW_2/D8
+ inp sg13_hv_pmos_MW6CUW_2/S7 inp sg13_hv_pmos_MW6CUW_2/D8 inn out inn sg13_hv_pmos_MW6CUW_2/D8
+ inp sg13_hv_pmos_MW6CUW_2/S7 inp sg13_hv_pmos_MW6CUW_2/D8 inn out inn sg13_hv_pmos_MW6CUW_2/D8
+ inp sg13_hv_pmos_MW6CUW_2/S7 inp avdd sg13_hv_pmos_MW6CUW_2/D8 sg13_hv_pmos_MW6CUW
Xsg13_hv_nmos_6DERAL_0 avss avss avss out avss sg13_hv_pmos_MW6CUW_2/S7 avss sg13_hv_pmos_MW6CUW_2/S7
+ sg13_hv_pmos_MW6CUW_2/S7 out avss sg13_hv_pmos_MW6CUW_2/S7 avss sg13_hv_pmos_MW6CUW_2/S7
+ sg13_hv_pmos_MW6CUW_2/S7 out avss sg13_hv_pmos_MW6CUW_2/S7 avss sg13_hv_pmos_MW6CUW_2/S7
+ sg13_hv_pmos_MW6CUW_2/S7 out avss sg13_hv_pmos_MW6CUW_2/S7 avss sg13_hv_pmos_MW6CUW_2/S7
+ sg13_hv_pmos_MW6CUW_2/S7 out avss sg13_hv_pmos_MW6CUW_2/S7 avss sg13_hv_pmos_MW6CUW_2/S7
+ sg13_hv_pmos_MW6CUW_2/S7 avss avss avss avss sg13_hv_nmos_6DERAL
Xsg13_hv_nmos_6DERAL_1 avss avss avss sg13_hv_pmos_MW6CUW_2/S7 avss sg13_hv_pmos_MW6CUW_2/S7
+ avss out sg13_hv_pmos_MW6CUW_2/S7 sg13_hv_pmos_MW6CUW_2/S7 avss sg13_hv_pmos_MW6CUW_2/S7
+ avss out sg13_hv_pmos_MW6CUW_2/S7 sg13_hv_pmos_MW6CUW_2/S7 avss sg13_hv_pmos_MW6CUW_2/S7
+ avss out sg13_hv_pmos_MW6CUW_2/S7 sg13_hv_pmos_MW6CUW_2/S7 avss sg13_hv_pmos_MW6CUW_2/S7
+ avss out sg13_hv_pmos_MW6CUW_2/S7 sg13_hv_pmos_MW6CUW_2/S7 avss sg13_hv_pmos_MW6CUW_2/S7
+ avss out sg13_hv_pmos_MW6CUW_2/S7 avss avss avss avss sg13_hv_nmos_6DERAL
Xsg13_hv_pmos_W338R3_0 avdd sg13_hv_pmos_MW6CUW_2/D8 sg13_hv_pmos_MW6CUW_0/D8 avdd
+ sg13_hv_pmos_MW6CUW_0/D8 sg13_hv_pmos_MW6CUW_0/D8 sg13_hv_pmos_MW6CUW_0/D8 avdd
+ sg13_hv_pmos_MW6CUW_0/D8 sg13_hv_pmos_MW6CUW_2/D8 avdd sg13_hv_pmos_MW6CUW_0/D8
+ avdd sg13_hv_pmos_MW6CUW_2/D8 sg13_hv_pmos_MW6CUW_0/D8 avdd sg13_hv_pmos_MW6CUW_0/D8
+ sg13_hv_pmos_MW6CUW_0/D8 sg13_hv_pmos_MW6CUW_0/D8 avdd sg13_hv_pmos_MW6CUW_0/D8
+ sg13_hv_pmos_MW6CUW_2/D8 avdd sg13_hv_pmos_MW6CUW_0/D8 avdd sg13_hv_pmos_MW6CUW_2/D8
+ sg13_hv_pmos_MW6CUW_0/D8 avdd sg13_hv_pmos_MW6CUW_0/D8 sg13_hv_pmos_MW6CUW_0/D8
+ sg13_hv_pmos_MW6CUW_0/D8 avdd sg13_hv_pmos_MW6CUW_0/D8 sg13_hv_pmos_MW6CUW_2/D8
+ avdd sg13_hv_pmos_MW6CUW_0/D8 avdd sg13_hv_pmos_MW6CUW_2/D8 sg13_hv_pmos_MW6CUW_0/D8
+ avdd sg13_hv_pmos_MW6CUW_0/D8 sg13_hv_pmos_MW6CUW_0/D8 sg13_hv_pmos_MW6CUW_0/D8
+ avdd sg13_hv_pmos_MW6CUW_0/D8 sg13_hv_pmos_MW6CUW_2/D8 avdd sg13_hv_pmos_MW6CUW_0/D8
+ avdd sg13_hv_pmos_MW6CUW_2/D8 sg13_hv_pmos_MW6CUW_0/D8 avdd sg13_hv_pmos_MW6CUW_0/D8
+ sg13_hv_pmos_MW6CUW_0/D8 sg13_hv_pmos_MW6CUW_0/D8 avdd sg13_hv_pmos_MW6CUW_0/D8
+ sg13_hv_pmos_MW6CUW_2/D8 avdd sg13_hv_pmos_MW6CUW_0/D8 avdd sg13_hv_pmos_W338R3
Xsg13_hv_pmos_W338R3_1 avdd sg13_hv_pmos_MW6CUW_2/D8 sg13_hv_pmos_MW6CUW_0/D8 avdd
+ sg13_hv_pmos_MW6CUW_0/D8 sg13_hv_pmos_MW6CUW_0/D8 sg13_hv_pmos_MW6CUW_0/D8 avdd
+ sg13_hv_pmos_MW6CUW_0/D8 sg13_hv_pmos_MW6CUW_2/D8 avdd sg13_hv_pmos_MW6CUW_0/D8
+ avdd sg13_hv_pmos_MW6CUW_2/D8 sg13_hv_pmos_MW6CUW_0/D8 avdd sg13_hv_pmos_MW6CUW_0/D8
+ sg13_hv_pmos_MW6CUW_0/D8 sg13_hv_pmos_MW6CUW_0/D8 avdd sg13_hv_pmos_MW6CUW_0/D8
+ sg13_hv_pmos_MW6CUW_2/D8 avdd sg13_hv_pmos_MW6CUW_0/D8 avdd sg13_hv_pmos_MW6CUW_2/D8
+ sg13_hv_pmos_MW6CUW_0/D8 avdd sg13_hv_pmos_MW6CUW_0/D8 sg13_hv_pmos_MW6CUW_0/D8
+ sg13_hv_pmos_MW6CUW_0/D8 avdd sg13_hv_pmos_MW6CUW_0/D8 sg13_hv_pmos_MW6CUW_2/D8
+ avdd sg13_hv_pmos_MW6CUW_0/D8 avdd sg13_hv_pmos_MW6CUW_2/D8 sg13_hv_pmos_MW6CUW_0/D8
+ avdd sg13_hv_pmos_MW6CUW_0/D8 sg13_hv_pmos_MW6CUW_0/D8 sg13_hv_pmos_MW6CUW_0/D8
+ avdd sg13_hv_pmos_MW6CUW_0/D8 sg13_hv_pmos_MW6CUW_2/D8 avdd sg13_hv_pmos_MW6CUW_0/D8
+ avdd sg13_hv_pmos_MW6CUW_2/D8 sg13_hv_pmos_MW6CUW_0/D8 avdd sg13_hv_pmos_MW6CUW_0/D8
+ sg13_hv_pmos_MW6CUW_0/D8 sg13_hv_pmos_MW6CUW_0/D8 avdd sg13_hv_pmos_MW6CUW_0/D8
+ sg13_hv_pmos_MW6CUW_2/D8 avdd sg13_hv_pmos_MW6CUW_0/D8 avdd sg13_hv_pmos_W338R3
Xsg13_hv_pmos_MW6CUW_0 sg13_hv_pmos_MW6CUW_0/D8 ena_b ibias ena_b sg13_hv_pmos_MW6CUW_0/D8
+ ena_b ibias ena_b sg13_hv_pmos_MW6CUW_0/D8 ena_b ibias ena_b sg13_hv_pmos_MW6CUW_0/D8
+ ena_b ibias ena_b sg13_hv_pmos_MW6CUW_0/D8 ena_b ibias ena_b sg13_hv_pmos_MW6CUW_0/D8
+ ena_b ibias ena_b sg13_hv_pmos_MW6CUW_0/D8 ena_b ibias ena_b sg13_hv_pmos_MW6CUW_0/D8
+ ena_b ibias ena_b sg13_hv_pmos_MW6CUW_0/D8 ena_b ibias ena_b sg13_hv_pmos_MW6CUW_0/D8
+ ena_b ibias ena_b avdd sg13_hv_pmos_MW6CUW_0/D8 sg13_hv_pmos_MW6CUW
.ends

.subckt capacitor_M46PNM c1 c2
X0 c1 c2 cap_cmomf mm_ok=1 subblock=0 mmax=4 mmin=1 l=47u w=8u
.ends

.subckt sg13_hv_pmos_DNCZKC D0 G0 S1 G1 w_n330_n224# a_138_n100#
X0 a_138_n100# G1 S1 w_n330_n224# sg13_hv_pmos ad=0.34p pd=2.68u as=0.19p ps=1.38u w=1u l=0.5u
X1 S1 G0 D0 w_n330_n224# sg13_hv_pmos ad=0.19p pd=1.38u as=0.34p ps=2.68u w=1u l=0.5u
.ends

.subckt sg13_hv_nmos_QHASHE D0 G0 S1 G1 a_138_n400# sub
X0 S1 G0 D0 sub sg13_hv_nmos ad=0.76p pd=4.38u as=1.36p ps=8.68u w=4u l=0.5u
X1 a_138_n400# G1 S1 sub sg13_hv_nmos ad=1.36p pd=8.68u as=0.76p ps=4.38u w=4u l=0.5u
.ends

.subckt sg13_hv_nmos_QBGVHE D0 G0 S1 G1 a_138_n100# sub
X0 a_138_n100# G1 S1 sub sg13_hv_nmos ad=0.34p pd=2.68u as=0.19p ps=1.38u w=1u l=0.5u
X1 S1 G0 D0 sub sg13_hv_nmos ad=0.19p pd=1.38u as=0.34p ps=2.68u w=1u l=0.5u
.ends

.subckt sg13_hv_pmos_ZPCZKC D0 G0 S1 G1 D2 S2 G2 w_n418_n324#
X0 S1 G0 D0 w_n418_n324# sg13_hv_pmos ad=0.38p pd=2.38u as=0.68p ps=4.68u w=2u l=0.5u
X1 S2 G2 D2 w_n418_n324# sg13_hv_pmos ad=0.68p pd=4.68u as=0.38p ps=2.38u w=2u l=0.5u
X2 D2 G1 S1 w_n418_n324# sg13_hv_pmos ad=0.38p pd=2.38u as=0.38p ps=2.38u w=2u l=0.5u
.ends

.subckt level_shift in_n in_p out vss vdd
Xsg13_hv_pmos_DNCZKC_0 XM2/G1 XM7/G0 vdd XM2/G1 vdd XM7/G0 sg13_hv_pmos_DNCZKC
XXM1 XM2/G1 in_p vss in_p XM2/G1 vss sg13_hv_nmos_QHASHE
XXM2 XM2/G1 XM7/G0 vdd XM2/G1 vdd XM7/G0 sg13_hv_pmos_DNCZKC
XXM3 XM7/G0 in_n vss in_n XM7/G0 vss sg13_hv_nmos_QHASHE
XXM6 vss XM7/G0 XM7/G2 XM7/G0 vss vss sg13_hv_nmos_QBGVHE
XXM7 XM7/G2 XM7/G0 vdd XM7/G2 out vdd XM7/G2 vdd sg13_hv_pmos_ZPCZKC
Xsg13_hv_nmos_QBGVHE_0 vss XM7/G2 out XM7/G2 vss vss sg13_hv_nmos_QBGVHE
Xsg13_hv_nmos_QBGVHE_1 vss XM7/G2 out XM7/G2 vss vss sg13_hv_nmos_QBGVHE
Xsg13_hv_pmos_ZPCZKC_0 XM7/G2 XM7/G0 vdd XM7/G2 out vdd XM7/G2 vdd sg13_hv_pmos_ZPCZKC
.ends

.subckt sg13_hv_pmos_7A8CUW D0 S0 G0 D1 S1 G1 D2 S2 G2 D3 S3 G3 D4 S4 G4 D5 S5 G5
+ D6 S6 G6 D7 S7 G7 D8 S8 G8 D9 S9 G9 D10 S10 G10 D11 S11 G11 w_n1771_n224#
X0 S6 G6 D6 w_n1771_n224# sg13_hv_pmos ad=0.34p pd=2.68u as=0.34p ps=2.68u w=1u l=0.5u
X1 S8 G8 D8 w_n1771_n224# sg13_hv_pmos ad=0.34p pd=2.68u as=0.34p ps=2.68u w=1u l=0.5u
X2 D1 G1 S1 w_n1771_n224# sg13_hv_pmos ad=0.34p pd=2.68u as=0.34p ps=2.68u w=1u l=0.5u
X3 S0 G0 D0 w_n1771_n224# sg13_hv_pmos ad=0.34p pd=2.68u as=0.34p ps=2.68u w=1u l=0.5u
X4 D5 G5 S5 w_n1771_n224# sg13_hv_pmos ad=0.34p pd=2.68u as=0.34p ps=2.68u w=1u l=0.5u
X5 D9 G9 S9 w_n1771_n224# sg13_hv_pmos ad=0.34p pd=2.68u as=0.34p ps=2.68u w=1u l=0.5u
X6 S4 G4 D4 w_n1771_n224# sg13_hv_pmos ad=0.34p pd=2.68u as=0.34p ps=2.68u w=1u l=0.5u
X7 D3 G3 S3 w_n1771_n224# sg13_hv_pmos ad=0.34p pd=2.68u as=0.34p ps=2.68u w=1u l=0.5u
X8 S10 G10 D10 w_n1771_n224# sg13_hv_pmos ad=0.34p pd=2.68u as=0.34p ps=2.68u w=1u l=0.5u
X9 D11 G11 S11 w_n1771_n224# sg13_hv_pmos ad=0.34p pd=2.68u as=0.34p ps=2.68u w=1u l=0.5u
X10 S2 G2 D2 w_n1771_n224# sg13_hv_pmos ad=0.34p pd=2.68u as=0.34p ps=2.68u w=1u l=0.5u
X11 D7 G7 S7 w_n1771_n224# sg13_hv_pmos ad=0.34p pd=2.68u as=0.34p ps=2.68u w=1u l=0.5u
.ends

.subckt sg13_hv_nmos_XVVFQX D0_0 S0_0 G0_0 D0_1 S0_1 G0_1 D1_0 S1_0 G1_0 D1_1 S1_1
+ G1_1 D2_0 S2_0 G2_0 D2_1 S2_1 G2_1 D3_0 S3_0 G3_0 D3_1 S3_1 G3_1 D4_0 S4_0 G4_0
+ D4_1 S4_1 G4_1 D5_0 S5_0 G5_0 D5_1 S5_1 G5_1 D6_0 S6_0 G6_0 D6_1 S6_1 G6_1 D7_0
+ S7_0 G7_0 D7_1 S7_1 G7_1 D8_0 S8_0 G8_0 D8_1 S8_1 G8_1 D9_0 S9_0 G9_0 D9_1 S9_1
+ G9_1 sub
X0 D7_1 G7_1 S7_1 sub sg13_hv_nmos ad=0.34p pd=2.68u as=0.34p ps=2.68u w=1u l=1u
X1 S2_0 G2_0 D2_0 sub sg13_hv_nmos ad=0.34p pd=2.68u as=0.34p ps=2.68u w=1u l=1u
X2 D1_0 G1_0 S1_0 sub sg13_hv_nmos ad=0.34p pd=2.68u as=0.34p ps=2.68u w=1u l=1u
X3 S6_0 G6_0 D6_0 sub sg13_hv_nmos ad=0.34p pd=2.68u as=0.34p ps=2.68u w=1u l=1u
X4 D1_1 G1_1 S1_1 sub sg13_hv_nmos ad=0.34p pd=2.68u as=0.34p ps=2.68u w=1u l=1u
X5 D9_1 G9_1 S9_1 sub sg13_hv_nmos ad=0.34p pd=2.68u as=0.34p ps=2.68u w=1u l=1u
X6 S0_0 G0_0 D0_0 sub sg13_hv_nmos ad=0.34p pd=2.68u as=0.34p ps=2.68u w=1u l=1u
X7 D7_0 G7_0 S7_0 sub sg13_hv_nmos ad=0.34p pd=2.68u as=0.34p ps=2.68u w=1u l=1u
X8 S6_1 G6_1 D6_1 sub sg13_hv_nmos ad=0.34p pd=2.68u as=0.34p ps=2.68u w=1u l=1u
X9 D3_1 G3_1 S3_1 sub sg13_hv_nmos ad=0.34p pd=2.68u as=0.34p ps=2.68u w=1u l=1u
X10 S8_0 G8_0 D8_0 sub sg13_hv_nmos ad=0.34p pd=2.68u as=0.34p ps=2.68u w=1u l=1u
X11 S2_1 G2_1 D2_1 sub sg13_hv_nmos ad=0.34p pd=2.68u as=0.34p ps=2.68u w=1u l=1u
X12 D9_0 G9_0 S9_0 sub sg13_hv_nmos ad=0.34p pd=2.68u as=0.34p ps=2.68u w=1u l=1u
X13 S8_1 G8_1 D8_1 sub sg13_hv_nmos ad=0.34p pd=2.68u as=0.34p ps=2.68u w=1u l=1u
X14 D5_0 G5_0 S5_0 sub sg13_hv_nmos ad=0.34p pd=2.68u as=0.34p ps=2.68u w=1u l=1u
X15 S4_1 G4_1 D4_1 sub sg13_hv_nmos ad=0.34p pd=2.68u as=0.34p ps=2.68u w=1u l=1u
X16 S4_0 G4_0 D4_0 sub sg13_hv_nmos ad=0.34p pd=2.68u as=0.34p ps=2.68u w=1u l=1u
X17 D3_0 G3_0 S3_0 sub sg13_hv_nmos ad=0.34p pd=2.68u as=0.34p ps=2.68u w=1u l=1u
X18 S0_1 G0_1 D0_1 sub sg13_hv_nmos ad=0.34p pd=2.68u as=0.34p ps=2.68u w=1u l=1u
X19 D5_1 G5_1 S5_1 sub sg13_hv_nmos ad=0.34p pd=2.68u as=0.34p ps=2.68u w=1u l=1u
.ends

.subckt sg13_hv_nmos_666RAL D0 G0 S1 G1 D2 G2 S3 G3 D4 G4 S5 G5 D6 G6 S7 G7 D8 G8
+ S9 G9 D10 G10 S11 G11 D12 G12 S13 G13 D14 G14 S15 G15 D16 G16 S17 G17 D18 G18 S19
+ G19 a_1722_n100# sub
X0 D4 G3 S3 sub sg13_hv_nmos ad=0.19p pd=1.38u as=0.19p ps=1.38u w=1u l=0.5u
X1 S19 G18 D18 sub sg13_hv_nmos ad=0.19p pd=1.38u as=0.19p ps=1.38u w=1u l=0.5u
X2 S5 G4 D4 sub sg13_hv_nmos ad=0.19p pd=1.38u as=0.19p ps=1.38u w=1u l=0.5u
X3 S11 G10 D10 sub sg13_hv_nmos ad=0.19p pd=1.38u as=0.19p ps=1.38u w=1u l=0.5u
X4 D14 G13 S13 sub sg13_hv_nmos ad=0.19p pd=1.38u as=0.19p ps=1.38u w=1u l=0.5u
X5 a_1722_n100# G19 S19 sub sg13_hv_nmos ad=0.34p pd=2.68u as=0.19p ps=1.38u w=1u l=0.5u
X6 S3 G2 D2 sub sg13_hv_nmos ad=0.19p pd=1.38u as=0.19p ps=1.38u w=1u l=0.5u
X7 D10 G9 S9 sub sg13_hv_nmos ad=0.19p pd=1.38u as=0.19p ps=1.38u w=1u l=0.5u
X8 S15 G14 D14 sub sg13_hv_nmos ad=0.19p pd=1.38u as=0.19p ps=1.38u w=1u l=0.5u
X9 D2 G1 S1 sub sg13_hv_nmos ad=0.19p pd=1.38u as=0.19p ps=1.38u w=1u l=0.5u
X10 D8 G7 S7 sub sg13_hv_nmos ad=0.19p pd=1.38u as=0.19p ps=1.38u w=1u l=0.5u
X11 S9 G8 D8 sub sg13_hv_nmos ad=0.19p pd=1.38u as=0.19p ps=1.38u w=1u l=0.5u
X12 D16 G15 S15 sub sg13_hv_nmos ad=0.19p pd=1.38u as=0.19p ps=1.38u w=1u l=0.5u
X13 S17 G16 D16 sub sg13_hv_nmos ad=0.19p pd=1.38u as=0.19p ps=1.38u w=1u l=0.5u
X14 S1 G0 D0 sub sg13_hv_nmos ad=0.19p pd=1.38u as=0.34p ps=2.68u w=1u l=0.5u
X15 S7 G6 D6 sub sg13_hv_nmos ad=0.19p pd=1.38u as=0.19p ps=1.38u w=1u l=0.5u
X16 D18 G17 S17 sub sg13_hv_nmos ad=0.19p pd=1.38u as=0.19p ps=1.38u w=1u l=0.5u
X17 S13 G12 D12 sub sg13_hv_nmos ad=0.19p pd=1.38u as=0.19p ps=1.38u w=1u l=0.5u
X18 D6 G5 S5 sub sg13_hv_nmos ad=0.19p pd=1.38u as=0.19p ps=1.38u w=1u l=0.5u
X19 D12 G11 S11 sub sg13_hv_nmos ad=0.19p pd=1.38u as=0.19p ps=1.38u w=1u l=0.5u
.ends

.subckt n_amp_large out inn inp avss ena ibias avdd
Xsg13_hv_pmos_7A8CUW_0 avdd avdd avdd XM6/S7 avdd XM6/S7 avdd out XM6/S7 XM6/S7 avdd
+ XM6/S7 avdd out XM6/S7 XM6/S7 avdd XM6/S7 avdd out XM6/S7 XM6/S7 avdd XM6/S7 avdd
+ out XM6/S7 XM6/S7 avdd XM6/S7 avdd out XM6/S7 avdd avdd avdd avdd sg13_hv_pmos_7A8CUW
Xsg13_hv_nmos_XVVFQX_0 avss XM1/S8_0 XM1/S8_0 avss XM6/D8 XM1/S8_0 XM6/D8 avss XM1/S8_0
+ XM1/S8_0 avss XM1/S8_0 avss XM1/S8_0 XM1/S8_0 avss XM6/D8 XM1/S8_0 XM6/D8 avss XM1/S8_0
+ XM1/S8_0 avss XM1/S8_0 avss XM1/S8_0 XM1/S8_0 avss XM6/D8 XM1/S8_0 XM6/D8 avss XM1/S8_0
+ XM1/S8_0 avss XM1/S8_0 avss XM1/S8_0 XM1/S8_0 avss XM6/D8 XM1/S8_0 XM6/D8 avss XM1/S8_0
+ XM1/S8_0 avss XM1/S8_0 avss XM1/S8_0 XM1/S8_0 avss XM6/D8 XM1/S8_0 XM6/D8 avss XM1/S8_0
+ XM1/S8_0 avss XM1/S8_0 avss sg13_hv_nmos_XVVFQX
XXM1 avss XM1/S8_0 XM1/S8_0 avss XM6/D8 XM1/S8_0 XM6/D8 avss XM1/S8_0 XM1/S8_0 avss
+ XM1/S8_0 avss XM1/S8_0 XM1/S8_0 avss XM6/D8 XM1/S8_0 XM6/D8 avss XM1/S8_0 XM1/S8_0
+ avss XM1/S8_0 avss XM1/S8_0 XM1/S8_0 avss XM6/D8 XM1/S8_0 XM6/D8 avss XM1/S8_0 XM1/S8_0
+ avss XM1/S8_0 avss XM1/S8_0 XM1/S8_0 avss XM6/D8 XM1/S8_0 XM6/D8 avss XM1/S8_0 XM1/S8_0
+ avss XM1/S8_0 avss XM1/S8_0 XM1/S8_0 avss XM6/D8 XM1/S8_0 XM6/D8 avss XM1/S8_0 XM1/S8_0
+ avss XM1/S8_0 avss sg13_hv_nmos_XVVFQX
XXM2 avdd avdd avdd out avdd XM6/S7 avdd XM6/S7 XM6/S7 out avdd XM6/S7 avdd XM6/S7
+ XM6/S7 out avdd XM6/S7 avdd XM6/S7 XM6/S7 out avdd XM6/S7 avdd XM6/S7 XM6/S7 out
+ avdd XM6/S7 avdd XM6/S7 XM6/S7 avdd avdd avdd avdd sg13_hv_pmos_7A8CUW
XXM5 XM6/D8 inp XM6/S7 inp XM6/D8 inn out inn XM6/D8 inp XM6/S7 inp XM6/D8 inn out
+ inn XM6/D8 inp XM6/S7 inp XM6/D8 inn out inn XM6/D8 inp XM6/S7 inp XM6/D8 inn out
+ inn XM6/D8 inp XM6/S7 inp XM6/D8 inn out inn XM6/D8 avss sg13_hv_nmos_666RAL
XXM6 XM6/D8 inn out inn XM6/D8 inp XM6/S7 inp XM6/D8 inn out inn XM6/D8 inp XM6/S7
+ inp XM6/D8 inn out inn XM6/D8 inp XM6/S7 inp XM6/D8 inn out inn XM6/D8 inp XM6/S7
+ inp XM6/D8 inn out inn XM6/D8 inp XM6/S7 inp XM6/D8 avss sg13_hv_nmos_666RAL
Xsg13_hv_nmos_666RAL_0 XM1/S8_0 ena ibias ena XM1/S8_0 ena ibias ena XM1/S8_0 ena
+ ibias ena XM1/S8_0 ena ibias ena XM1/S8_0 ena ibias ena XM1/S8_0 ena ibias ena XM1/S8_0
+ ena ibias ena XM1/S8_0 ena ibias ena XM1/S8_0 ena ibias ena XM1/S8_0 ena ibias ena
+ XM1/S8_0 avss sg13_hv_nmos_666RAL
.ends

.subckt sg13cmos5l_ocd_ip__voltgen_v2 dvdd s[2] s[1] s[0] vbg ibias1u_1 ibias1u_2
+ ena vout1 ena1 ena2 ibias1u_3 high vout2 vss vdd dvss
Xcapacitor_KK7B53_0 vdd XM1/G capacitor_KK7B53
Xsg13cmos5l_inv_2_0 sg13cmos5l_inv_2_0/Y sg13cmos5l_inv_2_0/A dvdd dvss sg13cmos5l_inv_2
Xhv_inv_1_0 vdd x6/ena vss x6/ena_b hv_inv_1
Xsg13cmos5l_inv_2_1 sg13cmos5l_inv_2_1/Y sg13cmos5l_inv_2_1/A dvdd dvss sg13cmos5l_inv_2
Xhv_inv_1_1 vdd hv_inv_1_1/X vss v0 hv_inv_1
Xsg13cmos5l_inv_2_2 sg13cmos5l_inv_2_2/Y sg13cmos5l_inv_2_2/A dvdd dvss sg13cmos5l_inv_2
Xhv_inv_1_2 vdd hv_inv_1_2/X vss v2 hv_inv_1
Xsg13cmos5l_inv_2_3 sg13cmos5l_inv_2_3/Y sg13cmos5l_inv_2_3/A dvdd dvss sg13cmos5l_inv_2
Xhv_inv_1_3 vdd hv_inv_1_3/X vss v1 hv_inv_1
Xsg13cmos5l_inv_2_4 sg13cmos5l_inv_2_4/Y sg13cmos5l_inv_2_4/A dvdd dvss sg13cmos5l_inv_2
Xhv_inv_1_4 vdd hv_inv_1_4/X vss v4 hv_inv_1
Xse_folded_cascode_p_0 vout2 ibias1u_3 level_shift_2/out vout2 x50/inp vdd vss se_folded_cascode_p
Xx6 x6/ena_b x6/in vref3 x6/ena vss vdd xgate
Xhv_inv_1_5 vdd hv_inv_1_5/X vss v3 hv_inv_1
Xsg13cmos5l_inv_2_5 level_shift_3/in_p ena1 dvdd dvss sg13cmos5l_inv_2
XXR1 vss vss vss vss vref0 vref1 vref0 vref1 vref2 vref3 vref2 vref3 vref4 vref5 vref4
+ vref5 vref6 vref7 vref6 vss vss rhigh_NFPZ4T
Xsg13cmos5l_inv_2_6 level_shift_2/in_p ena2 dvdd dvss sg13cmos5l_inv_2
Xhv_inv_1_6 vdd hv_inv_1_6/X vss v6 hv_inv_1
Xhv_inv_1_7 vdd hv_inv_1_7/X vss v5 hv_inv_1
Xsg13cmos5l_inv_2_7 sg13cmos5l_inv_2_7/Y ena dvdd dvss sg13cmos5l_inv_2
Xsg13cmos5l_inv_2_8 s0b s[0] dvdd dvss sg13cmos5l_inv_2
Xhv_inv_1_8 vdd hv_inv_1_8/X vss v7 hv_inv_1
Xsg13cmos5l_inv_2_9 s0 s0b dvdd dvss sg13cmos5l_inv_2
Xxgate_0 x6/ena x6/in vref2 x6/ena_b vss vdd xgate
Xxgate_1 hv_inv_1_1/X vref0 x50/inp v0 vss vdd xgate
XXM1 vdd vref7 vdd XM1/G sg13_hv_pmos_QH8WBX
Xsg13cmos5l_antennanp_0 s[2] dvdd dvss sg13cmos5l_antennanp
Xxgate_2 hv_inv_1_3/X vref1 x50/inp v1 vss vdd xgate
Xsg13cmos5l_antennanp_1 s[1] dvdd dvss sg13cmos5l_antennanp
Xxgate_3 hv_inv_1_2/X vref2 x50/inp v2 vss vdd xgate
Xxgate_4 hv_inv_1_5/X vref3 x50/inp v3 vss vdd xgate
Xsg13cmos5l_antennanp_2 s[0] dvdd dvss sg13cmos5l_antennanp
Xsg13cmos5l_nand3_1_0 sg13cmos5l_inv_2_1/A s2 s1 s0b dvdd dvss sg13cmos5l_nand3_1
Xsg13cmos5l_antennanp_3 ena dvdd dvss sg13cmos5l_antennanp
Xxgate_5 hv_inv_1_7/X vref5 x50/inp v5 vss vdd xgate
Xxgate_6 hv_inv_1_4/X vref4 x50/inp v4 vss vdd xgate
Xsg13cmos5l_nand3_1_1 sg13cmos5l_inv_2_0/A s2b s1 s0b dvdd dvss sg13cmos5l_nand3_1
Xsg13cmos5l_antennanp_4 ena2 dvdd dvss sg13cmos5l_antennanp
Xsg13cmos5l_nand3_1_2 sg13cmos5l_inv_2_4/A s2 s1b s0b dvdd dvss sg13cmos5l_nand3_1
Xsg13cmos5l_antennanp_5 ena1 dvdd dvss sg13cmos5l_antennanp
XC1 vdd XM1/G capacitor_BCZJG3
Xxgate_7 hv_inv_1_6/X vref6 x50/inp v6 vss vdd xgate
Xxgate_8 hv_inv_1_8/X vref7 x50/inp v7 vss vdd xgate
Xsg13cmos5l_nand3_1_3 sg13cmos5l_inv_2_2/A s2b s1b s0b dvdd dvss sg13cmos5l_nand3_1
Xsg13cmos5l_nand3_1_4 sg13cmos5l_inv_2_3/A s2b s1b s0 dvdd dvss sg13cmos5l_nand3_1
Xsg13cmos5l_antennanp_7 high dvdd dvss sg13cmos5l_antennanp
Xx50 vss vout1 vout1 x50/inp vdd x50/ena_b ibias1u_2 p_amp_large
Xcapacitor_M46PNM_0 vdd XM1/G capacitor_M46PNM
Xsg13cmos5l_nand3_1_5 sg13cmos5l_inv_2_14/A s2 s1b s0 dvdd dvss sg13cmos5l_nand3_1
Xlevel_shift_0[0] x14/A x14/Y v7 vss vdd level_shift
Xlevel_shift_0[1] sg13cmos5l_inv_2_4/A sg13cmos5l_inv_2_4/Y v4 vss vdd level_shift
Xlevel_shift_0[2] sg13cmos5l_inv_2_0/A sg13cmos5l_inv_2_0/Y v2 vss vdd level_shift
Xlevel_shift_0[3] sg13cmos5l_inv_2_2/A sg13cmos5l_inv_2_2/Y v0 vss vdd level_shift
Xlevel_shift_0[4] sg13cmos5l_inv_2_7/Y ena x48/ena vss vdd level_shift
Xlevel_shift_1[0] sg13cmos5l_inv_2_1/A sg13cmos5l_inv_2_1/Y v6 vss vdd level_shift
Xlevel_shift_1[1] sg13cmos5l_inv_2_14/A sg13cmos5l_inv_2_14/Y v5 vss vdd level_shift
Xlevel_shift_1[2] x35/Y x34/Y v3 vss vdd level_shift
Xlevel_shift_1[3] sg13cmos5l_inv_2_3/A sg13cmos5l_inv_2_3/Y v1 vss vdd level_shift
Xlevel_shift_1[4] sg13cmos5l_inv_2_15/Y high x6/ena_b vss vdd level_shift
Xlevel_shift_2 ena2 level_shift_2/in_p level_shift_2/out vss vdd level_shift
Xsg13cmos5l_decap_4_0 dvdd dvss sg13cmos5l_decap_4
Xlevel_shift_3 ena1 level_shift_3/in_p x50/ena_b vss vdd level_shift
Xx34 x34/Y x35/Y dvdd dvss sg13cmos5l_inv_2
Xx13 x14/A s2 s1 s0 dvdd dvss sg13cmos5l_nand3_1
Xx35 x35/Y s2b s1 s0 dvdd dvss sg13cmos5l_nand3_1
Xx14 x14/Y x14/A dvdd dvss sg13cmos5l_inv_2
Xx48 XM1/G vbg x6/in vss x48/ena ibias1u_1 vdd n_amp_large
Xsg13cmos5l_inv_2_10 s1 s1b dvdd dvss sg13cmos5l_inv_2
Xsg13cmos5l_inv_2_11 s2 s2b dvdd dvss sg13cmos5l_inv_2
Xsg13cmos5l_inv_2_12 s2b s[2] dvdd dvss sg13cmos5l_inv_2
Xsg13cmos5l_inv_2_13 s1b s[1] dvdd dvss sg13cmos5l_inv_2
Xsg13cmos5l_inv_2_14 sg13cmos5l_inv_2_14/Y sg13cmos5l_inv_2_14/A dvdd dvss sg13cmos5l_inv_2
Xsg13cmos5l_inv_2_15 sg13cmos5l_inv_2_15/Y high dvdd dvss sg13cmos5l_inv_2
.ends

.subckt RM_IHPSG13_1P_DLY_4 Z A VSS VDD
X0 VSS a_599_496# a_531_576# VSS sg13_lv_nmos ad=0.1577p pd=1.21u as=0.2822p ps=2.34u w=0.83u l=0.3u
X1 VSS a_89_496# a_21_576# VSS sg13_lv_nmos ad=0.1577p pd=1.21u as=0.2822p ps=2.34u w=0.83u l=0.3u
X2 a_2671_682# a_2461_102# a_2571_102# VSS sg13_lv_nmos ad=48f pd=0.62u as=0.102p ps=1.28u w=0.3u l=0.16u
X3 VSS a_2461_102# a_2671_682# VSS sg13_lv_nmos ad=57f pd=0.68u as=48f ps=0.62u w=0.3u l=0.16u
X4 a_3181_682# a_2971_102# a_3081_102# VSS sg13_lv_nmos ad=48f pd=0.62u as=0.102p ps=1.28u w=0.3u l=0.16u
X5 VSS a_2971_102# a_3181_682# VSS sg13_lv_nmos ad=57f pd=0.68u as=48f ps=0.62u w=0.3u l=0.16u
X6 a_2671_102# a_2461_102# a_2571_102# VDD sg13_lv_pmos ad=0.1152p pd=1.04u as=0.2448p ps=2.12u w=0.72u l=0.16u
X7 VDD a_2461_102# a_2671_102# VDD sg13_lv_pmos ad=0.1368p pd=1.1u as=0.1152p ps=1.04u w=0.72u l=0.16u
X8 a_3181_102# a_2971_102# a_3081_102# VDD sg13_lv_pmos ad=0.1152p pd=1.04u as=0.2448p ps=2.12u w=0.72u l=0.16u
X9 VDD a_2971_102# a_3181_102# VDD sg13_lv_pmos ad=0.1368p pd=1.1u as=0.1152p ps=1.04u w=0.72u l=0.16u
R0 m1_1341_104# a_2061_435# 0.253846
X10 VSS a_599_496# a_531_576# VSS sg13_lv_nmos ad=0.2822p pd=2.34u as=0.1577p ps=1.21u w=0.83u l=0.3u
X11 a_2875_682# a_2571_102# VSS VSS sg13_lv_nmos ad=48f pd=0.62u as=57f ps=0.68u w=0.3u l=0.16u
X12 a_3385_682# a_3081_102# VSS VSS sg13_lv_nmos ad=48f pd=0.62u as=57f ps=0.68u w=0.3u l=0.16u
X13 a_3481_102# a_3081_102# a_3385_682# VSS sg13_lv_nmos ad=0.102p pd=1.28u as=48f ps=0.62u w=0.3u l=0.16u
X14 a_2875_102# a_2571_102# VDD VDD sg13_lv_pmos ad=0.1152p pd=1.04u as=0.1368p ps=1.1u w=0.72u l=0.16u
X15 a_3385_102# a_3081_102# VDD VDD sg13_lv_pmos ad=0.1152p pd=1.04u as=0.1368p ps=1.1u w=0.72u l=0.16u
X16 a_531_576# a_599_496# VSS VSS sg13_lv_nmos ad=0.1577p pd=1.21u as=0.1577p ps=1.21u w=0.83u l=0.3u
X17 a_2971_102# a_2571_102# a_2875_682# VSS sg13_lv_nmos ad=0.102p pd=1.28u as=48f ps=0.62u w=0.3u l=0.16u
X18 a_89_496# a_21_576# VDD VDD sg13_lv_pmos ad=0.3078p pd=2u as=0.5508p ps=3.92u w=1.62u l=0.64u
X19 a_2971_102# a_2571_102# a_2875_102# VDD sg13_lv_pmos ad=0.2448p pd=2.12u as=0.1152p ps=1.04u w=0.72u l=0.16u
X20 a_3481_102# a_3081_102# a_3385_102# VDD sg13_lv_pmos ad=0.2448p pd=2.12u as=0.1152p ps=1.04u w=0.72u l=0.16u
R1 A m1_321_104# 0.253846
X21 a_3691_682# a_3481_102# a_3591_102# VSS sg13_lv_nmos ad=48f pd=0.62u as=0.102p ps=1.28u w=0.3u l=0.16u
X22 VSS a_3481_102# a_3691_682# VSS sg13_lv_nmos ad=57f pd=0.68u as=48f ps=0.62u w=0.3u l=0.16u
X23 VDD a_3481_102# a_3691_102# VDD sg13_lv_pmos ad=0.1368p pd=1.1u as=0.1152p ps=1.04u w=0.72u l=0.16u
X24 VDD a_1551_576# a_1619_496# VDD sg13_lv_pmos ad=0.5508p pd=3.92u as=0.3078p ps=2u w=1.62u l=0.64u
X25 a_3691_102# a_3481_102# a_3591_102# VDD sg13_lv_pmos ad=0.1152p pd=1.04u as=0.2448p ps=2.12u w=0.72u l=0.16u
X26 a_3895_682# a_3591_102# VSS VSS sg13_lv_nmos ad=48f pd=0.62u as=57f ps=0.68u w=0.3u l=0.16u
X27 Z a_3591_102# a_3895_682# VSS sg13_lv_nmos ad=0.102p pd=1.28u as=48f ps=0.62u w=0.3u l=0.16u
X28 a_3895_102# a_3591_102# VDD VDD sg13_lv_pmos ad=0.1152p pd=1.04u as=0.1368p ps=1.1u w=0.72u l=0.16u
X29 Z a_3591_102# a_3895_102# VDD sg13_lv_pmos ad=0.2448p pd=2.12u as=0.1152p ps=1.04u w=0.72u l=0.16u
X30 VSS a_1109_496# a_1041_576# VSS sg13_lv_nmos ad=0.2822p pd=2.34u as=0.1577p ps=1.21u w=0.83u l=0.3u
X31 VDD a_1041_576# a_1109_496# VDD sg13_lv_pmos ad=0.5508p pd=3.92u as=0.3078p ps=2u w=1.62u l=0.64u
X32 a_1619_496# a_1551_576# VDD VDD sg13_lv_pmos ad=0.3078p pd=2u as=0.5508p ps=3.92u w=1.62u l=0.64u
X33 a_1041_576# a_1109_496# VSS VSS sg13_lv_nmos ad=0.1577p pd=1.21u as=0.1577p ps=1.21u w=0.83u l=0.3u
R2 m1_321_104# m1_831_104# 0.253846
X34 VSS a_1109_496# a_1041_576# VSS sg13_lv_nmos ad=0.1577p pd=1.21u as=0.2822p ps=2.34u w=0.83u l=0.3u
X35 a_1109_496# a_1041_576# VDD VDD sg13_lv_pmos ad=0.3078p pd=2u as=0.5508p ps=3.92u w=1.62u l=0.64u
X36 VDD a_531_576# a_599_496# VDD sg13_lv_pmos ad=0.5508p pd=3.92u as=0.3078p ps=2u w=1.62u l=0.64u
X37 VSS a_1619_496# a_1551_576# VSS sg13_lv_nmos ad=0.2822p pd=2.34u as=0.1577p ps=1.21u w=0.83u l=0.3u
X38 a_1551_576# a_1619_496# VSS VSS sg13_lv_nmos ad=0.1577p pd=1.21u as=0.1577p ps=1.21u w=0.83u l=0.3u
X39 VSS a_1619_496# a_1551_576# VSS sg13_lv_nmos ad=0.1577p pd=1.21u as=0.2822p ps=2.34u w=0.83u l=0.3u
X40 a_2161_682# a_2061_435# a_2061_102# VSS sg13_lv_nmos ad=48f pd=0.62u as=0.102p ps=1.28u w=0.3u l=0.16u
X41 VSS a_2061_435# a_2161_682# VSS sg13_lv_nmos ad=57f pd=0.68u as=48f ps=0.62u w=0.3u l=0.16u
X42 VDD a_21_576# a_89_496# VDD sg13_lv_pmos ad=0.5508p pd=3.92u as=0.3078p ps=2u w=1.62u l=0.64u
X43 a_599_496# a_531_576# VDD VDD sg13_lv_pmos ad=0.3078p pd=2u as=0.5508p ps=3.92u w=1.62u l=0.64u
X44 a_2161_102# a_2061_435# a_2061_102# VDD sg13_lv_pmos ad=0.1152p pd=1.04u as=0.2448p ps=2.12u w=0.72u l=0.16u
X45 VDD a_2061_435# a_2161_102# VDD sg13_lv_pmos ad=0.1368p pd=1.1u as=0.1152p ps=1.04u w=0.72u l=0.16u
R3 m1_831_104# m1_1341_104# 0.253846
X46 VSS a_89_496# a_21_576# VSS sg13_lv_nmos ad=0.2822p pd=2.34u as=0.1577p ps=1.21u w=0.83u l=0.3u
X47 a_2365_682# a_2061_102# VSS VSS sg13_lv_nmos ad=48f pd=0.62u as=57f ps=0.68u w=0.3u l=0.16u
X48 a_21_576# a_89_496# VSS VSS sg13_lv_nmos ad=0.1577p pd=1.21u as=0.1577p ps=1.21u w=0.83u l=0.3u
X49 a_2461_102# a_2061_102# a_2365_682# VSS sg13_lv_nmos ad=0.102p pd=1.28u as=48f ps=0.62u w=0.3u l=0.16u
X50 a_2365_102# a_2061_102# VDD VDD sg13_lv_pmos ad=0.1152p pd=1.04u as=0.1368p ps=1.1u w=0.72u l=0.16u
X51 a_2461_102# a_2061_102# a_2365_102# VDD sg13_lv_pmos ad=0.2448p pd=2.12u as=0.1152p ps=1.04u w=0.72u l=0.16u
.ends

.subckt RM_IHPSG13_1P_WLDRV16X4 VSS VDD A<7> A<9> A<4> A<5> A<8> A<6> A<10> A<11>
+ A<3> A<14> A<15> A<0> A<12> A<13> A<2> Z<15> A<1> Z<0> Z<1> Z<2> Z<3> Z<4> Z<5>
+ Z<6> Z<7> Z<8> Z<9> Z<10> Z<11> Z<12> Z<13> Z<14> m3_n82_567#
X0 Z<8> a_123_1778# VSS VSS sg13_lv_nmos ad=0.2397p pd=2.09u as=0.16417p ps=1.28u w=0.705u l=0.13u
X1 Z<9> a_531_1778# VSS VSS sg13_lv_nmos ad=0.2397p pd=2.09u as=0.16417p ps=1.28u w=0.705u l=0.13u
X2 VDD A<5> a_531_936# VDD sg13_lv_pmos ad=0.2538p pd=2u as=0.306p ps=2.48u w=0.9u l=0.13u
X3 VDD A<11> a_1347_1778# VDD sg13_lv_pmos ad=0.2538p pd=2u as=0.306p ps=2.48u w=0.9u l=0.13u
X4 Z<1> a_531_98# VDD VDD sg13_lv_pmos ad=0.3078p pd=2u as=0.2538p ps=2u w=1.62u l=0.13u
X5 Z<15> a_1347_2616# VSS VSS sg13_lv_nmos ad=0.2397p pd=2.09u as=0.16417p ps=1.28u w=0.705u l=0.13u
X6 VDD A<14> a_939_2616# VDD sg13_lv_pmos ad=0.2538p pd=2u as=0.306p ps=2.48u w=0.9u l=0.13u
X7 VDD a_531_98# Z<1> VDD sg13_lv_pmos ad=0.5508p pd=3.92u as=0.3078p ps=2u w=1.62u l=0.13u
X8 Z<11> a_1347_1778# VSS VSS sg13_lv_nmos ad=0.2397p pd=2.09u as=0.16417p ps=1.28u w=0.705u l=0.13u
X9 VDD A<2> a_939_98# VDD sg13_lv_pmos ad=0.2538p pd=2u as=0.306p ps=2.48u w=0.9u l=0.13u
X10 VDD A<12> a_123_2616# VDD sg13_lv_pmos ad=0.2538p pd=2u as=0.306p ps=2.48u w=0.9u l=0.13u
X11 VDD A<13> a_531_2616# VDD sg13_lv_pmos ad=0.2538p pd=2u as=0.306p ps=2.48u w=0.9u l=0.13u
X12 Z<10> a_939_1778# VDD VDD sg13_lv_pmos ad=0.3078p pd=2u as=0.2538p ps=2u w=1.62u l=0.13u
X13 Z<2> a_939_98# VSS VSS sg13_lv_nmos ad=0.2397p pd=2.09u as=0.16417p ps=1.28u w=0.705u l=0.13u
X14 Z<8> a_123_1778# VDD VDD sg13_lv_pmos ad=0.3078p pd=2u as=0.2538p ps=2u w=1.62u l=0.13u
X15 Z<9> a_531_1778# VDD VDD sg13_lv_pmos ad=0.3078p pd=2u as=0.2538p ps=2u w=1.62u l=0.13u
X16 Z<5> a_531_936# VDD VDD sg13_lv_pmos ad=0.3078p pd=2u as=0.2538p ps=2u w=1.62u l=0.13u
X17 VDD a_531_936# Z<5> VDD sg13_lv_pmos ad=0.5508p pd=3.92u as=0.3078p ps=2u w=1.62u l=0.13u
X18 VDD A<3> a_1347_98# VDD sg13_lv_pmos ad=0.2538p pd=2u as=0.306p ps=2.48u w=0.9u l=0.13u
X19 Z<14> a_939_2616# VDD VDD sg13_lv_pmos ad=0.3078p pd=2u as=0.2538p ps=2u w=1.62u l=0.13u
X20 VDD A<15> a_1347_2616# VDD sg13_lv_pmos ad=0.2538p pd=2u as=0.306p ps=2.48u w=0.9u l=0.13u
X21 Z<6> a_939_936# VSS VSS sg13_lv_nmos ad=0.2397p pd=2.09u as=0.16417p ps=1.28u w=0.705u l=0.13u
X22 VDD A<0> a_123_98# VDD sg13_lv_pmos ad=0.2538p pd=2u as=0.306p ps=2.48u w=0.9u l=0.13u
X23 Z<2> a_939_98# VDD VDD sg13_lv_pmos ad=0.3078p pd=2u as=0.2538p ps=2u w=1.62u l=0.13u
X24 VSS A<14> a_939_2616# VSS sg13_lv_nmos ad=0.16417p pd=1.28u as=0.306p ps=2.48u w=0.9u l=0.13u
X25 VDD a_939_98# Z<2> VDD sg13_lv_pmos ad=0.5508p pd=3.92u as=0.3078p ps=2u w=1.62u l=0.13u
X26 Z<12> a_123_2616# VDD VDD sg13_lv_pmos ad=0.3078p pd=2u as=0.2538p ps=2u w=1.62u l=0.13u
X27 Z<13> a_531_2616# VDD VDD sg13_lv_pmos ad=0.3078p pd=2u as=0.2538p ps=2u w=1.62u l=0.13u
X28 Z<11> a_1347_1778# VDD VDD sg13_lv_pmos ad=0.3078p pd=2u as=0.2538p ps=2u w=1.62u l=0.13u
X29 Z<4> a_123_936# VSS VSS sg13_lv_nmos ad=0.2397p pd=2.09u as=0.16417p ps=1.28u w=0.705u l=0.13u
X30 Z<5> a_531_936# VSS VSS sg13_lv_nmos ad=0.2397p pd=2.09u as=0.16417p ps=1.28u w=0.705u l=0.13u
X31 VSS A<12> a_123_2616# VSS sg13_lv_nmos ad=0.16417p pd=1.28u as=0.306p ps=2.48u w=0.9u l=0.13u
X32 VSS A<13> a_531_2616# VSS sg13_lv_nmos ad=0.16417p pd=1.28u as=0.306p ps=2.48u w=0.9u l=0.13u
X33 VDD a_531_1778# Z<9> VDD sg13_lv_pmos ad=0.5508p pd=3.92u as=0.3078p ps=2u w=1.62u l=0.13u
X34 Z<0> a_123_98# VSS VSS sg13_lv_nmos ad=0.2397p pd=2.09u as=0.16417p ps=1.28u w=0.705u l=0.13u
X35 VSS A<1> a_531_98# VSS sg13_lv_nmos ad=0.16417p pd=1.28u as=0.306p ps=2.48u w=0.9u l=0.13u
X36 Z<3> a_1347_98# VSS VSS sg13_lv_nmos ad=0.2397p pd=2.09u as=0.16417p ps=1.28u w=0.705u l=0.13u
X37 VDD a_123_1778# Z<8> VDD sg13_lv_pmos ad=0.5508p pd=3.92u as=0.3078p ps=2u w=1.62u l=0.13u
X38 VDD A<6> a_939_936# VDD sg13_lv_pmos ad=0.2538p pd=2u as=0.306p ps=2.48u w=0.9u l=0.13u
X39 Z<6> a_939_936# VDD VDD sg13_lv_pmos ad=0.3078p pd=2u as=0.2538p ps=2u w=1.62u l=0.13u
X40 Z<3> a_1347_98# VDD VDD sg13_lv_pmos ad=0.3078p pd=2u as=0.2538p ps=2u w=1.62u l=0.13u
X41 VSS A<2> a_939_98# VSS sg13_lv_nmos ad=0.16417p pd=1.28u as=0.306p ps=2.48u w=0.9u l=0.13u
X42 VDD a_939_936# Z<6> VDD sg13_lv_pmos ad=0.5508p pd=3.92u as=0.3078p ps=2u w=1.62u l=0.13u
X43 Z<15> a_1347_2616# VDD VDD sg13_lv_pmos ad=0.3078p pd=2u as=0.2538p ps=2u w=1.62u l=0.13u
X44 Z<7> a_1347_936# VSS VSS sg13_lv_nmos ad=0.2397p pd=2.09u as=0.16417p ps=1.28u w=0.705u l=0.13u
X45 Z<0> a_123_98# VDD VDD sg13_lv_pmos ad=0.3078p pd=2u as=0.2538p ps=2u w=1.62u l=0.13u
X46 VDD A<1> a_531_98# VDD sg13_lv_pmos ad=0.2538p pd=2u as=0.306p ps=2.48u w=0.9u l=0.13u
X47 VDD a_1347_98# Z<3> VDD sg13_lv_pmos ad=0.5508p pd=3.92u as=0.3078p ps=2u w=1.62u l=0.13u
X48 Z<1> a_531_98# VSS VSS sg13_lv_nmos ad=0.2397p pd=2.09u as=0.16417p ps=1.28u w=0.705u l=0.13u
X49 VSS A<15> a_1347_2616# VSS sg13_lv_nmos ad=0.16417p pd=1.28u as=0.306p ps=2.48u w=0.9u l=0.13u
X50 VDD a_531_2616# Z<13> VDD sg13_lv_pmos ad=0.5508p pd=3.92u as=0.3078p ps=2u w=1.62u l=0.13u
X51 VDD a_123_2616# Z<12> VDD sg13_lv_pmos ad=0.5508p pd=3.92u as=0.3078p ps=2u w=1.62u l=0.13u
X52 VDD a_939_1778# Z<10> VDD sg13_lv_pmos ad=0.5508p pd=3.92u as=0.3078p ps=2u w=1.62u l=0.13u
X53 VDD a_1347_1778# Z<11> VDD sg13_lv_pmos ad=0.5508p pd=3.92u as=0.3078p ps=2u w=1.62u l=0.13u
X54 VSS A<10> a_939_1778# VSS sg13_lv_nmos ad=0.16417p pd=1.28u as=0.306p ps=2.48u w=0.9u l=0.13u
X55 VDD a_123_98# Z<0> VDD sg13_lv_pmos ad=0.5508p pd=3.92u as=0.3078p ps=2u w=1.62u l=0.13u
X56 VSS A<8> a_123_1778# VSS sg13_lv_nmos ad=0.16417p pd=1.28u as=0.306p ps=2.48u w=0.9u l=0.13u
X57 VSS A<9> a_531_1778# VSS sg13_lv_nmos ad=0.16417p pd=1.28u as=0.306p ps=2.48u w=0.9u l=0.13u
X58 VSS A<6> a_939_936# VSS sg13_lv_nmos ad=0.16417p pd=1.28u as=0.306p ps=2.48u w=0.9u l=0.13u
X59 VDD A<7> a_1347_936# VDD sg13_lv_pmos ad=0.2538p pd=2u as=0.306p ps=2.48u w=0.9u l=0.13u
X60 VSS A<4> a_123_936# VSS sg13_lv_nmos ad=0.16417p pd=1.28u as=0.306p ps=2.48u w=0.9u l=0.13u
X61 VSS A<5> a_531_936# VSS sg13_lv_nmos ad=0.16417p pd=1.28u as=0.306p ps=2.48u w=0.9u l=0.13u
X62 VDD A<4> a_123_936# VDD sg13_lv_pmos ad=0.2538p pd=2u as=0.306p ps=2.48u w=0.9u l=0.13u
X63 Z<7> a_1347_936# VDD VDD sg13_lv_pmos ad=0.3078p pd=2u as=0.2538p ps=2u w=1.62u l=0.13u
X64 VDD A<10> a_939_1778# VDD sg13_lv_pmos ad=0.2538p pd=2u as=0.306p ps=2.48u w=0.9u l=0.13u
X65 VSS A<0> a_123_98# VSS sg13_lv_nmos ad=0.16417p pd=1.28u as=0.306p ps=2.48u w=0.9u l=0.13u
X66 VSS A<3> a_1347_98# VSS sg13_lv_nmos ad=0.16417p pd=1.28u as=0.306p ps=2.48u w=0.9u l=0.13u
X67 VDD A<8> a_123_1778# VDD sg13_lv_pmos ad=0.2538p pd=2u as=0.306p ps=2.48u w=0.9u l=0.13u
X68 VDD A<9> a_531_1778# VDD sg13_lv_pmos ad=0.2538p pd=2u as=0.306p ps=2.48u w=0.9u l=0.13u
X69 Z<4> a_123_936# VDD VDD sg13_lv_pmos ad=0.3078p pd=2u as=0.2538p ps=2u w=1.62u l=0.13u
X70 VDD a_1347_936# Z<7> VDD sg13_lv_pmos ad=0.5508p pd=3.92u as=0.3078p ps=2u w=1.62u l=0.13u
X71 Z<14> a_939_2616# VSS VSS sg13_lv_nmos ad=0.2397p pd=2.09u as=0.16417p ps=1.28u w=0.705u l=0.13u
X72 VDD a_939_2616# Z<14> VDD sg13_lv_pmos ad=0.5508p pd=3.92u as=0.3078p ps=2u w=1.62u l=0.13u
X73 VDD a_1347_2616# Z<15> VDD sg13_lv_pmos ad=0.5508p pd=3.92u as=0.3078p ps=2u w=1.62u l=0.13u
X74 VDD a_123_936# Z<4> VDD sg13_lv_pmos ad=0.5508p pd=3.92u as=0.3078p ps=2u w=1.62u l=0.13u
X75 Z<12> a_123_2616# VSS VSS sg13_lv_nmos ad=0.2397p pd=2.09u as=0.16417p ps=1.28u w=0.705u l=0.13u
X76 Z<13> a_531_2616# VSS VSS sg13_lv_nmos ad=0.2397p pd=2.09u as=0.16417p ps=1.28u w=0.705u l=0.13u
X77 Z<10> a_939_1778# VSS VSS sg13_lv_nmos ad=0.2397p pd=2.09u as=0.16417p ps=1.28u w=0.705u l=0.13u
X78 VSS A<11> a_1347_1778# VSS sg13_lv_nmos ad=0.16417p pd=1.28u as=0.306p ps=2.48u w=0.9u l=0.13u
X79 VSS A<7> a_1347_936# VSS sg13_lv_nmos ad=0.16417p pd=1.28u as=0.306p ps=2.48u w=0.9u l=0.13u
.ends

.subckt RM_IHPSG13_1P_DLY_2 Z A VSS VDD
X0 VSS a_599_496# a_531_576# VSS sg13_lv_nmos ad=0.1577p pd=1.21u as=0.2822p ps=2.34u w=0.83u l=0.3u
X1 VSS a_2129_496# a_2061_576# VSS sg13_lv_nmos ad=0.2822p pd=2.34u as=0.1577p ps=1.21u w=0.83u l=0.3u
X2 a_2571_576# a_2639_496# VSS VSS sg13_lv_nmos ad=0.1577p pd=1.21u as=0.1577p ps=1.21u w=0.83u l=0.3u
X3 VSS a_2639_496# a_2571_576# VSS sg13_lv_nmos ad=0.1577p pd=1.21u as=0.2822p ps=2.34u w=0.83u l=0.3u
X4 VSS a_89_496# a_21_576# VSS sg13_lv_nmos ad=0.1577p pd=1.21u as=0.2822p ps=2.34u w=0.83u l=0.3u
X5 a_3181_682# a_3081_435# a_3081_102# VSS sg13_lv_nmos ad=48f pd=0.62u as=0.102p ps=1.28u w=0.3u l=0.16u
X6 VSS a_3081_435# a_3181_682# VSS sg13_lv_nmos ad=57f pd=0.68u as=48f ps=0.62u w=0.3u l=0.16u
X7 a_3181_102# a_3081_435# a_3081_102# VDD sg13_lv_pmos ad=0.1152p pd=1.04u as=0.2448p ps=2.12u w=0.72u l=0.16u
X8 VDD a_3081_435# a_3181_102# VDD sg13_lv_pmos ad=0.1368p pd=1.1u as=0.1152p ps=1.04u w=0.72u l=0.16u
R0 m1_1341_104# m1_1851_104# 0.253846
R1 m1_1851_104# m1_2361_104# 0.253846
X9 VSS a_599_496# a_531_576# VSS sg13_lv_nmos ad=0.2822p pd=2.34u as=0.1577p ps=1.21u w=0.83u l=0.3u
X10 a_3385_682# a_3081_102# VSS VSS sg13_lv_nmos ad=48f pd=0.62u as=57f ps=0.68u w=0.3u l=0.16u
X11 a_3481_102# a_3081_102# a_3385_682# VSS sg13_lv_nmos ad=0.102p pd=1.28u as=48f ps=0.62u w=0.3u l=0.16u
X12 a_3385_102# a_3081_102# VDD VDD sg13_lv_pmos ad=0.1152p pd=1.04u as=0.1368p ps=1.1u w=0.72u l=0.16u
X13 a_531_576# a_599_496# VSS VSS sg13_lv_nmos ad=0.1577p pd=1.21u as=0.1577p ps=1.21u w=0.83u l=0.3u
X14 a_89_496# a_21_576# VDD VDD sg13_lv_pmos ad=0.3078p pd=2u as=0.5508p ps=3.92u w=1.62u l=0.64u
X15 a_3481_102# a_3081_102# a_3385_102# VDD sg13_lv_pmos ad=0.2448p pd=2.12u as=0.1152p ps=1.04u w=0.72u l=0.16u
X16 VSS a_2639_496# a_2571_576# VSS sg13_lv_nmos ad=0.2822p pd=2.34u as=0.1577p ps=1.21u w=0.83u l=0.3u
R2 A m1_321_104# 0.253846
X17 a_3691_682# a_3481_102# a_3591_102# VSS sg13_lv_nmos ad=48f pd=0.62u as=0.102p ps=1.28u w=0.3u l=0.16u
X18 VSS a_3481_102# a_3691_682# VSS sg13_lv_nmos ad=57f pd=0.68u as=48f ps=0.62u w=0.3u l=0.16u
X19 VDD a_3481_102# a_3691_102# VDD sg13_lv_pmos ad=0.1368p pd=1.1u as=0.1152p ps=1.04u w=0.72u l=0.16u
X20 VDD a_1551_576# a_1619_496# VDD sg13_lv_pmos ad=0.5508p pd=3.92u as=0.3078p ps=2u w=1.62u l=0.64u
X21 a_3691_102# a_3481_102# a_3591_102# VDD sg13_lv_pmos ad=0.1152p pd=1.04u as=0.2448p ps=2.12u w=0.72u l=0.16u
R3 m1_2361_104# a_3081_435# 0.253846
X22 a_3895_682# a_3591_102# VSS VSS sg13_lv_nmos ad=48f pd=0.62u as=57f ps=0.68u w=0.3u l=0.16u
X23 Z a_3591_102# a_3895_682# VSS sg13_lv_nmos ad=0.102p pd=1.28u as=48f ps=0.62u w=0.3u l=0.16u
X24 VDD a_2571_576# a_2639_496# VDD sg13_lv_pmos ad=0.5508p pd=3.92u as=0.3078p ps=2u w=1.62u l=0.64u
X25 a_3895_102# a_3591_102# VDD VDD sg13_lv_pmos ad=0.1152p pd=1.04u as=0.1368p ps=1.1u w=0.72u l=0.16u
X26 Z a_3591_102# a_3895_102# VDD sg13_lv_pmos ad=0.2448p pd=2.12u as=0.1152p ps=1.04u w=0.72u l=0.16u
X27 VSS a_1109_496# a_1041_576# VSS sg13_lv_nmos ad=0.2822p pd=2.34u as=0.1577p ps=1.21u w=0.83u l=0.3u
X28 VDD a_1041_576# a_1109_496# VDD sg13_lv_pmos ad=0.5508p pd=3.92u as=0.3078p ps=2u w=1.62u l=0.64u
X29 a_1619_496# a_1551_576# VDD VDD sg13_lv_pmos ad=0.3078p pd=2u as=0.5508p ps=3.92u w=1.62u l=0.64u
X30 a_1041_576# a_1109_496# VSS VSS sg13_lv_nmos ad=0.1577p pd=1.21u as=0.1577p ps=1.21u w=0.83u l=0.3u
R4 m1_321_104# m1_831_104# 0.253846
X31 VDD a_2061_576# a_2129_496# VDD sg13_lv_pmos ad=0.5508p pd=3.92u as=0.3078p ps=2u w=1.62u l=0.64u
X32 a_2639_496# a_2571_576# VDD VDD sg13_lv_pmos ad=0.3078p pd=2u as=0.5508p ps=3.92u w=1.62u l=0.64u
X33 VSS a_1109_496# a_1041_576# VSS sg13_lv_nmos ad=0.1577p pd=1.21u as=0.2822p ps=2.34u w=0.83u l=0.3u
X34 a_1109_496# a_1041_576# VDD VDD sg13_lv_pmos ad=0.3078p pd=2u as=0.5508p ps=3.92u w=1.62u l=0.64u
X35 a_2129_496# a_2061_576# VDD VDD sg13_lv_pmos ad=0.3078p pd=2u as=0.5508p ps=3.92u w=1.62u l=0.64u
X36 VDD a_531_576# a_599_496# VDD sg13_lv_pmos ad=0.5508p pd=3.92u as=0.3078p ps=2u w=1.62u l=0.64u
X37 VSS a_1619_496# a_1551_576# VSS sg13_lv_nmos ad=0.2822p pd=2.34u as=0.1577p ps=1.21u w=0.83u l=0.3u
X38 a_1551_576# a_1619_496# VSS VSS sg13_lv_nmos ad=0.1577p pd=1.21u as=0.1577p ps=1.21u w=0.83u l=0.3u
X39 a_2061_576# a_2129_496# VSS VSS sg13_lv_nmos ad=0.1577p pd=1.21u as=0.1577p ps=1.21u w=0.83u l=0.3u
X40 VSS a_2129_496# a_2061_576# VSS sg13_lv_nmos ad=0.1577p pd=1.21u as=0.2822p ps=2.34u w=0.83u l=0.3u
X41 VSS a_1619_496# a_1551_576# VSS sg13_lv_nmos ad=0.1577p pd=1.21u as=0.2822p ps=2.34u w=0.83u l=0.3u
X42 VDD a_21_576# a_89_496# VDD sg13_lv_pmos ad=0.5508p pd=3.92u as=0.3078p ps=2u w=1.62u l=0.64u
X43 a_599_496# a_531_576# VDD VDD sg13_lv_pmos ad=0.3078p pd=2u as=0.5508p ps=3.92u w=1.62u l=0.64u
R5 m1_831_104# m1_1341_104# 0.253846
X44 VSS a_89_496# a_21_576# VSS sg13_lv_nmos ad=0.2822p pd=2.34u as=0.1577p ps=1.21u w=0.83u l=0.3u
X45 a_21_576# a_89_496# VSS VSS sg13_lv_nmos ad=0.1577p pd=1.21u as=0.1577p ps=1.21u w=0.83u l=0.3u
.ends

.subckt RM_IHPSG13_1P_COLDRV13X4 VSS VDD RCLK_I DCLK_I ADDR_DEC_O<2> ADDR_DEC_O<0>
+ ADDR_DEC_O<1> ADDR_DEC_I<7> ADDR_DEC_I<0> ADDR_DEC_I<4> ADDR_DEC_I<2> ADDR_COL_I<0>
+ ADDR_COL_I<1> ADDR_DEC_I<3> ADDR_DEC_I<1> ADDR_DEC_I<5> ADDR_DEC_I<6> WCLK_I ADDR_DEC_O<3>
+ ADDR_COL_O<1> ADDR_COL_O<0> ADDR_DEC_O<6> ADDR_DEC_O<4> ADDR_DEC_O<7> RCLK_O ADDR_DEC_O<5>
+ DCLK_O WCLK_O VDD_uq0 VDD_uq1 VDD_uq2 m3_0_n6153# m3_0_n6573# m2_579_n365#
X0 ADDR_DEC_O<7> a_21_n4942# VSS VSS sg13_lv_nmos ad=0.13395p pd=1.085u as=0.13395p ps=1.085u w=0.705u l=0.13u
X1 VDD ADDR_DEC_I<4> a_429_n5784# VDD sg13_lv_pmos ad=0.3078p pd=2u as=0.5508p ps=3.92u w=1.62u l=0.13u
X2 RCLK_O a_21_n7464# VSS VSS sg13_lv_nmos ad=0.13395p pd=1.085u as=0.13395p ps=1.085u w=0.705u l=0.13u
X3 VSS ADDR_COL_I<0> a_429_n4104# VSS sg13_lv_nmos ad=0.13395p pd=1.085u as=0.2397p ps=2.09u w=0.705u l=0.13u
X4 VDD_uq1 a_429_n4104# ADDR_COL_O<0> VDD_uq1 sg13_lv_pmos ad=0.5508p pd=3.92u as=0.3078p ps=2u w=1.62u l=0.13u
X5 VDD_uq2 ADDR_DEC_I<0> a_429_n3262# VDD_uq2 sg13_lv_pmos ad=0.3078p pd=2u as=0.5508p ps=3.92u w=1.62u l=0.13u
X6 ADDR_DEC_O<6> a_21_n5784# VDD VDD sg13_lv_pmos ad=0.3078p pd=2u as=0.3078p ps=2u w=1.62u l=0.13u
X7 ADDR_DEC_O<2> a_21_n4104# VSS VSS sg13_lv_nmos ad=0.13395p pd=1.085u as=0.13395p ps=1.085u w=0.705u l=0.13u
X8 VSS a_429_n6622# ADDR_COL_O<1> VSS sg13_lv_nmos ad=0.2397p pd=2.09u as=0.13395p ps=1.085u w=0.705u l=0.13u
X9 ADDR_DEC_O<3> a_21_n3262# VDD_uq2 VDD_uq2 sg13_lv_pmos ad=0.3078p pd=2u as=0.3078p ps=2u w=1.62u l=0.13u
X10 VDD_uq0 a_429_n7464# DCLK_O VDD_uq0 sg13_lv_pmos ad=0.5508p pd=3.92u as=0.3078p ps=2u w=1.62u l=0.13u
X11 VSS a_429_n3262# ADDR_DEC_O<0> VSS sg13_lv_nmos ad=0.2397p pd=2.09u as=0.13395p ps=1.085u w=0.705u l=0.13u
X12 VDD_uq1 a_429_n4942# ADDR_DEC_O<5> VDD_uq1 sg13_lv_pmos ad=0.5508p pd=3.92u as=0.3078p ps=2u w=1.62u l=0.13u
X13 VSS a_429_n5784# ADDR_DEC_O<4> VSS sg13_lv_nmos ad=0.2397p pd=2.09u as=0.13395p ps=1.085u w=0.705u l=0.13u
X14 VDD ADDR_COL_I<1> a_429_n6622# VDD sg13_lv_pmos ad=0.3078p pd=2u as=0.5508p ps=3.92u w=1.62u l=0.13u
X15 VDD_uq2 ADDR_DEC_I<1> a_21_n2424# VDD_uq2 sg13_lv_pmos ad=0.3078p pd=2u as=0.5508p ps=3.92u w=1.62u l=0.13u
X16 VDD_uq2 a_21_n2424# ADDR_DEC_O<1> VDD_uq2 sg13_lv_pmos ad=0.5508p pd=3.92u as=0.3078p ps=2u w=1.62u l=0.13u
X17 ADDR_DEC_O<5> a_429_n4942# VSS VSS sg13_lv_nmos ad=0.13395p pd=1.085u as=0.13395p ps=1.085u w=0.705u l=0.13u
X18 DCLK_O a_429_n7464# VSS VSS sg13_lv_nmos ad=0.13395p pd=1.085u as=0.13395p ps=1.085u w=0.705u l=0.13u
X19 WCLK_O a_21_n6622# VDD VDD sg13_lv_pmos ad=0.3078p pd=2u as=0.3078p ps=2u w=1.62u l=0.13u
X20 VSS ADDR_DEC_I<7> a_21_n4942# VSS sg13_lv_nmos ad=0.13395p pd=1.085u as=0.2397p ps=2.09u w=0.705u l=0.13u
X21 VSS a_21_n4942# ADDR_DEC_O<7> VSS sg13_lv_nmos ad=0.2397p pd=2.09u as=0.13395p ps=1.085u w=0.705u l=0.13u
X22 ADDR_DEC_O<4> a_429_n5784# VDD VDD sg13_lv_pmos ad=0.3078p pd=2u as=0.3078p ps=2u w=1.62u l=0.13u
X23 VSS RCLK_I a_21_n7464# VSS sg13_lv_nmos ad=0.13395p pd=1.085u as=0.2397p ps=2.09u w=0.705u l=0.13u
X24 VSS a_21_n7464# RCLK_O VSS sg13_lv_nmos ad=0.2397p pd=2.09u as=0.13395p ps=1.085u w=0.705u l=0.13u
X25 ADDR_COL_O<0> a_429_n4104# VSS VSS sg13_lv_nmos ad=0.13395p pd=1.085u as=0.13395p ps=1.085u w=0.705u l=0.13u
X26 VDD_uq1 ADDR_COL_I<0> a_429_n4104# VDD_uq1 sg13_lv_pmos ad=0.3078p pd=2u as=0.5508p ps=3.92u w=1.62u l=0.13u
X27 ADDR_DEC_O<0> a_429_n3262# VDD_uq2 VDD_uq2 sg13_lv_pmos ad=0.3078p pd=2u as=0.3078p ps=2u w=1.62u l=0.13u
X28 VDD ADDR_DEC_I<6> a_21_n5784# VDD sg13_lv_pmos ad=0.3078p pd=2u as=0.5508p ps=3.92u w=1.62u l=0.13u
X29 VDD a_21_n5784# ADDR_DEC_O<6> VDD sg13_lv_pmos ad=0.5508p pd=3.92u as=0.3078p ps=2u w=1.62u l=0.13u
X30 ADDR_DEC_O<1> a_21_n2424# VSS VSS sg13_lv_nmos ad=0.13395p pd=1.085u as=0.13395p ps=1.085u w=0.705u l=0.13u
X31 VSS ADDR_DEC_I<2> a_21_n4104# VSS sg13_lv_nmos ad=0.13395p pd=1.085u as=0.2397p ps=2.09u w=0.705u l=0.13u
X32 VSS a_21_n4104# ADDR_DEC_O<2> VSS sg13_lv_nmos ad=0.2397p pd=2.09u as=0.13395p ps=1.085u w=0.705u l=0.13u
X33 ADDR_DEC_O<2> a_21_n4104# VDD_uq1 VDD_uq1 sg13_lv_pmos ad=0.3078p pd=2u as=0.3078p ps=2u w=1.62u l=0.13u
X34 VSS ADDR_COL_I<1> a_429_n6622# VSS sg13_lv_nmos ad=0.13395p pd=1.085u as=0.2397p ps=2.09u w=0.705u l=0.13u
X35 VDD_uq2 ADDR_DEC_I<3> a_21_n3262# VDD_uq2 sg13_lv_pmos ad=0.3078p pd=2u as=0.5508p ps=3.92u w=1.62u l=0.13u
X36 VDD_uq2 a_21_n3262# ADDR_DEC_O<3> VDD_uq2 sg13_lv_pmos ad=0.5508p pd=3.92u as=0.3078p ps=2u w=1.62u l=0.13u
X37 WCLK_O a_21_n6622# VSS VSS sg13_lv_nmos ad=0.13395p pd=1.085u as=0.13395p ps=1.085u w=0.705u l=0.13u
X38 VDD_uq0 DCLK_I a_429_n7464# VDD_uq0 sg13_lv_pmos ad=0.3078p pd=2u as=0.5508p ps=3.92u w=1.62u l=0.13u
X39 VSS ADDR_DEC_I<0> a_429_n3262# VSS sg13_lv_nmos ad=0.13395p pd=1.085u as=0.2397p ps=2.09u w=0.705u l=0.13u
X40 VSS ADDR_DEC_I<4> a_429_n5784# VSS sg13_lv_nmos ad=0.13395p pd=1.085u as=0.2397p ps=2.09u w=0.705u l=0.13u
X41 VDD_uq1 ADDR_DEC_I<5> a_429_n4942# VDD_uq1 sg13_lv_pmos ad=0.3078p pd=2u as=0.5508p ps=3.92u w=1.62u l=0.13u
X42 ADDR_COL_O<1> a_429_n6622# VDD VDD sg13_lv_pmos ad=0.3078p pd=2u as=0.3078p ps=2u w=1.62u l=0.13u
X43 RCLK_O a_21_n7464# VDD_uq0 VDD_uq0 sg13_lv_pmos ad=0.3078p pd=2u as=0.3078p ps=2u w=1.62u l=0.13u
X44 ADDR_DEC_O<3> a_21_n3262# VSS VSS sg13_lv_nmos ad=0.13395p pd=1.085u as=0.13395p ps=1.085u w=0.705u l=0.13u
X45 ADDR_DEC_O<6> a_21_n5784# VSS VSS sg13_lv_nmos ad=0.13395p pd=1.085u as=0.13395p ps=1.085u w=0.705u l=0.13u
X46 ADDR_DEC_O<7> a_21_n4942# VDD_uq1 VDD_uq1 sg13_lv_pmos ad=0.3078p pd=2u as=0.3078p ps=2u w=1.62u l=0.13u
X47 VDD WCLK_I a_21_n6622# VDD sg13_lv_pmos ad=0.3078p pd=2u as=0.5508p ps=3.92u w=1.62u l=0.13u
X48 VDD a_21_n6622# WCLK_O VDD sg13_lv_pmos ad=0.5508p pd=3.92u as=0.3078p ps=2u w=1.62u l=0.13u
X49 VSS a_429_n4942# ADDR_DEC_O<5> VSS sg13_lv_nmos ad=0.2397p pd=2.09u as=0.13395p ps=1.085u w=0.705u l=0.13u
X50 VSS a_429_n7464# DCLK_O VSS sg13_lv_nmos ad=0.2397p pd=2.09u as=0.13395p ps=1.085u w=0.705u l=0.13u
X51 ADDR_COL_O<0> a_429_n4104# VDD_uq1 VDD_uq1 sg13_lv_pmos ad=0.3078p pd=2u as=0.3078p ps=2u w=1.62u l=0.13u
X52 VDD a_429_n5784# ADDR_DEC_O<4> VDD sg13_lv_pmos ad=0.5508p pd=3.92u as=0.3078p ps=2u w=1.62u l=0.13u
X53 VSS ADDR_DEC_I<1> a_21_n2424# VSS sg13_lv_nmos ad=0.13395p pd=1.085u as=0.2397p ps=2.09u w=0.705u l=0.13u
X54 VSS a_21_n2424# ADDR_DEC_O<1> VSS sg13_lv_nmos ad=0.2397p pd=2.09u as=0.13395p ps=1.085u w=0.705u l=0.13u
X55 VDD_uq1 ADDR_DEC_I<2> a_21_n4104# VDD_uq1 sg13_lv_pmos ad=0.3078p pd=2u as=0.5508p ps=3.92u w=1.62u l=0.13u
X56 VDD_uq1 a_21_n4104# ADDR_DEC_O<2> VDD_uq1 sg13_lv_pmos ad=0.5508p pd=3.92u as=0.3078p ps=2u w=1.62u l=0.13u
X57 ADDR_COL_O<1> a_429_n6622# VSS VSS sg13_lv_nmos ad=0.13395p pd=1.085u as=0.13395p ps=1.085u w=0.705u l=0.13u
X58 VDD_uq2 a_429_n3262# ADDR_DEC_O<0> VDD_uq2 sg13_lv_pmos ad=0.5508p pd=3.92u as=0.3078p ps=2u w=1.62u l=0.13u
X59 VSS a_429_n4104# ADDR_COL_O<0> VSS sg13_lv_nmos ad=0.2397p pd=2.09u as=0.13395p ps=1.085u w=0.705u l=0.13u
X60 VSS WCLK_I a_21_n6622# VSS sg13_lv_nmos ad=0.13395p pd=1.085u as=0.2397p ps=2.09u w=0.705u l=0.13u
X61 VSS a_21_n6622# WCLK_O VSS sg13_lv_nmos ad=0.2397p pd=2.09u as=0.13395p ps=1.085u w=0.705u l=0.13u
X62 DCLK_O a_429_n7464# VDD_uq0 VDD_uq0 sg13_lv_pmos ad=0.3078p pd=2u as=0.3078p ps=2u w=1.62u l=0.13u
X63 ADDR_DEC_O<0> a_429_n3262# VSS VSS sg13_lv_nmos ad=0.13395p pd=1.085u as=0.13395p ps=1.085u w=0.705u l=0.13u
X64 ADDR_DEC_O<4> a_429_n5784# VSS VSS sg13_lv_nmos ad=0.13395p pd=1.085u as=0.13395p ps=1.085u w=0.705u l=0.13u
X65 ADDR_DEC_O<5> a_429_n4942# VDD_uq1 VDD_uq1 sg13_lv_pmos ad=0.3078p pd=2u as=0.3078p ps=2u w=1.62u l=0.13u
X66 VDD_uq0 RCLK_I a_21_n7464# VDD_uq0 sg13_lv_pmos ad=0.3078p pd=2u as=0.5508p ps=3.92u w=1.62u l=0.13u
X67 VDD_uq0 a_21_n7464# RCLK_O VDD_uq0 sg13_lv_pmos ad=0.5508p pd=3.92u as=0.3078p ps=2u w=1.62u l=0.13u
X68 VSS ADDR_DEC_I<3> a_21_n3262# VSS sg13_lv_nmos ad=0.13395p pd=1.085u as=0.2397p ps=2.09u w=0.705u l=0.13u
X69 VSS a_21_n3262# ADDR_DEC_O<3> VSS sg13_lv_nmos ad=0.2397p pd=2.09u as=0.13395p ps=1.085u w=0.705u l=0.13u
X70 VSS ADDR_DEC_I<6> a_21_n5784# VSS sg13_lv_nmos ad=0.13395p pd=1.085u as=0.2397p ps=2.09u w=0.705u l=0.13u
X71 VSS a_21_n5784# ADDR_DEC_O<6> VSS sg13_lv_nmos ad=0.2397p pd=2.09u as=0.13395p ps=1.085u w=0.705u l=0.13u
X72 VDD_uq1 ADDR_DEC_I<7> a_21_n4942# VDD_uq1 sg13_lv_pmos ad=0.3078p pd=2u as=0.5508p ps=3.92u w=1.62u l=0.13u
X73 VDD_uq1 a_21_n4942# ADDR_DEC_O<7> VDD_uq1 sg13_lv_pmos ad=0.5508p pd=3.92u as=0.3078p ps=2u w=1.62u l=0.13u
X74 ADDR_DEC_O<1> a_21_n2424# VDD_uq2 VDD_uq2 sg13_lv_pmos ad=0.3078p pd=2u as=0.3078p ps=2u w=1.62u l=0.13u
X75 VSS ADDR_DEC_I<5> a_429_n4942# VSS sg13_lv_nmos ad=0.13395p pd=1.085u as=0.2397p ps=2.09u w=0.705u l=0.13u
X76 VDD a_429_n6622# ADDR_COL_O<1> VDD sg13_lv_pmos ad=0.5508p pd=3.92u as=0.3078p ps=2u w=1.62u l=0.13u
X77 VSS DCLK_I a_429_n7464# VSS sg13_lv_nmos ad=0.13395p pd=1.085u as=0.2397p ps=2.09u w=0.705u l=0.13u
.ends

.subckt RM_IHPSG13_1P_COLDEC2 VSS BIST_ADDR<0> BIST_ADDR<2> BIST_EN_I BIST_ADDR<1>
+ ACLK_N ADDR<0> ADDR<2> ADDR<1> VDD ADDR_DEC<6> ADDR_DEC<5> ADDR_DEC<4> ADDR_DEC<3>
+ ADDR_DEC<2> ADDR_DEC<1> ADDR_DEC<7> ADDR_DEC<0> ADDR_COL<0> ADDR_COL<1> VDD_uq0
+ m2_2096_n9300# m2_4646_n9300# m2_n556_n9300# m2_1484_n9300# m2_n454_n5040# m2_n454_n9300#
+ m2_1382_n9300# m2_3932_n9300# m2_n352_n5040# m2_4340_n5040# m2_2504_n4785# m2_4238_n5040#
+ m2_1178_n5040# m2_n352_n9300# m2_3830_n9300# m2_4340_n9300# m2_3728_n9300# m2_4238_n9300#
+ m2_n250_n5040# m2_1076_n5040# m2_n148_n5040# m2_n250_n9300# m2_n148_n9300# m2_3626_n9300#
+ m2_4136_n9300# m2_158_n9300# m2_5514_n5092# m2_3014_n4275# m2_3524_n9300# m2_4034_n9300#
+ m2_2912_n9300# m2_3422_n9300# m2_2606_n4683# m2_56_n9300# m2_n760_n3893# m2_2708_n9300#
+ m2_3218_n4173# m2_2606_n9300# m3_n1122_n8450# m2_6584_n5040# m2_3014_n9300# m2_n46_n5040#
+ m2_2708_n4581# m2_2810_n4479# m2_2402_n9300# m2_n46_n9300# m2_2300_n9300# m2_n454_n4397#
+ m2_5768_n9300# m2_3320_n4071# m2_5666_n9300# m2_1994_n9300# m2_6074_n9300# m2_2912_n4377#
+ m2_974_n5040# m2_n964_n9300# m2_n862_n5040# m2_5360_n5040# m2_872_n5040# m2_4748_n5040#
+ m2_n862_n9300# m2_1790_n9300# m2_1688_n9300# m2_2198_n9300# m2_4748_n9300# m2_4646_n5040#
X0 VDD_uq0 a_803_n8064# a_803_n8342# VDD_uq0 sg13_lv_pmos ad=0.3078p pd=2u as=0.3078p ps=2u w=1.62u l=0.385u
X1 a_5699_n8700# a_5699_n9186# VDD_uq0 VDD_uq0 sg13_lv_pmos ad=0.3078p pd=2u as=0.3078p ps=2u w=1.62u l=0.385u
X2 VSS a_497_n3302# a_497_n3024# VSS sg13_lv_nmos ad=0.2822p pd=2.34u as=0.1577p ps=1.21u w=0.83u l=0.13u
X3 VDD_uq0 a_6447_n8664# a_6485_n8744# VDD_uq0 sg13_lv_pmos ad=0.5508p pd=3.92u as=0.3078p ps=2u w=1.62u l=0.385u
X4 VSS a_n1033_n8342# a_n1033_n8064# VSS sg13_lv_nmos ad=0.1577p pd=1.21u as=0.1577p ps=1.21u w=0.83u l=0.13u
X5 VSS a_5087_n8342# a_5087_n8064# VSS sg13_lv_nmos ad=0.1577p pd=1.21u as=0.1577p ps=1.21u w=0.83u l=0.13u
X6 VDD a_5699_n3024# a_5699_n3302# VDD sg13_lv_pmos ad=0.3078p pd=2u as=0.3078p ps=2u w=1.62u l=0.385u
X7 VSS a_3149_n4037# a_3073_n3630# VSS sg13_lv_nmos ad=91.2f pd=0.86u as=91.2f ps=0.86u w=0.48u l=0.13u
X8 VSS BIST_ADDR<1> a_1849_n3630# VSS sg13_lv_nmos ad=0.1904p pd=1.8u as=0.1064p ps=0.94u w=0.56u l=0.13u
X9 a_4475_n3302# a_4475_n3024# VDD VDD sg13_lv_pmos ad=0.3078p pd=2u as=0.3078p ps=2u w=1.62u l=0.385u
X10 VSS a_n727_n3660# a_n727_n4146# VSS sg13_lv_nmos ad=0.1577p pd=1.21u as=0.1577p ps=1.21u w=0.83u l=0.13u
X11 VSS a_n421_n8342# a_n421_n8064# VSS sg13_lv_nmos ad=0.1577p pd=1.21u as=0.1577p ps=1.21u w=0.83u l=0.13u
X12 VSS a_3251_n8342# a_3251_n8064# VSS sg13_lv_nmos ad=0.1577p pd=1.21u as=0.1577p ps=1.21u w=0.83u l=0.13u
X13 VSS BIST_EN_I a_1449_n4035# VSS sg13_lv_nmos ad=0.1064p pd=0.94u as=0.1904p ps=1.8u w=0.56u l=0.13u
X14 VDD_uq0 a_4475_n9186# a_4475_n8700# VDD_uq0 sg13_lv_pmos ad=0.3078p pd=2u as=0.3078p ps=2u w=1.62u l=0.385u
X15 VSS a_3251_n8342# a_3251_n8064# VSS sg13_lv_nmos ad=0.1577p pd=1.21u as=0.1577p ps=1.21u w=0.83u l=0.13u
X16 a_5521_n4104# a_3685_n3262# a_5521_n3654# VSS sg13_lv_nmos ad=0.3332p pd=2.64u as=0.1862p ps=1.36u w=0.98u l=0.13u
X17 a_5699_n3302# a_5699_n3024# VDD VDD sg13_lv_pmos ad=0.3078p pd=2u as=0.3078p ps=2u w=1.62u l=0.385u
X18 VSS a_1415_n8342# a_1415_n8064# VSS sg13_lv_nmos ad=0.1577p pd=1.21u as=0.1577p ps=1.21u w=0.83u l=0.13u
X19 a_3889_n4104# a_3481_n3262# a_3889_n3654# VSS sg13_lv_nmos ad=0.3332p pd=2.64u as=0.1862p ps=1.36u w=0.98u l=0.13u
X20 a_191_n8700# a_191_n9186# VDD_uq0 VDD_uq0 sg13_lv_pmos ad=0.3078p pd=2u as=0.3078p ps=2u w=1.62u l=0.385u
X21 VSS a_4475_n8700# a_4475_n9186# VSS sg13_lv_nmos ad=0.1577p pd=1.21u as=0.1577p ps=1.21u w=0.83u l=0.13u
X22 VSS a_803_n8342# a_803_n8064# VSS sg13_lv_nmos ad=0.1577p pd=1.21u as=0.1577p ps=1.21u w=0.83u l=0.13u
X23 VSS a_n115_n4982# a_n115_n4704# VSS sg13_lv_nmos ad=0.1577p pd=1.21u as=0.1577p ps=1.21u w=0.83u l=0.13u
X24 a_3073_n3186# ACLK_N a_2971_n3260# VSS sg13_lv_nmos ad=91.2f pd=0.86u as=0.13375p ps=1.23u w=0.48u l=0.13u
X25 a_2869_n4038# a_2537_n4040# VDD VDD sg13_lv_pmos ad=0.1881p pd=1.37u as=0.3366p ps=2.66u w=0.99u l=0.13u
X26 VSS a_n115_n4982# a_n115_n4704# VSS sg13_lv_nmos ad=0.1577p pd=1.21u as=0.1577p ps=1.21u w=0.83u l=0.13u
X27 VSS a_4475_n8700# a_4475_n9186# VSS sg13_lv_nmos ad=0.1577p pd=1.21u as=0.1577p ps=1.21u w=0.83u l=0.13u
X28 a_2869_n3218# a_2537_n3220# VSS VSS sg13_lv_nmos ad=0.1783p pd=1.44u as=0.289p ps=2.38u w=0.85u l=0.13u
X29 VSS a_2639_n8700# a_2639_n9186# VSS sg13_lv_nmos ad=0.1577p pd=1.21u as=0.1577p ps=1.21u w=0.83u l=0.13u
X30 VSS a_3863_n8700# a_3863_n9186# VSS sg13_lv_nmos ad=0.1577p pd=1.21u as=0.1577p ps=1.21u w=0.83u l=0.13u
X31 VSS a_6485_n8744# a_6447_n8664# VSS sg13_lv_nmos ad=0.1577p pd=1.21u as=0.2822p ps=2.34u w=0.83u l=0.13u
X32 VSS a_2027_n8700# a_2027_n9186# VSS sg13_lv_nmos ad=0.1577p pd=1.21u as=0.1577p ps=1.21u w=0.83u l=0.13u
X33 a_n1033_n8342# a_n1033_n8064# VDD_uq0 VDD_uq0 sg13_lv_pmos ad=0.3078p pd=2u as=0.5508p ps=3.92u w=1.62u l=0.385u
X34 a_5087_n8700# a_5087_n9186# VDD_uq0 VDD_uq0 sg13_lv_pmos ad=0.3078p pd=2u as=0.3078p ps=2u w=1.62u l=0.385u
X35 a_n727_n4704# a_n727_n4982# VSS VSS sg13_lv_nmos ad=0.1577p pd=1.21u as=0.1577p ps=1.21u w=0.83u l=0.13u
X36 a_3149_n4037# a_2971_n4038# VSS VSS sg13_lv_nmos ad=0.1632p pd=1.64u as=91.2f ps=0.86u w=0.48u l=0.13u
X37 a_5699_n9186# a_5699_n8700# VSS VSS sg13_lv_nmos ad=0.1577p pd=1.21u as=0.1577p ps=1.21u w=0.83u l=0.13u
X38 VDD_uq0 a_2639_n9186# a_2639_n8700# VDD_uq0 sg13_lv_pmos ad=0.3078p pd=2u as=0.3078p ps=2u w=1.62u l=0.385u
X39 a_2461_n2874# ACLK_N a_2359_n3262# VDD sg13_lv_pmos ad=91.2f pd=0.86u as=0.14927p ps=1.355u w=0.48u l=0.13u
X40 VSS a_2027_n8700# a_2027_n9186# VSS sg13_lv_nmos ad=0.1577p pd=1.21u as=0.1577p ps=1.21u w=0.83u l=0.13u
X41 a_n421_n8700# a_n421_n9186# VDD_uq0 VDD_uq0 sg13_lv_pmos ad=0.3078p pd=2u as=0.3078p ps=2u w=1.62u l=0.385u
X42 a_n115_n4704# a_n115_n4982# VSS VSS sg13_lv_nmos ad=0.1577p pd=1.21u as=0.1577p ps=1.21u w=0.83u l=0.13u
X43 VSS a_6485_n3704# a_6447_n3624# VSS sg13_lv_nmos ad=0.2822p pd=2.34u as=0.1577p ps=1.21u w=0.83u l=0.13u
X44 VDD_uq0 a_3863_n9186# a_3863_n8700# VDD_uq0 sg13_lv_pmos ad=0.3078p pd=2u as=0.3078p ps=2u w=1.62u l=0.385u
X45 a_497_n3302# a_497_n3024# VDD VDD sg13_lv_pmos ad=0.3078p pd=2u as=0.3078p ps=2u w=1.62u l=0.385u
X46 a_4475_n3024# a_4475_n3302# VSS VSS sg13_lv_nmos ad=0.1577p pd=1.21u as=0.1577p ps=1.21u w=0.83u l=0.13u
X47 a_1415_n8700# a_1415_n9186# VDD_uq0 VDD_uq0 sg13_lv_pmos ad=0.3078p pd=2u as=0.3078p ps=2u w=1.62u l=0.385u
X48 ADDR_DEC<0> a_5011_n4104# VSS VSS sg13_lv_nmos ad=0.3332p pd=2.64u as=0.3332p ps=2.64u w=0.98u l=0.13u
X49 a_n727_n3660# a_n727_n4146# VDD VDD sg13_lv_pmos ad=0.3078p pd=2u as=0.5508p ps=3.92u w=1.62u l=0.385u
X50 VDD a_3685_n3262# a_5521_n4104# VDD sg13_lv_pmos ad=0.5508p pd=3.92u as=0.3078p ps=2u w=1.62u l=0.13u
X51 a_2869_n2880# a_2537_n3220# VDD VDD sg13_lv_pmos ad=0.1881p pd=1.37u as=0.3366p ps=2.66u w=0.99u l=0.13u
X52 VDD a_3481_n3262# a_3889_n4104# VDD sg13_lv_pmos ad=0.5508p pd=3.92u as=0.3078p ps=2u w=1.62u l=0.13u
X53 a_6447_n3262# a_6485_n3082# VSS VSS sg13_lv_nmos ad=0.1577p pd=1.21u as=0.1577p ps=1.21u w=0.83u l=0.13u
X54 a_5087_n8342# a_5087_n8064# VDD_uq0 VDD_uq0 sg13_lv_pmos ad=0.3078p pd=2u as=0.3078p ps=2u w=1.62u l=0.385u
X55 a_3863_n8342# a_3863_n8064# VDD_uq0 VDD_uq0 sg13_lv_pmos ad=0.3078p pd=2u as=0.3078p ps=2u w=1.62u l=0.385u
X56 VDD_uq0 a_2027_n8064# a_2027_n8342# VDD_uq0 sg13_lv_pmos ad=0.3078p pd=2u as=0.3078p ps=2u w=1.62u l=0.385u
X57 a_497_n3302# a_497_n3024# VDD VDD sg13_lv_pmos ad=0.3078p pd=2u as=0.3078p ps=2u w=1.62u l=0.385u
X58 VSS a_5699_n3302# a_5699_n3024# VSS sg13_lv_nmos ad=0.2822p pd=2.34u as=0.1577p ps=1.21u w=0.83u l=0.13u
X59 a_3863_n9186# a_3863_n8700# VSS VSS sg13_lv_nmos ad=0.1577p pd=1.21u as=0.1577p ps=1.21u w=0.83u l=0.13u
X60 VDD a_4305_n3624# a_4343_n3704# VDD sg13_lv_pmos ad=0.5508p pd=3.92u as=0.3078p ps=2u w=1.62u l=0.385u
X61 a_5699_n3302# a_5699_n3024# VDD VDD sg13_lv_pmos ad=0.3078p pd=2u as=0.3078p ps=2u w=1.62u l=0.385u
X62 VDD a_3149_n4037# a_3073_n3938# VDD sg13_lv_pmos ad=91.2f pd=0.86u as=91.2f ps=0.86u w=0.48u l=0.13u
X63 VSS a_4475_n8342# a_4475_n8064# VSS sg13_lv_nmos ad=0.1577p pd=1.21u as=0.1577p ps=1.21u w=0.83u l=0.13u
X64 VDD a_6447_n3262# a_6485_n3082# VDD sg13_lv_pmos ad=0.5508p pd=3.92u as=0.3078p ps=2u w=1.62u l=0.385u
X65 a_191_n9186# a_191_n8700# VSS VSS sg13_lv_nmos ad=0.1577p pd=1.21u as=0.1577p ps=1.21u w=0.83u l=0.13u
X66 VDD_uq0 a_3863_n8064# a_3863_n8342# VDD_uq0 sg13_lv_pmos ad=0.3078p pd=2u as=0.3078p ps=2u w=1.62u l=0.385u
X67 a_1415_n8342# a_1415_n8064# VDD_uq0 VDD_uq0 sg13_lv_pmos ad=0.3078p pd=2u as=0.3078p ps=2u w=1.62u l=0.385u
X68 a_2027_n9186# a_2027_n8700# VSS VSS sg13_lv_nmos ad=0.1577p pd=1.21u as=0.1577p ps=1.21u w=0.83u l=0.13u
X69 VSS a_4475_n8342# a_4475_n8064# VSS sg13_lv_nmos ad=0.1577p pd=1.21u as=0.1577p ps=1.21u w=0.83u l=0.13u
X70 a_1211_n4980# a_1211_n4980# VDD VDD sg13_lv_pmos ad=0.1632p pd=1.64u as=0.1632p ps=1.64u w=0.48u l=0.13u
X71 VSS BIST_ADDR<0> a_1849_n3202# VSS sg13_lv_nmos ad=0.1904p pd=1.8u as=0.1064p ps=0.94u w=0.56u l=0.13u
X72 a_3685_n3262# a_3481_n3262# VDD VDD sg13_lv_pmos ad=0.5508p pd=3.92u as=0.5508p ps=3.92u w=1.62u l=0.13u
X73 VDD a_n727_n4704# a_n727_n4982# VDD sg13_lv_pmos ad=0.3078p pd=2u as=0.3078p ps=2u w=1.62u l=0.385u
X74 a_4305_n3624# a_4343_n3704# VSS VSS sg13_lv_nmos ad=0.1577p pd=1.21u as=0.1577p ps=1.21u w=0.83u l=0.13u
X75 VSS a_3863_n8342# a_3863_n8064# VSS sg13_lv_nmos ad=0.1577p pd=1.21u as=0.1577p ps=1.21u w=0.83u l=0.13u
X76 VSS a_2639_n8342# a_2639_n8064# VSS sg13_lv_nmos ad=0.1577p pd=1.21u as=0.1577p ps=1.21u w=0.83u l=0.13u
X77 VSS BIST_EN_I a_1449_n3202# VSS sg13_lv_nmos ad=0.1064p pd=0.94u as=0.1904p ps=1.8u w=0.56u l=0.13u
X78 VDD a_4475_n3024# a_4475_n3302# VDD sg13_lv_pmos ad=0.3078p pd=2u as=0.3078p ps=2u w=1.62u l=0.385u
X79 VSS a_6485_n8122# a_6447_n8302# VSS sg13_lv_nmos ad=0.1577p pd=1.21u as=0.2822p ps=2.34u w=0.83u l=0.13u
X80 VSS a_803_n8700# a_803_n9186# VSS sg13_lv_nmos ad=0.1577p pd=1.21u as=0.1577p ps=1.21u w=0.83u l=0.13u
X81 VSS a_4475_n3302# a_4475_n3024# VSS sg13_lv_nmos ad=0.1577p pd=1.21u as=0.1577p ps=1.21u w=0.83u l=0.13u
X82 VSS a_2027_n8342# a_2027_n8064# VSS sg13_lv_nmos ad=0.1577p pd=1.21u as=0.1577p ps=1.21u w=0.83u l=0.13u
X83 a_5699_n8064# a_5699_n8342# VSS VSS sg13_lv_nmos ad=0.1577p pd=1.21u as=0.1577p ps=1.21u w=0.83u l=0.13u
X84 a_n727_n3660# a_n727_n4146# VDD VDD sg13_lv_pmos ad=0.3078p pd=2u as=0.3078p ps=2u w=1.62u l=0.385u
X85 a_n115_n3302# a_n115_n3024# VDD VDD sg13_lv_pmos ad=0.3078p pd=2u as=0.3078p ps=2u w=1.62u l=0.385u
X86 VSS a_3863_n3302# a_3863_n3024# VSS sg13_lv_nmos ad=0.1577p pd=1.21u as=0.1577p ps=1.21u w=0.83u l=0.13u
X87 VSS a_2027_n8342# a_2027_n8064# VSS sg13_lv_nmos ad=0.1577p pd=1.21u as=0.1577p ps=1.21u w=0.83u l=0.13u
X88 ADDR_DEC<0> a_5011_n4104# VDD VDD sg13_lv_pmos ad=0.5508p pd=3.92u as=0.5508p ps=3.92u w=1.62u l=0.13u
X89 a_1645_n4035# ADDR<1> VDD VDD sg13_lv_pmos ad=0.18715p pd=1.365u as=0.16165p ps=1.365u w=0.985u l=0.13u
X90 VSS a_2537_n3220# a_2461_n3184# VSS sg13_lv_nmos ad=91.2f pd=0.86u as=91.2f ps=0.86u w=0.48u l=0.13u
X91 VDD_uq0 a_191_n9186# a_191_n8700# VDD_uq0 sg13_lv_pmos ad=0.3078p pd=2u as=0.3078p ps=2u w=1.62u l=0.385u
X92 a_2461_n3632# a_2061_n4035# a_2359_n4035# VSS sg13_lv_nmos ad=91.2f pd=0.86u as=0.13605p ps=1.25u w=0.48u l=0.13u
X93 a_2359_n3262# ACLK_N a_2257_n3262# VSS sg13_lv_nmos ad=0.13605p pd=1.25u as=0.1653p ps=1.25u w=0.87u l=0.13u
X94 VDD_uq0 a_2027_n8064# a_2027_n8342# VDD_uq0 sg13_lv_pmos ad=0.3078p pd=2u as=0.3078p ps=2u w=1.62u l=0.385u
X95 a_3149_n4037# a_2971_n4038# VDD VDD sg13_lv_pmos ad=0.1632p pd=1.64u as=91.2f ps=0.86u w=0.48u l=0.13u
X96 VDD a_497_n4146# a_497_n3660# VDD sg13_lv_pmos ad=0.5508p pd=3.92u as=0.3078p ps=2u w=1.62u l=0.385u
X97 a_5087_n3302# a_5087_n3024# VDD VDD sg13_lv_pmos ad=0.3078p pd=2u as=0.3078p ps=2u w=1.62u l=0.385u
X98 VSS a_n421_n8700# a_n421_n9186# VSS sg13_lv_nmos ad=0.1577p pd=1.21u as=0.1577p ps=1.21u w=0.83u l=0.13u
X99 a_n1033_n9186# a_n1033_n8700# VSS VSS sg13_lv_nmos ad=0.1577p pd=1.21u as=0.2822p ps=2.34u w=0.83u l=0.13u
X100 a_1211_n4140# a_1211_n4140# VDD VDD sg13_lv_pmos ad=0.1632p pd=1.64u as=0.1632p ps=1.64u w=0.48u l=0.13u
X101 a_n115_n3302# a_n115_n3024# VDD VDD sg13_lv_pmos ad=0.3078p pd=2u as=0.3078p ps=2u w=1.62u l=0.385u
X102 VSS a_191_n8700# a_191_n9186# VSS sg13_lv_nmos ad=0.1577p pd=1.21u as=0.1577p ps=1.21u w=0.83u l=0.13u
X103 VDD_uq0 a_n1033_n8064# a_n1033_n8342# VDD_uq0 sg13_lv_pmos ad=0.3078p pd=2u as=0.3078p ps=2u w=1.62u l=0.385u
X104 VDD_uq0 a_5087_n9186# a_5087_n8700# VDD_uq0 sg13_lv_pmos ad=0.3078p pd=2u as=0.3078p ps=2u w=1.62u l=0.385u
X105 a_3863_n8064# a_3863_n8342# VSS VSS sg13_lv_nmos ad=0.1577p pd=1.21u as=0.1577p ps=1.21u w=0.83u l=0.13u
X106 a_2639_n8700# a_2639_n9186# VDD_uq0 VDD_uq0 sg13_lv_pmos ad=0.3078p pd=2u as=0.3078p ps=2u w=1.62u l=0.385u
X107 a_3863_n8700# a_3863_n9186# VDD_uq0 VDD_uq0 sg13_lv_pmos ad=0.3078p pd=2u as=0.3078p ps=2u w=1.62u l=0.385u
X108 VDD_uq0 a_1415_n9186# a_1415_n8700# VDD_uq0 sg13_lv_pmos ad=0.3078p pd=2u as=0.3078p ps=2u w=1.62u l=0.385u
X109 a_6485_n8744# a_6447_n8664# VDD_uq0 VDD_uq0 sg13_lv_pmos ad=0.3078p pd=2u as=0.5508p ps=3.92u w=1.62u l=0.385u
X110 ADDR_DEC<6> a_4781_n4140# VSS VSS sg13_lv_nmos ad=0.1632p pd=1.64u as=0.1632p ps=1.64u w=0.48u l=0.13u
X111 a_1645_n2882# ADDR<0> VDD VDD sg13_lv_pmos ad=0.18715p pd=1.365u as=0.16165p ps=1.365u w=0.985u l=0.13u
X112 VDD a_3863_n3024# a_3863_n3302# VDD sg13_lv_pmos ad=0.3078p pd=2u as=0.3078p ps=2u w=1.62u l=0.385u
X113 a_191_n8064# a_191_n8342# VSS VSS sg13_lv_nmos ad=0.1577p pd=1.21u as=0.1577p ps=1.21u w=0.83u l=0.13u
X114 a_2027_n8064# a_2027_n8342# VSS VSS sg13_lv_nmos ad=0.1577p pd=1.21u as=0.1577p ps=1.21u w=0.83u l=0.13u
X115 a_1747_n4035# BIST_EN_I a_1645_n4035# VDD sg13_lv_pmos ad=0.18715p pd=1.365u as=0.18715p ps=1.365u w=0.985u l=0.13u
X116 a_497_n4146# a_497_n3660# VSS VSS sg13_lv_nmos ad=0.1577p pd=1.21u as=0.1577p ps=1.21u w=0.83u l=0.13u
X117 a_n1033_n9186# a_n1033_n8700# VSS VSS sg13_lv_nmos ad=0.1577p pd=1.21u as=0.1577p ps=1.21u w=0.83u l=0.13u
X118 a_5087_n9186# a_5087_n8700# VSS VSS sg13_lv_nmos ad=0.1577p pd=1.21u as=0.1577p ps=1.21u w=0.83u l=0.13u
X119 a_n421_n9186# a_n421_n8700# VSS VSS sg13_lv_nmos ad=0.1577p pd=1.21u as=0.1577p ps=1.21u w=0.83u l=0.13u
X120 VSS a_803_n8342# a_803_n8064# VSS sg13_lv_nmos ad=0.1577p pd=1.21u as=0.1577p ps=1.21u w=0.83u l=0.13u
X121 a_3863_n9186# a_3863_n8700# VSS VSS sg13_lv_nmos ad=0.1577p pd=1.21u as=0.1577p ps=1.21u w=0.83u l=0.13u
X122 a_5087_n9186# a_5087_n8700# VSS VSS sg13_lv_nmos ad=0.1577p pd=1.21u as=0.1577p ps=1.21u w=0.83u l=0.13u
X123 VDD a_3149_n3300# a_3073_n2878# VDD sg13_lv_pmos ad=91.2f pd=0.86u as=91.2f ps=0.86u w=0.48u l=0.13u
X124 VSS a_n115_n3302# a_n115_n3024# VSS sg13_lv_nmos ad=0.1577p pd=1.21u as=0.1577p ps=1.21u w=0.83u l=0.13u
X125 a_6031_n3654# a_3481_n4104# VSS VSS sg13_lv_nmos ad=0.1862p pd=1.36u as=0.3332p ps=2.64u w=0.98u l=0.13u
X126 a_2639_n8342# a_2639_n8064# VDD_uq0 VDD_uq0 sg13_lv_pmos ad=0.3078p pd=2u as=0.3078p ps=2u w=1.62u l=0.385u
X127 VSS a_497_n3660# a_497_n4146# VSS sg13_lv_nmos ad=0.1577p pd=1.21u as=0.1577p ps=1.21u w=0.83u l=0.13u
X128 a_3251_n9186# a_3251_n8700# VSS VSS sg13_lv_nmos ad=0.1577p pd=1.21u as=0.1577p ps=1.21u w=0.83u l=0.13u
X129 VSS a_5699_n8700# a_5699_n9186# VSS sg13_lv_nmos ad=0.1577p pd=1.21u as=0.1577p ps=1.21u w=0.83u l=0.13u
X130 a_2639_n9186# a_2639_n8700# VSS VSS sg13_lv_nmos ad=0.1577p pd=1.21u as=0.1577p ps=1.21u w=0.83u l=0.13u
X131 a_1415_n9186# a_1415_n8700# VSS VSS sg13_lv_nmos ad=0.1577p pd=1.21u as=0.1577p ps=1.21u w=0.83u l=0.13u
X132 VDD a_497_n4146# a_497_n3660# VDD sg13_lv_pmos ad=0.3078p pd=2u as=0.3078p ps=2u w=1.62u l=0.385u
X133 a_497_n3024# a_497_n3302# VSS VSS sg13_lv_nmos ad=0.1577p pd=1.21u as=0.1577p ps=1.21u w=0.83u l=0.13u
X134 a_1415_n9186# a_1415_n8700# VSS VSS sg13_lv_nmos ad=0.1577p pd=1.21u as=0.1577p ps=1.21u w=0.83u l=0.13u
X135 VDD a_n115_n4146# a_n115_n3660# VDD sg13_lv_pmos ad=0.3078p pd=2u as=0.3078p ps=2u w=1.62u l=0.385u
X136 a_n727_n3024# a_n727_n3302# VSS VSS sg13_lv_nmos ad=0.1577p pd=1.21u as=0.2822p ps=2.34u w=0.83u l=0.13u
X137 VDD_uq0 a_5087_n9186# a_5087_n8700# VDD_uq0 sg13_lv_pmos ad=0.3078p pd=2u as=0.3078p ps=2u w=1.62u l=0.385u
X138 VDD_uq0 a_n1033_n8064# a_n1033_n8342# VDD_uq0 sg13_lv_pmos ad=0.3078p pd=2u as=0.3078p ps=2u w=1.62u l=0.385u
X139 a_803_n9186# a_803_n8700# VSS VSS sg13_lv_nmos ad=0.1577p pd=1.21u as=0.1577p ps=1.21u w=0.83u l=0.13u
X140 VSS a_5087_n3302# a_5087_n3024# VSS sg13_lv_nmos ad=0.1577p pd=1.21u as=0.1577p ps=1.21u w=0.83u l=0.13u
X141 a_1747_n3202# BIST_EN_I a_1645_n2882# VDD sg13_lv_pmos ad=0.18715p pd=1.365u as=0.18715p ps=1.365u w=0.985u l=0.13u
X142 VDD_uq0 a_803_n9186# a_803_n8700# VDD_uq0 sg13_lv_pmos ad=0.3078p pd=2u as=0.3078p ps=2u w=1.62u l=0.385u
X143 VDD a_n727_n4146# a_n727_n3660# VDD sg13_lv_pmos ad=0.3078p pd=2u as=0.3078p ps=2u w=1.62u l=0.385u
X144 a_n727_n3024# a_n727_n3302# VSS VSS sg13_lv_nmos ad=0.1577p pd=1.21u as=0.1577p ps=1.21u w=0.83u l=0.13u
X145 a_n727_n4982# a_n727_n4704# VDD VDD sg13_lv_pmos ad=0.3078p pd=2u as=0.5508p ps=3.92u w=1.62u l=0.385u
X146 VDD a_2537_n4040# a_2461_n3942# VDD sg13_lv_pmos ad=91.2f pd=0.86u as=91.2f ps=0.86u w=0.48u l=0.13u
X147 VSS a_3863_n3302# a_3863_n3024# VSS sg13_lv_nmos ad=0.1577p pd=1.21u as=0.1577p ps=1.21u w=0.83u l=0.13u
X148 VSS a_5087_n3302# a_5087_n3024# VSS sg13_lv_nmos ad=0.1577p pd=1.21u as=0.1577p ps=1.21u w=0.83u l=0.13u
X149 VSS a_n421_n8342# a_n421_n8064# VSS sg13_lv_nmos ad=0.1577p pd=1.21u as=0.1577p ps=1.21u w=0.83u l=0.13u
X150 VSS a_497_n4982# a_497_n4704# VSS sg13_lv_nmos ad=0.1577p pd=1.21u as=0.1577p ps=1.21u w=0.83u l=0.13u
X151 a_n1033_n8064# a_n1033_n8342# VSS VSS sg13_lv_nmos ad=0.1577p pd=1.21u as=0.2822p ps=2.34u w=0.83u l=0.13u
X152 VSS a_191_n8342# a_191_n8064# VSS sg13_lv_nmos ad=0.1577p pd=1.21u as=0.1577p ps=1.21u w=0.83u l=0.13u
X153 a_4475_n8342# a_4475_n8064# VDD_uq0 VDD_uq0 sg13_lv_pmos ad=0.3078p pd=2u as=0.3078p ps=2u w=1.62u l=0.385u
X154 a_5699_n3024# a_5699_n3302# VSS VSS sg13_lv_nmos ad=0.1577p pd=1.21u as=0.1577p ps=1.21u w=0.83u l=0.13u
X155 VSS a_n115_n3660# a_n115_n4146# VSS sg13_lv_nmos ad=0.1577p pd=1.21u as=0.1577p ps=1.21u w=0.83u l=0.13u
X156 VDD a_n115_n3024# a_n115_n3302# VDD sg13_lv_pmos ad=0.3078p pd=2u as=0.3078p ps=2u w=1.62u l=0.385u
X157 a_3149_n3300# a_2971_n3260# VDD VDD sg13_lv_pmos ad=0.1632p pd=1.64u as=91.2f ps=0.86u w=0.48u l=0.13u
X158 a_497_n4704# a_497_n4982# VSS VSS sg13_lv_nmos ad=0.1577p pd=1.21u as=0.1577p ps=1.21u w=0.83u l=0.13u
X159 VSS a_n115_n3660# a_n115_n4146# VSS sg13_lv_nmos ad=0.1577p pd=1.21u as=0.1577p ps=1.21u w=0.83u l=0.13u
X160 VDD_uq0 a_3251_n8064# a_3251_n8342# VDD_uq0 sg13_lv_pmos ad=0.3078p pd=2u as=0.3078p ps=2u w=1.62u l=0.385u
X161 a_6031_n4104# a_3481_n4104# VDD VDD sg13_lv_pmos ad=0.3078p pd=2u as=0.5508p ps=3.92u w=1.62u l=0.13u
X162 a_2027_n8342# a_2027_n8064# VDD_uq0 VDD_uq0 sg13_lv_pmos ad=0.3078p pd=2u as=0.3078p ps=2u w=1.62u l=0.385u
X163 a_n1033_n8064# a_n1033_n8342# VSS VSS sg13_lv_nmos ad=0.1577p pd=1.21u as=0.1577p ps=1.21u w=0.83u l=0.13u
X164 a_5087_n8064# a_5087_n8342# VSS VSS sg13_lv_nmos ad=0.1577p pd=1.21u as=0.1577p ps=1.21u w=0.83u l=0.13u
X165 a_n727_n4146# a_n727_n3660# VSS VSS sg13_lv_nmos ad=0.1577p pd=1.21u as=0.1577p ps=1.21u w=0.83u l=0.13u
X166 a_n421_n8064# a_n421_n8342# VSS VSS sg13_lv_nmos ad=0.1577p pd=1.21u as=0.1577p ps=1.21u w=0.83u l=0.13u
X167 a_5087_n8064# a_5087_n8342# VSS VSS sg13_lv_nmos ad=0.1577p pd=1.21u as=0.1577p ps=1.21u w=0.83u l=0.13u
X168 a_3863_n8064# a_3863_n8342# VSS VSS sg13_lv_nmos ad=0.1577p pd=1.21u as=0.1577p ps=1.21u w=0.83u l=0.13u
X169 VDD a_5087_n3024# a_5087_n3302# VDD sg13_lv_pmos ad=0.3078p pd=2u as=0.3078p ps=2u w=1.62u l=0.385u
X170 a_1645_n3630# ADDR<1> VSS VSS sg13_lv_nmos ad=0.1064p pd=0.94u as=0.1064p ps=0.94u w=0.56u l=0.13u
X171 a_3863_n3302# a_3863_n3024# VDD VDD sg13_lv_pmos ad=0.3078p pd=2u as=0.3078p ps=2u w=1.62u l=0.385u
X172 a_n115_n4146# a_n115_n3660# VSS VSS sg13_lv_nmos ad=0.1577p pd=1.21u as=0.1577p ps=1.21u w=0.83u l=0.13u
X173 a_6485_n3082# a_6447_n3262# VDD VDD sg13_lv_pmos ad=0.3078p pd=2u as=0.5508p ps=3.92u w=1.62u l=0.385u
X174 a_3251_n8064# a_3251_n8342# VSS VSS sg13_lv_nmos ad=0.1577p pd=1.21u as=0.1577p ps=1.21u w=0.83u l=0.13u
X175 VSS a_5699_n8342# a_5699_n8064# VSS sg13_lv_nmos ad=0.1577p pd=1.21u as=0.1577p ps=1.21u w=0.83u l=0.13u
X176 VSS a_n727_n3302# a_n727_n3024# VSS sg13_lv_nmos ad=0.1577p pd=1.21u as=0.1577p ps=1.21u w=0.83u l=0.13u
X177 a_5087_n3024# a_5087_n3302# VSS VSS sg13_lv_nmos ad=0.1577p pd=1.21u as=0.1577p ps=1.21u w=0.83u l=0.13u
X178 a_2639_n8064# a_2639_n8342# VSS VSS sg13_lv_nmos ad=0.1577p pd=1.21u as=0.1577p ps=1.21u w=0.83u l=0.13u
X179 a_1415_n8064# a_1415_n8342# VSS VSS sg13_lv_nmos ad=0.1577p pd=1.21u as=0.1577p ps=1.21u w=0.83u l=0.13u
X180 a_n1033_n8700# a_n1033_n9186# VDD_uq0 VDD_uq0 sg13_lv_pmos ad=0.3078p pd=2u as=0.5508p ps=3.92u w=1.62u l=0.385u
X181 a_n115_n4704# a_n115_n4982# VSS VSS sg13_lv_nmos ad=0.1577p pd=1.21u as=0.1577p ps=1.21u w=0.83u l=0.13u
X182 a_n727_n4982# a_n727_n4704# VDD VDD sg13_lv_pmos ad=0.3078p pd=2u as=0.3078p ps=2u w=1.62u l=0.385u
X183 a_1415_n8064# a_1415_n8342# VSS VSS sg13_lv_nmos ad=0.1577p pd=1.21u as=0.1577p ps=1.21u w=0.83u l=0.13u
X184 a_n115_n4704# a_n115_n4982# VSS VSS sg13_lv_nmos ad=0.1577p pd=1.21u as=0.1577p ps=1.21u w=0.83u l=0.13u
X185 VSS a_3149_n3300# a_3073_n3186# VSS sg13_lv_nmos ad=91.2f pd=0.86u as=91.2f ps=0.86u w=0.48u l=0.13u
X186 a_3685_n4104# a_3481_n4104# VSS VSS sg13_lv_nmos ad=0.3332p pd=2.64u as=0.3332p ps=2.64u w=0.98u l=0.13u
X187 VDD ACLK_N a_2061_n4035# VDD sg13_lv_pmos ad=0.14812p pd=1.355u as=0.1632p ps=1.64u w=0.48u l=0.13u
X188 a_2971_n4038# ACLK_N a_2869_n4038# VDD sg13_lv_pmos ad=0.1511p pd=1.37u as=0.1881p ps=1.37u w=0.99u l=0.13u
X189 a_4475_n9186# a_4475_n8700# VSS VSS sg13_lv_nmos ad=0.1577p pd=1.21u as=0.1577p ps=1.21u w=0.83u l=0.13u
X190 a_803_n8064# a_803_n8342# VSS VSS sg13_lv_nmos ad=0.1577p pd=1.21u as=0.1577p ps=1.21u w=0.83u l=0.13u
X191 a_6447_n8664# a_6485_n8744# VSS VSS sg13_lv_nmos ad=0.1577p pd=1.21u as=0.1577p ps=1.21u w=0.83u l=0.13u
X192 VDD ACLK_N a_2061_n3262# VDD sg13_lv_pmos ad=0.14812p pd=1.355u as=0.1632p ps=1.64u w=0.48u l=0.13u
X193 a_497_n3660# a_497_n4146# VDD VDD sg13_lv_pmos ad=0.3078p pd=2u as=0.3078p ps=2u w=1.62u l=0.385u
X194 ADDR_COL<0> a_1211_n3300# VSS VSS sg13_lv_nmos ad=0.1632p pd=1.64u as=0.1632p ps=1.64u w=0.48u l=0.13u
X195 a_2639_n9186# a_2639_n8700# VSS VSS sg13_lv_nmos ad=0.1577p pd=1.21u as=0.1577p ps=1.21u w=0.83u l=0.13u
X196 VSS a_n727_n4982# a_n727_n4704# VSS sg13_lv_nmos ad=0.1577p pd=1.21u as=0.1577p ps=1.21u w=0.83u l=0.13u
X197 VDD a_497_n4704# a_497_n4982# VDD sg13_lv_pmos ad=0.5508p pd=3.92u as=0.3078p ps=2u w=1.62u l=0.385u
X198 VSS a_5699_n8700# a_5699_n9186# VSS sg13_lv_nmos ad=0.2822p pd=2.34u as=0.1577p ps=1.21u w=0.83u l=0.13u
X199 VDD a_2537_n3220# a_2461_n2874# VDD sg13_lv_pmos ad=91.2f pd=0.86u as=91.2f ps=0.86u w=0.48u l=0.13u
X200 a_3863_n8700# a_3863_n9186# VDD_uq0 VDD_uq0 sg13_lv_pmos ad=0.3078p pd=2u as=0.3078p ps=2u w=1.62u l=0.385u
X201 a_5087_n8700# a_5087_n9186# VDD_uq0 VDD_uq0 sg13_lv_pmos ad=0.3078p pd=2u as=0.3078p ps=2u w=1.62u l=0.385u
X202 VSS a_n727_n4982# a_n727_n4704# VSS sg13_lv_nmos ad=0.1577p pd=1.21u as=0.1577p ps=1.21u w=0.83u l=0.13u
X203 a_1747_n4035# a_1449_n4035# a_1645_n3630# VSS sg13_lv_nmos ad=0.1064p pd=0.94u as=0.1064p ps=0.94u w=0.56u l=0.13u
X204 VDD_uq0 a_2027_n9186# a_2027_n8700# VDD_uq0 sg13_lv_pmos ad=0.3078p pd=2u as=0.3078p ps=2u w=1.62u l=0.385u
X205 a_497_n3660# a_497_n4146# VDD VDD sg13_lv_pmos ad=0.3078p pd=2u as=0.3078p ps=2u w=1.62u l=0.385u
X206 VDD a_5087_n3024# a_5087_n3302# VDD sg13_lv_pmos ad=0.3078p pd=2u as=0.3078p ps=2u w=1.62u l=0.385u
X207 a_n1033_n8342# a_n1033_n8064# VDD_uq0 VDD_uq0 sg13_lv_pmos ad=0.3078p pd=2u as=0.3078p ps=2u w=1.62u l=0.385u
X208 VDD_uq0 a_3863_n9186# a_3863_n8700# VDD_uq0 sg13_lv_pmos ad=0.3078p pd=2u as=0.3078p ps=2u w=1.62u l=0.385u
X209 a_2971_n3260# ACLK_N a_2869_n2880# VDD sg13_lv_pmos ad=0.1511p pd=1.37u as=0.1881p ps=1.37u w=0.99u l=0.13u
X210 a_3149_n3300# a_2971_n3260# VSS VSS sg13_lv_nmos ad=0.1632p pd=1.64u as=91.2f ps=0.86u w=0.48u l=0.13u
X211 VDD a_6447_n3624# a_6485_n3704# VDD sg13_lv_pmos ad=0.5508p pd=3.92u as=0.3078p ps=2u w=1.62u l=0.385u
X212 a_1415_n8700# a_1415_n9186# VDD_uq0 VDD_uq0 sg13_lv_pmos ad=0.3078p pd=2u as=0.3078p ps=2u w=1.62u l=0.385u
X213 VSS a_6485_n3082# a_6447_n3262# VSS sg13_lv_nmos ad=0.2822p pd=2.34u as=0.1577p ps=1.21u w=0.83u l=0.13u
X214 a_2257_n4035# a_1747_n4035# VDD VDD sg13_lv_pmos ad=0.18525p pd=1.355u as=0.14812p ps=1.355u w=0.975u l=0.13u
X215 VSS a_4475_n8700# a_4475_n9186# VSS sg13_lv_nmos ad=0.1577p pd=1.21u as=0.1577p ps=1.21u w=0.83u l=0.13u
X216 VDD_uq0 a_5699_n8064# a_5699_n8342# VDD_uq0 sg13_lv_pmos ad=0.5508p pd=3.92u as=0.3078p ps=2u w=1.62u l=0.385u
X217 VDD_uq0 a_4475_n8064# a_4475_n8342# VDD_uq0 sg13_lv_pmos ad=0.3078p pd=2u as=0.3078p ps=2u w=1.62u l=0.385u
X218 VSS a_497_n4982# a_497_n4704# VSS sg13_lv_nmos ad=0.2822p pd=2.34u as=0.1577p ps=1.21u w=0.83u l=0.13u
X219 a_3685_n4104# a_3481_n4104# VDD VDD sg13_lv_pmos ad=0.5508p pd=3.92u as=0.5508p ps=3.92u w=1.62u l=0.13u
X220 a_3251_n8342# a_3251_n8064# VDD_uq0 VDD_uq0 sg13_lv_pmos ad=0.3078p pd=2u as=0.3078p ps=2u w=1.62u l=0.385u
X221 VSS a_3863_n8700# a_3863_n9186# VSS sg13_lv_nmos ad=0.1577p pd=1.21u as=0.1577p ps=1.21u w=0.83u l=0.13u
X222 a_1211_n3300# a_1211_n3300# VDD VDD sg13_lv_pmos ad=0.1632p pd=1.64u as=0.1632p ps=1.64u w=0.48u l=0.13u
X223 VSS a_2639_n8700# a_2639_n9186# VSS sg13_lv_nmos ad=0.1577p pd=1.21u as=0.1577p ps=1.21u w=0.83u l=0.13u
X224 ADDR_DEC<5> a_1211_n4140# VSS VSS sg13_lv_nmos ad=0.1632p pd=1.64u as=0.1632p ps=1.64u w=0.48u l=0.13u
X225 a_n115_n3660# a_n115_n4146# VDD VDD sg13_lv_pmos ad=0.3078p pd=2u as=0.3078p ps=2u w=1.62u l=0.385u
X226 VSS a_2027_n8700# a_2027_n9186# VSS sg13_lv_nmos ad=0.1577p pd=1.21u as=0.1577p ps=1.21u w=0.83u l=0.13u
X227 a_4475_n8064# a_4475_n8342# VSS VSS sg13_lv_nmos ad=0.1577p pd=1.21u as=0.1577p ps=1.21u w=0.83u l=0.13u
X228 VDD a_497_n4704# a_497_n4982# VDD sg13_lv_pmos ad=0.3078p pd=2u as=0.3078p ps=2u w=1.62u l=0.385u
X229 a_803_n8342# a_803_n8064# VDD_uq0 VDD_uq0 sg13_lv_pmos ad=0.3078p pd=2u as=0.3078p ps=2u w=1.62u l=0.385u
X230 VDD a_n115_n4704# a_n115_n4982# VDD sg13_lv_pmos ad=0.3078p pd=2u as=0.3078p ps=2u w=1.62u l=0.385u
X231 VSS a_4343_n3704# a_4305_n3624# VSS sg13_lv_nmos ad=0.2822p pd=2.34u as=0.1577p ps=1.21u w=0.83u l=0.13u
X232 a_1645_n3202# ADDR<0> VSS VSS sg13_lv_nmos ad=0.1064p pd=0.94u as=0.1064p ps=0.94u w=0.56u l=0.13u
X233 VDD_uq0 a_2027_n9186# a_2027_n8700# VDD_uq0 sg13_lv_pmos ad=0.3078p pd=2u as=0.3078p ps=2u w=1.62u l=0.385u
X234 a_6447_n8302# a_6485_n8122# VSS VSS sg13_lv_nmos ad=0.1577p pd=1.21u as=0.1577p ps=1.21u w=0.83u l=0.13u
X235 VDD a_n999_n4104# a_n999_n4104# VDD sg13_lv_pmos ad=0.1632p pd=1.64u as=0.1632p ps=1.64u w=0.48u l=0.13u
X236 a_4475_n3024# a_4475_n3302# VSS VSS sg13_lv_nmos ad=0.1577p pd=1.21u as=0.1577p ps=1.21u w=0.83u l=0.13u
X237 a_2639_n8064# a_2639_n8342# VSS VSS sg13_lv_nmos ad=0.1577p pd=1.21u as=0.1577p ps=1.21u w=0.83u l=0.13u
X238 VDD a_n727_n4704# a_n727_n4982# VDD sg13_lv_pmos ad=0.3078p pd=2u as=0.3078p ps=2u w=1.62u l=0.385u
X239 VSS a_6485_n3704# a_6447_n3624# VSS sg13_lv_nmos ad=0.1577p pd=1.21u as=0.2822p ps=2.34u w=0.83u l=0.13u
X240 VSS a_5699_n8342# a_5699_n8064# VSS sg13_lv_nmos ad=0.2822p pd=2.34u as=0.1577p ps=1.21u w=0.83u l=0.13u
X241 a_4475_n3024# a_4475_n3302# VSS VSS sg13_lv_nmos ad=0.1577p pd=1.21u as=0.1577p ps=1.21u w=0.83u l=0.13u
X242 a_n421_n8342# a_n421_n8064# VDD_uq0 VDD_uq0 sg13_lv_pmos ad=0.3078p pd=2u as=0.3078p ps=2u w=1.62u l=0.385u
X243 a_3863_n3024# a_3863_n3302# VSS VSS sg13_lv_nmos ad=0.1577p pd=1.21u as=0.1577p ps=1.21u w=0.83u l=0.13u
X244 a_n115_n3660# a_n115_n4146# VDD VDD sg13_lv_pmos ad=0.3078p pd=2u as=0.3078p ps=2u w=1.62u l=0.385u
X245 a_2537_n3220# a_2359_n3262# VSS VSS sg13_lv_nmos ad=0.1632p pd=1.64u as=91.2f ps=0.86u w=0.48u l=0.13u
X246 VDD_uq0 a_n1033_n9186# a_n1033_n8700# VDD_uq0 sg13_lv_pmos ad=0.3078p pd=2u as=0.3078p ps=2u w=1.62u l=0.385u
X247 VSS a_2537_n4040# a_2461_n3632# VSS sg13_lv_nmos ad=91.2f pd=0.86u as=91.2f ps=0.86u w=0.48u l=0.13u
X248 a_2257_n2880# a_1747_n3202# VDD VDD sg13_lv_pmos ad=0.18525p pd=1.355u as=0.14812p ps=1.355u w=0.975u l=0.13u
X249 VSS a_5699_n3302# a_5699_n3024# VSS sg13_lv_nmos ad=0.1577p pd=1.21u as=0.1577p ps=1.21u w=0.83u l=0.13u
X250 a_3251_n8342# a_3251_n8064# VDD_uq0 VDD_uq0 sg13_lv_pmos ad=0.3078p pd=2u as=0.3078p ps=2u w=1.62u l=0.385u
X251 a_2971_n4038# a_2061_n4035# a_2869_n3672# VSS sg13_lv_nmos ad=0.13375p pd=1.23u as=0.1783p ps=1.44u w=0.85u l=0.13u
X252 VDD_uq0 a_803_n8064# a_803_n8342# VDD_uq0 sg13_lv_pmos ad=0.3078p pd=2u as=0.3078p ps=2u w=1.62u l=0.385u
X253 VSS a_4475_n8342# a_4475_n8064# VSS sg13_lv_nmos ad=0.1577p pd=1.21u as=0.1577p ps=1.21u w=0.83u l=0.13u
X254 a_191_n9186# a_191_n8700# VSS VSS sg13_lv_nmos ad=0.1577p pd=1.21u as=0.1577p ps=1.21u w=0.83u l=0.13u
X255 a_3863_n3302# a_3863_n3024# VDD VDD sg13_lv_pmos ad=0.3078p pd=2u as=0.5508p ps=3.92u w=1.62u l=0.385u
X256 a_5087_n3302# a_5087_n3024# VDD VDD sg13_lv_pmos ad=0.3078p pd=2u as=0.3078p ps=2u w=1.62u l=0.385u
X257 VSS a_3863_n8342# a_3863_n8064# VSS sg13_lv_nmos ad=0.1577p pd=1.21u as=0.1577p ps=1.21u w=0.83u l=0.13u
X258 a_1747_n3202# a_1449_n3202# a_1645_n3202# VSS sg13_lv_nmos ad=0.1064p pd=0.94u as=0.1064p ps=0.94u w=0.56u l=0.13u
X259 a_3481_n3262# a_2971_n3260# VDD VDD sg13_lv_pmos ad=0.5508p pd=3.92u as=0.5508p ps=3.92u w=1.62u l=0.13u
X260 a_2639_n8700# a_2639_n9186# VDD_uq0 VDD_uq0 sg13_lv_pmos ad=0.3078p pd=2u as=0.3078p ps=2u w=1.62u l=0.385u
X261 VSS a_2639_n8342# a_2639_n8064# VSS sg13_lv_nmos ad=0.1577p pd=1.21u as=0.1577p ps=1.21u w=0.83u l=0.13u
X262 a_5011_n3654# a_3481_n4104# VSS VSS sg13_lv_nmos ad=0.1862p pd=1.36u as=0.3332p ps=2.64u w=0.98u l=0.13u
X263 VSS a_191_n8700# a_191_n9186# VSS sg13_lv_nmos ad=0.1577p pd=1.21u as=0.1577p ps=1.21u w=0.83u l=0.13u
X264 VSS a_2027_n8342# a_2027_n8064# VSS sg13_lv_nmos ad=0.1577p pd=1.21u as=0.1577p ps=1.21u w=0.83u l=0.13u
X265 VDD a_3863_n3024# a_3863_n3302# VDD sg13_lv_pmos ad=0.3078p pd=2u as=0.3078p ps=2u w=1.62u l=0.385u
X266 a_1849_n4035# a_1449_n4035# a_1747_n4035# VDD sg13_lv_pmos ad=0.18715p pd=1.365u as=0.18715p ps=1.365u w=0.985u l=0.13u
X267 VSS a_497_n3660# a_497_n4146# VSS sg13_lv_nmos ad=0.1577p pd=1.21u as=0.1577p ps=1.21u w=0.83u l=0.13u
X268 VSS a_n1033_n8700# a_n1033_n9186# VSS sg13_lv_nmos ad=0.1577p pd=1.21u as=0.1577p ps=1.21u w=0.83u l=0.13u
X269 VSS a_5087_n8700# a_5087_n9186# VSS sg13_lv_nmos ad=0.1577p pd=1.21u as=0.1577p ps=1.21u w=0.83u l=0.13u
X270 ADDR_DEC<2> a_3889_n4104# VSS VSS sg13_lv_nmos ad=0.3332p pd=2.64u as=0.3332p ps=2.64u w=0.98u l=0.13u
X271 VSS a_n421_n8700# a_n421_n9186# VSS sg13_lv_nmos ad=0.1577p pd=1.21u as=0.1577p ps=1.21u w=0.83u l=0.13u
X272 VSS a_3863_n8700# a_3863_n9186# VSS sg13_lv_nmos ad=0.1577p pd=1.21u as=0.1577p ps=1.21u w=0.83u l=0.13u
X273 VSS a_5087_n8700# a_5087_n9186# VSS sg13_lv_nmos ad=0.1577p pd=1.21u as=0.1577p ps=1.21u w=0.83u l=0.13u
X274 VDD_uq0 a_n1033_n9186# a_n1033_n8700# VDD_uq0 sg13_lv_pmos ad=0.3078p pd=2u as=0.3078p ps=2u w=1.62u l=0.385u
X275 a_497_n3024# a_497_n3302# VSS VSS sg13_lv_nmos ad=0.1577p pd=1.21u as=0.1577p ps=1.21u w=0.83u l=0.13u
X276 a_6031_n4104# a_3685_n3262# a_6031_n3654# VSS sg13_lv_nmos ad=0.3332p pd=2.64u as=0.1862p ps=1.36u w=0.98u l=0.13u
X277 a_2257_n3632# a_1747_n4035# VSS VSS sg13_lv_nmos ad=0.1653p pd=1.25u as=0.13717p ps=1.25u w=0.87u l=0.13u
X278 a_497_n4146# a_497_n3660# VSS VSS sg13_lv_nmos ad=0.1577p pd=1.21u as=0.1577p ps=1.21u w=0.83u l=0.13u
X279 VSS a_3251_n8700# a_3251_n9186# VSS sg13_lv_nmos ad=0.1577p pd=1.21u as=0.1577p ps=1.21u w=0.83u l=0.13u
X280 a_5699_n9186# a_5699_n8700# VSS VSS sg13_lv_nmos ad=0.1577p pd=1.21u as=0.1577p ps=1.21u w=0.83u l=0.13u
X281 a_497_n4982# a_497_n4704# VDD VDD sg13_lv_pmos ad=0.3078p pd=2u as=0.3078p ps=2u w=1.62u l=0.385u
X282 VSS a_1415_n8700# a_1415_n9186# VSS sg13_lv_nmos ad=0.1577p pd=1.21u as=0.1577p ps=1.21u w=0.83u l=0.13u
X283 VSS a_2639_n8700# a_2639_n9186# VSS sg13_lv_nmos ad=0.1577p pd=1.21u as=0.1577p ps=1.21u w=0.83u l=0.13u
X284 a_4475_n8700# a_4475_n9186# VDD_uq0 VDD_uq0 sg13_lv_pmos ad=0.3078p pd=2u as=0.3078p ps=2u w=1.62u l=0.385u
X285 VSS a_497_n3302# a_497_n3024# VSS sg13_lv_nmos ad=0.1577p pd=1.21u as=0.1577p ps=1.21u w=0.83u l=0.13u
X286 VSS a_1415_n8700# a_1415_n9186# VSS sg13_lv_nmos ad=0.1577p pd=1.21u as=0.1577p ps=1.21u w=0.83u l=0.13u
X287 VDD_uq0 a_191_n8064# a_191_n8342# VDD_uq0 sg13_lv_pmos ad=0.3078p pd=2u as=0.3078p ps=2u w=1.62u l=0.385u
X288 VDD_uq0 a_n421_n8064# a_n421_n8342# VDD_uq0 sg13_lv_pmos ad=0.3078p pd=2u as=0.3078p ps=2u w=1.62u l=0.385u
X289 VDD a_n115_n4146# a_n115_n3660# VDD sg13_lv_pmos ad=0.3078p pd=2u as=0.3078p ps=2u w=1.62u l=0.385u
X290 a_497_n4982# a_497_n4704# VDD VDD sg13_lv_pmos ad=0.3078p pd=2u as=0.3078p ps=2u w=1.62u l=0.385u
X291 VSS a_803_n8700# a_803_n9186# VSS sg13_lv_nmos ad=0.1577p pd=1.21u as=0.1577p ps=1.21u w=0.83u l=0.13u
X292 a_5699_n3024# a_5699_n3302# VSS VSS sg13_lv_nmos ad=0.1577p pd=1.21u as=0.1577p ps=1.21u w=0.83u l=0.13u
X293 a_1849_n2882# a_1449_n3202# a_1747_n3202# VDD sg13_lv_pmos ad=0.18715p pd=1.365u as=0.18715p ps=1.365u w=0.985u l=0.13u
X294 VDD_uq0 a_3251_n9186# a_3251_n8700# VDD_uq0 sg13_lv_pmos ad=0.3078p pd=2u as=0.3078p ps=2u w=1.62u l=0.385u
X295 VDD_uq0 a_n421_n8064# a_n421_n8342# VDD_uq0 sg13_lv_pmos ad=0.3078p pd=2u as=0.3078p ps=2u w=1.62u l=0.385u
X296 a_2537_n4040# a_2359_n4035# VDD VDD sg13_lv_pmos ad=0.1632p pd=1.64u as=91.2f ps=0.86u w=0.48u l=0.13u
X297 a_2027_n8700# a_2027_n9186# VDD_uq0 VDD_uq0 sg13_lv_pmos ad=0.3078p pd=2u as=0.3078p ps=2u w=1.62u l=0.385u
X298 a_5011_n4104# a_3481_n4104# VDD VDD sg13_lv_pmos ad=0.3078p pd=2u as=0.5508p ps=3.92u w=1.62u l=0.13u
X299 a_191_n8064# a_191_n8342# VSS VSS sg13_lv_nmos ad=0.1577p pd=1.21u as=0.1577p ps=1.21u w=0.83u l=0.13u
X300 a_3685_n3262# a_3481_n3262# VSS VSS sg13_lv_nmos ad=0.3332p pd=2.64u as=0.3332p ps=2.64u w=0.98u l=0.13u
X301 a_n115_n4146# a_n115_n3660# VSS VSS sg13_lv_nmos ad=0.1577p pd=1.21u as=0.1577p ps=1.21u w=0.83u l=0.13u
X302 VDD_uq0 a_5699_n8064# a_5699_n8342# VDD_uq0 sg13_lv_pmos ad=0.3078p pd=2u as=0.3078p ps=2u w=1.62u l=0.385u
X303 a_n115_n4146# a_n115_n3660# VSS VSS sg13_lv_nmos ad=0.1577p pd=1.21u as=0.1577p ps=1.21u w=0.83u l=0.13u
X304 a_n421_n9186# a_n421_n8700# VSS VSS sg13_lv_nmos ad=0.1577p pd=1.21u as=0.1577p ps=1.21u w=0.83u l=0.13u
X305 a_4475_n8342# a_4475_n8064# VDD_uq0 VDD_uq0 sg13_lv_pmos ad=0.3078p pd=2u as=0.3078p ps=2u w=1.62u l=0.385u
X306 a_5087_n9186# a_5087_n8700# VSS VSS sg13_lv_nmos ad=0.1577p pd=1.21u as=0.1577p ps=1.21u w=0.83u l=0.13u
X307 VDD_uq0 a_2639_n8064# a_2639_n8342# VDD_uq0 sg13_lv_pmos ad=0.3078p pd=2u as=0.3078p ps=2u w=1.62u l=0.385u
X308 VDD_uq0 a_1415_n8064# a_1415_n8342# VDD_uq0 sg13_lv_pmos ad=0.3078p pd=2u as=0.3078p ps=2u w=1.62u l=0.385u
X309 ADDR_DEC<2> a_3889_n4104# VDD VDD sg13_lv_pmos ad=0.5508p pd=3.92u as=0.5508p ps=3.92u w=1.62u l=0.13u
X310 a_6485_n3704# a_6447_n3624# VDD VDD sg13_lv_pmos ad=0.3078p pd=2u as=0.5508p ps=3.92u w=1.62u l=0.385u
X311 VSS a_191_n8342# a_191_n8064# VSS sg13_lv_nmos ad=0.1577p pd=1.21u as=0.1577p ps=1.21u w=0.83u l=0.13u
X312 VSS a_n115_n3302# a_n115_n3024# VSS sg13_lv_nmos ad=0.1577p pd=1.21u as=0.1577p ps=1.21u w=0.83u l=0.13u
X313 VDD a_3685_n3262# a_6031_n4104# VDD sg13_lv_pmos ad=0.5508p pd=3.92u as=0.3078p ps=2u w=1.62u l=0.13u
X314 a_3251_n9186# a_3251_n8700# VSS VSS sg13_lv_nmos ad=0.1577p pd=1.21u as=0.1577p ps=1.21u w=0.83u l=0.13u
X315 VSS a_n1033_n8342# a_n1033_n8064# VSS sg13_lv_nmos ad=0.1577p pd=1.21u as=0.1577p ps=1.21u w=0.83u l=0.13u
X316 a_5699_n8342# a_5699_n8064# VDD_uq0 VDD_uq0 sg13_lv_pmos ad=0.3078p pd=2u as=0.3078p ps=2u w=1.62u l=0.385u
X317 VSS a_5087_n8342# a_5087_n8064# VSS sg13_lv_nmos ad=0.1577p pd=1.21u as=0.1577p ps=1.21u w=0.83u l=0.13u
X318 VSS a_n115_n3302# a_n115_n3024# VSS sg13_lv_nmos ad=0.1577p pd=1.21u as=0.1577p ps=1.21u w=0.83u l=0.13u
X319 VDD_uq0 a_3251_n8064# a_3251_n8342# VDD_uq0 sg13_lv_pmos ad=0.3078p pd=2u as=0.3078p ps=2u w=1.62u l=0.385u
X320 a_n115_n4982# a_n115_n4704# VDD VDD sg13_lv_pmos ad=0.3078p pd=2u as=0.3078p ps=2u w=1.62u l=0.385u
X321 a_2027_n8342# a_2027_n8064# VDD_uq0 VDD_uq0 sg13_lv_pmos ad=0.3078p pd=2u as=0.3078p ps=2u w=1.62u l=0.385u
X322 VSS a_n727_n3660# a_n727_n4146# VSS sg13_lv_nmos ad=0.1577p pd=1.21u as=0.1577p ps=1.21u w=0.83u l=0.13u
X323 VSS a_n421_n8342# a_n421_n8064# VSS sg13_lv_nmos ad=0.1577p pd=1.21u as=0.1577p ps=1.21u w=0.83u l=0.13u
X324 VSS a_5087_n8342# a_5087_n8064# VSS sg13_lv_nmos ad=0.1577p pd=1.21u as=0.1577p ps=1.21u w=0.83u l=0.13u
X325 VSS a_3863_n8342# a_3863_n8064# VSS sg13_lv_nmos ad=0.1577p pd=1.21u as=0.1577p ps=1.21u w=0.83u l=0.13u
X326 VSS a_n999_n2712# ADDR_DEC<4> VSS sg13_lv_nmos ad=0.1632p pd=1.64u as=0.1632p ps=1.64u w=0.48u l=0.13u
X327 a_803_n9186# a_803_n8700# VSS VSS sg13_lv_nmos ad=0.1577p pd=1.21u as=0.1577p ps=1.21u w=0.83u l=0.13u
X328 VSS a_n727_n3660# a_n727_n4146# VSS sg13_lv_nmos ad=0.1577p pd=1.21u as=0.1577p ps=1.21u w=0.83u l=0.13u
X329 VSS a_3251_n8342# a_3251_n8064# VSS sg13_lv_nmos ad=0.1577p pd=1.21u as=0.1577p ps=1.21u w=0.83u l=0.13u
X330 a_5699_n8064# a_5699_n8342# VSS VSS sg13_lv_nmos ad=0.1577p pd=1.21u as=0.1577p ps=1.21u w=0.83u l=0.13u
X331 a_n727_n3024# a_n727_n3302# VSS VSS sg13_lv_nmos ad=0.1577p pd=1.21u as=0.1577p ps=1.21u w=0.83u l=0.13u
X332 VSS a_5087_n3302# a_5087_n3024# VSS sg13_lv_nmos ad=0.1577p pd=1.21u as=0.1577p ps=1.21u w=0.83u l=0.13u
X333 VSS a_2639_n8342# a_2639_n8064# VSS sg13_lv_nmos ad=0.1577p pd=1.21u as=0.1577p ps=1.21u w=0.83u l=0.13u
X334 VSS a_1415_n8342# a_1415_n8064# VSS sg13_lv_nmos ad=0.1577p pd=1.21u as=0.1577p ps=1.21u w=0.83u l=0.13u
X335 a_n115_n3024# a_n115_n3302# VSS VSS sg13_lv_nmos ad=0.1577p pd=1.21u as=0.1577p ps=1.21u w=0.83u l=0.13u
X336 VSS a_1415_n8342# a_1415_n8064# VSS sg13_lv_nmos ad=0.1577p pd=1.21u as=0.1577p ps=1.21u w=0.83u l=0.13u
X337 VSS a_n115_n4982# a_n115_n4704# VSS sg13_lv_nmos ad=0.1577p pd=1.21u as=0.1577p ps=1.21u w=0.83u l=0.13u
X338 a_n115_n4982# a_n115_n4704# VDD VDD sg13_lv_pmos ad=0.3078p pd=2u as=0.3078p ps=2u w=1.62u l=0.385u
X339 VSS a_803_n8342# a_803_n8064# VSS sg13_lv_nmos ad=0.1577p pd=1.21u as=0.1577p ps=1.21u w=0.83u l=0.13u
X340 VDD a_n727_n3024# a_n727_n3302# VDD sg13_lv_pmos ad=0.3078p pd=2u as=0.3078p ps=2u w=1.62u l=0.385u
X341 VSS a_497_n3660# a_497_n4146# VSS sg13_lv_nmos ad=0.2822p pd=2.34u as=0.1577p ps=1.21u w=0.83u l=0.13u
X342 a_497_n4704# a_497_n4982# VSS VSS sg13_lv_nmos ad=0.1577p pd=1.21u as=0.1577p ps=1.21u w=0.83u l=0.13u
X343 VSS a_6485_n8744# a_6447_n8664# VSS sg13_lv_nmos ad=0.2822p pd=2.34u as=0.1577p ps=1.21u w=0.83u l=0.13u
X344 a_n1033_n8700# a_n1033_n9186# VDD_uq0 VDD_uq0 sg13_lv_pmos ad=0.3078p pd=2u as=0.3078p ps=2u w=1.62u l=0.385u
X345 a_191_n8342# a_191_n8064# VDD_uq0 VDD_uq0 sg13_lv_pmos ad=0.3078p pd=2u as=0.3078p ps=2u w=1.62u l=0.385u
X346 a_n727_n4704# a_n727_n4982# VSS VSS sg13_lv_nmos ad=0.1577p pd=1.21u as=0.2822p ps=2.34u w=0.83u l=0.13u
X347 a_4475_n3302# a_4475_n3024# VDD VDD sg13_lv_pmos ad=0.3078p pd=2u as=0.3078p ps=2u w=1.62u l=0.385u
X348 a_2537_n3220# a_2359_n3262# VDD VDD sg13_lv_pmos ad=0.1632p pd=1.64u as=91.2f ps=0.86u w=0.48u l=0.13u
X349 a_n421_n8064# a_n421_n8342# VSS VSS sg13_lv_nmos ad=0.1577p pd=1.21u as=0.1577p ps=1.21u w=0.83u l=0.13u
X350 VDD a_n999_n2712# a_n999_n2712# VDD sg13_lv_pmos ad=0.1632p pd=1.64u as=0.1632p ps=1.64u w=0.48u l=0.13u
X351 a_5087_n8064# a_5087_n8342# VSS VSS sg13_lv_nmos ad=0.1577p pd=1.21u as=0.1577p ps=1.21u w=0.83u l=0.13u
X352 a_n727_n4704# a_n727_n4982# VSS VSS sg13_lv_nmos ad=0.1577p pd=1.21u as=0.1577p ps=1.21u w=0.83u l=0.13u
X353 a_3073_n3630# ACLK_N a_2971_n4038# VSS sg13_lv_nmos ad=91.2f pd=0.86u as=0.13375p ps=1.23u w=0.48u l=0.13u
X354 a_1849_n3630# BIST_EN_I a_1747_n4035# VSS sg13_lv_nmos ad=0.1064p pd=0.94u as=0.1064p ps=0.94u w=0.56u l=0.13u
X355 VSS a_n999_n4104# ADDR_COL<1> VSS sg13_lv_nmos ad=0.1632p pd=1.64u as=0.1632p ps=1.64u w=0.48u l=0.13u
X356 VDD_uq0 a_4475_n9186# a_4475_n8700# VDD_uq0 sg13_lv_pmos ad=0.3078p pd=2u as=0.3078p ps=2u w=1.62u l=0.385u
X357 VDD_uq0 a_5699_n9186# a_5699_n8700# VDD_uq0 sg13_lv_pmos ad=0.5508p pd=3.92u as=0.3078p ps=2u w=1.62u l=0.385u
X358 a_3251_n8700# a_3251_n9186# VDD_uq0 VDD_uq0 sg13_lv_pmos ad=0.3078p pd=2u as=0.3078p ps=2u w=1.62u l=0.385u
X359 a_803_n8342# a_803_n8064# VDD_uq0 VDD_uq0 sg13_lv_pmos ad=0.3078p pd=2u as=0.3078p ps=2u w=1.62u l=0.385u
X360 a_3251_n8064# a_3251_n8342# VSS VSS sg13_lv_nmos ad=0.1577p pd=1.21u as=0.1577p ps=1.21u w=0.83u l=0.13u
X361 a_5521_n3654# a_3685_n4104# VSS VSS sg13_lv_nmos ad=0.1862p pd=1.36u as=0.3332p ps=2.64u w=0.98u l=0.13u
X362 a_5699_n8342# a_5699_n8064# VDD_uq0 VDD_uq0 sg13_lv_pmos ad=0.3078p pd=2u as=0.3078p ps=2u w=1.62u l=0.385u
X363 a_5011_n4104# a_3481_n3262# a_5011_n3654# VSS sg13_lv_nmos ad=0.3332p pd=2.64u as=0.1862p ps=1.36u w=0.98u l=0.13u
X364 a_3889_n3654# a_3685_n4104# VSS VSS sg13_lv_nmos ad=0.1862p pd=1.36u as=0.3332p ps=2.64u w=0.98u l=0.13u
X365 VDD_uq0 a_6447_n8302# a_6485_n8122# VDD_uq0 sg13_lv_pmos ad=0.5508p pd=3.92u as=0.3078p ps=2u w=1.62u l=0.385u
X366 a_2359_n4035# a_2061_n4035# a_2257_n4035# VDD sg13_lv_pmos ad=0.14927p pd=1.355u as=0.18525p ps=1.355u w=0.975u l=0.13u
X367 a_4475_n9186# a_4475_n8700# VSS VSS sg13_lv_nmos ad=0.1577p pd=1.21u as=0.1577p ps=1.21u w=0.83u l=0.13u
X368 a_803_n8064# a_803_n8342# VSS VSS sg13_lv_nmos ad=0.1577p pd=1.21u as=0.1577p ps=1.21u w=0.83u l=0.13u
X369 a_803_n8700# a_803_n9186# VDD_uq0 VDD_uq0 sg13_lv_pmos ad=0.3078p pd=2u as=0.3078p ps=2u w=1.62u l=0.385u
X370 a_3481_n4104# a_2971_n4038# VSS VSS sg13_lv_nmos ad=0.3332p pd=2.64u as=0.3332p ps=2.64u w=0.98u l=0.13u
X371 VDD BIST_EN_I a_1449_n3202# VDD sg13_lv_pmos ad=0.16165p pd=1.365u as=0.2193p ps=1.97u w=0.645u l=0.13u
X372 ADDR_DEC<3> a_5521_n4104# VSS VSS sg13_lv_nmos ad=0.3332p pd=2.64u as=0.3332p ps=2.64u w=0.98u l=0.13u
X373 a_4475_n9186# a_4475_n8700# VSS VSS sg13_lv_nmos ad=0.1577p pd=1.21u as=0.1577p ps=1.21u w=0.83u l=0.13u
X374 VDD_uq0 a_4475_n8064# a_4475_n8342# VDD_uq0 sg13_lv_pmos ad=0.3078p pd=2u as=0.3078p ps=2u w=1.62u l=0.385u
X375 a_2639_n9186# a_2639_n8700# VSS VSS sg13_lv_nmos ad=0.1577p pd=1.21u as=0.1577p ps=1.21u w=0.83u l=0.13u
X376 a_3863_n9186# a_3863_n8700# VSS VSS sg13_lv_nmos ad=0.1577p pd=1.21u as=0.1577p ps=1.21u w=0.83u l=0.13u
X377 a_2027_n9186# a_2027_n8700# VSS VSS sg13_lv_nmos ad=0.1577p pd=1.21u as=0.1577p ps=1.21u w=0.83u l=0.13u
X378 a_n421_n8700# a_n421_n9186# VDD_uq0 VDD_uq0 sg13_lv_pmos ad=0.3078p pd=2u as=0.3078p ps=2u w=1.62u l=0.385u
X379 a_191_n8342# a_191_n8064# VDD_uq0 VDD_uq0 sg13_lv_pmos ad=0.3078p pd=2u as=0.3078p ps=2u w=1.62u l=0.385u
X380 VSS a_n727_n4982# a_n727_n4704# VSS sg13_lv_nmos ad=0.1577p pd=1.21u as=0.1577p ps=1.21u w=0.83u l=0.13u
X381 VSS a_5699_n8700# a_5699_n9186# VSS sg13_lv_nmos ad=0.1577p pd=1.21u as=0.1577p ps=1.21u w=0.83u l=0.13u
X382 a_2027_n9186# a_2027_n8700# VSS VSS sg13_lv_nmos ad=0.1577p pd=1.21u as=0.1577p ps=1.21u w=0.83u l=0.13u
X383 VDD a_n115_n4704# a_n115_n4982# VDD sg13_lv_pmos ad=0.3078p pd=2u as=0.3078p ps=2u w=1.62u l=0.385u
X384 VSS a_6485_n8122# a_6447_n8302# VSS sg13_lv_nmos ad=0.2822p pd=2.34u as=0.1577p ps=1.21u w=0.83u l=0.13u
X385 VSS a_4475_n3302# a_4475_n3024# VSS sg13_lv_nmos ad=0.1577p pd=1.21u as=0.1577p ps=1.21u w=0.83u l=0.13u
X386 a_3251_n8700# a_3251_n9186# VDD_uq0 VDD_uq0 sg13_lv_pmos ad=0.3078p pd=2u as=0.3078p ps=2u w=1.62u l=0.385u
X387 a_6447_n3624# a_6485_n3704# VSS VSS sg13_lv_nmos ad=0.1577p pd=1.21u as=0.1577p ps=1.21u w=0.83u l=0.13u
X388 VSS a_4475_n3302# a_4475_n3024# VSS sg13_lv_nmos ad=0.1577p pd=1.21u as=0.1577p ps=1.21u w=0.83u l=0.13u
X389 VDD_uq0 a_803_n9186# a_803_n8700# VDD_uq0 sg13_lv_pmos ad=0.3078p pd=2u as=0.3078p ps=2u w=1.62u l=0.385u
X390 a_5521_n4104# a_3685_n4104# VDD VDD sg13_lv_pmos ad=0.3078p pd=2u as=0.5508p ps=3.92u w=1.62u l=0.13u
X391 a_5087_n8342# a_5087_n8064# VDD_uq0 VDD_uq0 sg13_lv_pmos ad=0.3078p pd=2u as=0.3078p ps=2u w=1.62u l=0.385u
X392 VSS a_3863_n3302# a_3863_n3024# VSS sg13_lv_nmos ad=0.1577p pd=1.21u as=0.1577p ps=1.21u w=0.83u l=0.13u
X393 VDD_uq0 a_2639_n8064# a_2639_n8342# VDD_uq0 sg13_lv_pmos ad=0.3078p pd=2u as=0.3078p ps=2u w=1.62u l=0.385u
X394 VDD a_3481_n3262# a_5011_n4104# VDD sg13_lv_pmos ad=0.5508p pd=3.92u as=0.3078p ps=2u w=1.62u l=0.13u
X395 a_3889_n4104# a_3685_n4104# VDD VDD sg13_lv_pmos ad=0.3078p pd=2u as=0.5508p ps=3.92u w=1.62u l=0.13u
X396 VSS a_6485_n3082# a_6447_n3262# VSS sg13_lv_nmos ad=0.1577p pd=1.21u as=0.2822p ps=2.34u w=0.83u l=0.13u
X397 a_n421_n8342# a_n421_n8064# VDD_uq0 VDD_uq0 sg13_lv_pmos ad=0.3078p pd=2u as=0.3078p ps=2u w=1.62u l=0.385u
X398 ADDR_DEC<7> a_1211_n4980# VSS VSS sg13_lv_nmos ad=0.1632p pd=1.64u as=0.1632p ps=1.64u w=0.48u l=0.13u
X399 a_2537_n4040# a_2359_n4035# VSS VSS sg13_lv_nmos ad=0.1632p pd=1.64u as=91.2f ps=0.86u w=0.48u l=0.13u
X400 a_2359_n3262# a_2061_n3262# a_2257_n2880# VDD sg13_lv_pmos ad=0.14927p pd=1.355u as=0.18525p ps=1.355u w=0.975u l=0.13u
X401 a_3481_n4104# a_2971_n4038# VDD VDD sg13_lv_pmos ad=0.5508p pd=3.92u as=0.5508p ps=3.92u w=1.62u l=0.13u
X402 a_5699_n3024# a_5699_n3302# VSS VSS sg13_lv_nmos ad=0.1577p pd=1.21u as=0.1577p ps=1.21u w=0.83u l=0.13u
X403 ADDR_DEC<3> a_5521_n4104# VDD VDD sg13_lv_pmos ad=0.5508p pd=3.92u as=0.5508p ps=3.92u w=1.62u l=0.13u
X404 VSS ACLK_N a_2061_n3262# VSS sg13_lv_nmos ad=0.13717p pd=1.25u as=0.1683p ps=1.67u w=0.495u l=0.13u
X405 VDD_uq0 a_3863_n8064# a_3863_n8342# VDD_uq0 sg13_lv_pmos ad=0.3078p pd=2u as=0.3078p ps=2u w=1.62u l=0.385u
X406 a_n727_n3302# a_n727_n3024# VDD VDD sg13_lv_pmos ad=0.3078p pd=2u as=0.5508p ps=3.92u w=1.62u l=0.385u
X407 a_2971_n3260# a_2061_n3262# a_2869_n3218# VSS sg13_lv_nmos ad=0.13375p pd=1.23u as=0.1783p ps=1.44u w=0.85u l=0.13u
X408 a_1415_n8342# a_1415_n8064# VDD_uq0 VDD_uq0 sg13_lv_pmos ad=0.3078p pd=2u as=0.3078p ps=2u w=1.62u l=0.385u
X409 a_3073_n3938# a_2061_n4035# a_2971_n4038# VDD sg13_lv_pmos ad=91.2f pd=0.86u as=0.1511p ps=1.37u w=0.48u l=0.13u
X410 a_4475_n8064# a_4475_n8342# VSS VSS sg13_lv_nmos ad=0.1577p pd=1.21u as=0.1577p ps=1.21u w=0.83u l=0.13u
X411 VSS a_191_n8700# a_191_n9186# VSS sg13_lv_nmos ad=0.1577p pd=1.21u as=0.1577p ps=1.21u w=0.83u l=0.13u
X412 a_4475_n8064# a_4475_n8342# VSS VSS sg13_lv_nmos ad=0.1577p pd=1.21u as=0.1577p ps=1.21u w=0.83u l=0.13u
X413 VDD a_4475_n3024# a_4475_n3302# VDD sg13_lv_pmos ad=0.3078p pd=2u as=0.3078p ps=2u w=1.62u l=0.385u
X414 a_1849_n3202# BIST_EN_I a_1747_n3202# VSS sg13_lv_nmos ad=0.1064p pd=0.94u as=0.1064p ps=0.94u w=0.56u l=0.13u
X415 VDD a_5699_n3024# a_5699_n3302# VDD sg13_lv_pmos ad=0.5508p pd=3.92u as=0.3078p ps=2u w=1.62u l=0.385u
X416 VSS a_4343_n3704# a_4305_n3624# VSS sg13_lv_nmos ad=0.1577p pd=1.21u as=0.2822p ps=2.34u w=0.83u l=0.13u
X417 a_3863_n8064# a_3863_n8342# VSS VSS sg13_lv_nmos ad=0.1577p pd=1.21u as=0.1577p ps=1.21u w=0.83u l=0.13u
X418 a_2639_n8064# a_2639_n8342# VSS VSS sg13_lv_nmos ad=0.1577p pd=1.21u as=0.1577p ps=1.21u w=0.83u l=0.13u
X419 a_803_n9186# a_803_n8700# VSS VSS sg13_lv_nmos ad=0.1577p pd=1.21u as=0.1577p ps=1.21u w=0.83u l=0.13u
X420 a_2027_n8064# a_2027_n8342# VSS VSS sg13_lv_nmos ad=0.1577p pd=1.21u as=0.1577p ps=1.21u w=0.83u l=0.13u
X421 VSS a_5699_n8342# a_5699_n8064# VSS sg13_lv_nmos ad=0.1577p pd=1.21u as=0.1577p ps=1.21u w=0.83u l=0.13u
X422 VDD BIST_ADDR<1> a_1849_n4035# VDD sg13_lv_pmos ad=0.3349p pd=2.65u as=0.18715p ps=1.365u w=0.985u l=0.13u
X423 a_n1033_n9186# a_n1033_n8700# VSS VSS sg13_lv_nmos ad=0.1577p pd=1.21u as=0.1577p ps=1.21u w=0.83u l=0.13u
X424 a_3863_n3024# a_3863_n3302# VSS VSS sg13_lv_nmos ad=0.1577p pd=1.21u as=0.1577p ps=1.21u w=0.83u l=0.13u
X425 a_5699_n9186# a_5699_n8700# VSS VSS sg13_lv_nmos ad=0.1577p pd=1.21u as=0.1577p ps=1.21u w=0.83u l=0.13u
X426 a_2027_n8064# a_2027_n8342# VSS VSS sg13_lv_nmos ad=0.1577p pd=1.21u as=0.1577p ps=1.21u w=0.83u l=0.13u
X427 VDD_uq0 a_191_n9186# a_191_n8700# VDD_uq0 sg13_lv_pmos ad=0.3078p pd=2u as=0.3078p ps=2u w=1.62u l=0.385u
X428 VDD_uq0 a_n421_n9186# a_n421_n8700# VDD_uq0 sg13_lv_pmos ad=0.3078p pd=2u as=0.3078p ps=2u w=1.62u l=0.385u
X429 VDD BIST_EN_I a_1449_n4035# VDD sg13_lv_pmos ad=0.16165p pd=1.365u as=0.2193p ps=1.97u w=0.645u l=0.13u
X430 a_2461_n3184# a_2061_n3262# a_2359_n3262# VSS sg13_lv_nmos ad=91.2f pd=0.86u as=0.13605p ps=1.25u w=0.48u l=0.13u
X431 VSS a_497_n3302# a_497_n3024# VSS sg13_lv_nmos ad=0.1577p pd=1.21u as=0.1577p ps=1.21u w=0.83u l=0.13u
X432 a_2359_n4035# ACLK_N a_2257_n3632# VSS sg13_lv_nmos ad=0.13605p pd=1.25u as=0.1653p ps=1.25u w=0.87u l=0.13u
X433 a_2257_n3262# a_1747_n3202# VSS VSS sg13_lv_nmos ad=0.1653p pd=1.25u as=0.13717p ps=1.25u w=0.87u l=0.13u
X434 a_3251_n9186# a_3251_n8700# VSS VSS sg13_lv_nmos ad=0.1577p pd=1.21u as=0.1577p ps=1.21u w=0.83u l=0.13u
X435 VDD_uq0 a_n421_n9186# a_n421_n8700# VDD_uq0 sg13_lv_pmos ad=0.3078p pd=2u as=0.3078p ps=2u w=1.62u l=0.385u
X436 a_n727_n3302# a_n727_n3024# VDD VDD sg13_lv_pmos ad=0.3078p pd=2u as=0.3078p ps=2u w=1.62u l=0.385u
X437 a_497_n3024# a_497_n3302# VSS VSS sg13_lv_nmos ad=0.1577p pd=1.21u as=0.1577p ps=1.21u w=0.83u l=0.13u
X438 VDD_uq0 a_5699_n9186# a_5699_n8700# VDD_uq0 sg13_lv_pmos ad=0.3078p pd=2u as=0.3078p ps=2u w=1.62u l=0.385u
X439 a_1415_n9186# a_1415_n8700# VSS VSS sg13_lv_nmos ad=0.1577p pd=1.21u as=0.1577p ps=1.21u w=0.83u l=0.13u
X440 VSS ACLK_N a_2061_n4035# VSS sg13_lv_nmos ad=0.13717p pd=1.25u as=0.1683p ps=1.67u w=0.495u l=0.13u
X441 a_4475_n8700# a_4475_n9186# VDD_uq0 VDD_uq0 sg13_lv_pmos ad=0.3078p pd=2u as=0.3078p ps=2u w=1.62u l=0.385u
X442 a_191_n9186# a_191_n8700# VSS VSS sg13_lv_nmos ad=0.1577p pd=1.21u as=0.1577p ps=1.21u w=0.83u l=0.13u
X443 VDD_uq0 a_1415_n9186# a_1415_n8700# VDD_uq0 sg13_lv_pmos ad=0.3078p pd=2u as=0.3078p ps=2u w=1.62u l=0.385u
X444 VDD_uq0 a_2639_n9186# a_2639_n8700# VDD_uq0 sg13_lv_pmos ad=0.3078p pd=2u as=0.3078p ps=2u w=1.62u l=0.385u
X445 VDD_uq0 a_191_n8064# a_191_n8342# VDD_uq0 sg13_lv_pmos ad=0.3078p pd=2u as=0.3078p ps=2u w=1.62u l=0.385u
X446 VDD BIST_ADDR<0> a_1849_n2882# VDD sg13_lv_pmos ad=0.3349p pd=2.65u as=0.18715p ps=1.365u w=0.985u l=0.13u
X447 a_n421_n9186# a_n421_n8700# VSS VSS sg13_lv_nmos ad=0.1577p pd=1.21u as=0.1577p ps=1.21u w=0.83u l=0.13u
X448 a_5699_n8700# a_5699_n9186# VDD_uq0 VDD_uq0 sg13_lv_pmos ad=0.3078p pd=2u as=0.3078p ps=2u w=1.62u l=0.385u
X449 VSS a_191_n8342# a_191_n8064# VSS sg13_lv_nmos ad=0.1577p pd=1.21u as=0.1577p ps=1.21u w=0.83u l=0.13u
X450 VDD a_497_n3024# a_497_n3302# VDD sg13_lv_pmos ad=0.5508p pd=3.92u as=0.3078p ps=2u w=1.62u l=0.385u
X451 VDD_uq0 a_3251_n9186# a_3251_n8700# VDD_uq0 sg13_lv_pmos ad=0.3078p pd=2u as=0.3078p ps=2u w=1.62u l=0.385u
X452 VSS a_n1033_n8700# a_n1033_n9186# VSS sg13_lv_nmos ad=0.1577p pd=1.21u as=0.1577p ps=1.21u w=0.83u l=0.13u
X453 a_2027_n8700# a_2027_n9186# VDD_uq0 VDD_uq0 sg13_lv_pmos ad=0.3078p pd=2u as=0.3078p ps=2u w=1.62u l=0.385u
X454 VSS a_n115_n3660# a_n115_n4146# VSS sg13_lv_nmos ad=0.1577p pd=1.21u as=0.1577p ps=1.21u w=0.83u l=0.13u
X455 VSS a_n1033_n8700# a_n1033_n9186# VSS sg13_lv_nmos ad=0.1577p pd=1.21u as=0.1577p ps=1.21u w=0.83u l=0.13u
X456 VSS a_5087_n8700# a_5087_n9186# VSS sg13_lv_nmos ad=0.1577p pd=1.21u as=0.1577p ps=1.21u w=0.83u l=0.13u
X457 VDD_uq0 a_5087_n8064# a_5087_n8342# VDD_uq0 sg13_lv_pmos ad=0.3078p pd=2u as=0.3078p ps=2u w=1.62u l=0.385u
X458 VSS a_n421_n8700# a_n421_n9186# VSS sg13_lv_nmos ad=0.1577p pd=1.21u as=0.1577p ps=1.21u w=0.83u l=0.13u
X459 a_3863_n8342# a_3863_n8064# VDD_uq0 VDD_uq0 sg13_lv_pmos ad=0.3078p pd=2u as=0.3078p ps=2u w=1.62u l=0.385u
X460 a_2639_n8342# a_2639_n8064# VDD_uq0 VDD_uq0 sg13_lv_pmos ad=0.3078p pd=2u as=0.3078p ps=2u w=1.62u l=0.385u
X461 ADDR_DEC<1> a_6031_n4104# VSS VSS sg13_lv_nmos ad=0.3332p pd=2.64u as=0.3332p ps=2.64u w=0.98u l=0.13u
X462 a_n115_n3024# a_n115_n3302# VSS VSS sg13_lv_nmos ad=0.1577p pd=1.21u as=0.1577p ps=1.21u w=0.83u l=0.13u
X463 VSS a_3251_n8700# a_3251_n9186# VSS sg13_lv_nmos ad=0.1577p pd=1.21u as=0.1577p ps=1.21u w=0.83u l=0.13u
X464 a_803_n8064# a_803_n8342# VSS VSS sg13_lv_nmos ad=0.1577p pd=1.21u as=0.1577p ps=1.21u w=0.83u l=0.13u
X465 a_6485_n8122# a_6447_n8302# VDD_uq0 VDD_uq0 sg13_lv_pmos ad=0.3078p pd=2u as=0.5508p ps=3.92u w=1.62u l=0.385u
X466 VDD_uq0 a_1415_n8064# a_1415_n8342# VDD_uq0 sg13_lv_pmos ad=0.3078p pd=2u as=0.3078p ps=2u w=1.62u l=0.385u
X467 a_3073_n2878# a_2061_n3262# a_2971_n3260# VDD sg13_lv_pmos ad=91.2f pd=0.86u as=0.1511p ps=1.37u w=0.48u l=0.13u
X468 a_n115_n3024# a_n115_n3302# VSS VSS sg13_lv_nmos ad=0.1577p pd=1.21u as=0.1577p ps=1.21u w=0.83u l=0.13u
X469 a_497_n4146# a_497_n3660# VSS VSS sg13_lv_nmos ad=0.1577p pd=1.21u as=0.1577p ps=1.21u w=0.83u l=0.13u
X470 VSS a_3251_n8700# a_3251_n9186# VSS sg13_lv_nmos ad=0.1577p pd=1.21u as=0.1577p ps=1.21u w=0.83u l=0.13u
X471 a_n1033_n8064# a_n1033_n8342# VSS VSS sg13_lv_nmos ad=0.1577p pd=1.21u as=0.1577p ps=1.21u w=0.83u l=0.13u
X472 a_5699_n8064# a_5699_n8342# VSS VSS sg13_lv_nmos ad=0.1577p pd=1.21u as=0.1577p ps=1.21u w=0.83u l=0.13u
X473 a_2869_n3672# a_2537_n4040# VSS VSS sg13_lv_nmos ad=0.1783p pd=1.44u as=0.289p ps=2.38u w=0.85u l=0.13u
X474 a_n727_n4146# a_n727_n3660# VSS VSS sg13_lv_nmos ad=0.1577p pd=1.21u as=0.2822p ps=2.34u w=0.83u l=0.13u
X475 VSS a_1415_n8700# a_1415_n9186# VSS sg13_lv_nmos ad=0.1577p pd=1.21u as=0.1577p ps=1.21u w=0.83u l=0.13u
X476 VSS a_803_n8700# a_803_n9186# VSS sg13_lv_nmos ad=0.1577p pd=1.21u as=0.1577p ps=1.21u w=0.83u l=0.13u
X477 a_n727_n4146# a_n727_n3660# VSS VSS sg13_lv_nmos ad=0.1577p pd=1.21u as=0.1577p ps=1.21u w=0.83u l=0.13u
X478 a_3251_n8064# a_3251_n8342# VSS VSS sg13_lv_nmos ad=0.1577p pd=1.21u as=0.1577p ps=1.21u w=0.83u l=0.13u
X479 VDD a_n727_n4146# a_n727_n3660# VDD sg13_lv_pmos ad=0.3078p pd=2u as=0.3078p ps=2u w=1.62u l=0.385u
X480 VSS a_n727_n3302# a_n727_n3024# VSS sg13_lv_nmos ad=0.1577p pd=1.21u as=0.1577p ps=1.21u w=0.83u l=0.13u
X481 a_5087_n3024# a_5087_n3302# VSS VSS sg13_lv_nmos ad=0.1577p pd=1.21u as=0.1577p ps=1.21u w=0.83u l=0.13u
X482 a_191_n8700# a_191_n9186# VDD_uq0 VDD_uq0 sg13_lv_pmos ad=0.3078p pd=2u as=0.3078p ps=2u w=1.62u l=0.385u
X483 VSS a_n727_n3302# a_n727_n3024# VSS sg13_lv_nmos ad=0.1577p pd=1.21u as=0.1577p ps=1.21u w=0.83u l=0.13u
X484 a_2461_n3942# ACLK_N a_2359_n4035# VDD sg13_lv_pmos ad=91.2f pd=0.86u as=0.14927p ps=1.355u w=0.48u l=0.13u
X485 a_3863_n3024# a_3863_n3302# VSS VSS sg13_lv_nmos ad=0.1577p pd=1.21u as=0.2822p ps=2.34u w=0.83u l=0.13u
X486 a_5087_n3024# a_5087_n3302# VSS VSS sg13_lv_nmos ad=0.1577p pd=1.21u as=0.1577p ps=1.21u w=0.83u l=0.13u
X487 a_1415_n8064# a_1415_n8342# VSS VSS sg13_lv_nmos ad=0.1577p pd=1.21u as=0.1577p ps=1.21u w=0.83u l=0.13u
X488 a_497_n4704# a_497_n4982# VSS VSS sg13_lv_nmos ad=0.1577p pd=1.21u as=0.1577p ps=1.21u w=0.83u l=0.13u
X489 a_4781_n4140# a_4781_n4140# VDD VDD sg13_lv_pmos ad=0.1632p pd=1.64u as=0.1632p ps=1.64u w=0.48u l=0.13u
X490 a_191_n8064# a_191_n8342# VSS VSS sg13_lv_nmos ad=0.1577p pd=1.21u as=0.1577p ps=1.21u w=0.83u l=0.13u
X491 VDD a_497_n3024# a_497_n3302# VDD sg13_lv_pmos ad=0.3078p pd=2u as=0.3078p ps=2u w=1.62u l=0.385u
X492 a_3481_n3262# a_2971_n3260# VSS VSS sg13_lv_nmos ad=0.3332p pd=2.64u as=0.3332p ps=2.64u w=0.98u l=0.13u
X493 VDD a_n115_n3024# a_n115_n3302# VDD sg13_lv_pmos ad=0.3078p pd=2u as=0.3078p ps=2u w=1.62u l=0.385u
X494 a_4343_n3704# a_4305_n3624# VDD VDD sg13_lv_pmos ad=0.3078p pd=2u as=0.5508p ps=3.92u w=1.62u l=0.385u
X495 VSS a_5699_n3302# a_5699_n3024# VSS sg13_lv_nmos ad=0.1577p pd=1.21u as=0.1577p ps=1.21u w=0.83u l=0.13u
X496 a_n421_n8064# a_n421_n8342# VSS VSS sg13_lv_nmos ad=0.1577p pd=1.21u as=0.1577p ps=1.21u w=0.83u l=0.13u
X497 a_803_n8700# a_803_n9186# VDD_uq0 VDD_uq0 sg13_lv_pmos ad=0.3078p pd=2u as=0.3078p ps=2u w=1.62u l=0.385u
X498 VDD_uq0 a_5087_n8064# a_5087_n8342# VDD_uq0 sg13_lv_pmos ad=0.3078p pd=2u as=0.3078p ps=2u w=1.62u l=0.385u
X499 VSS a_497_n4982# a_497_n4704# VSS sg13_lv_nmos ad=0.1577p pd=1.21u as=0.1577p ps=1.21u w=0.83u l=0.13u
X500 ADDR_DEC<1> a_6031_n4104# VDD VDD sg13_lv_pmos ad=0.5508p pd=3.92u as=0.5508p ps=3.92u w=1.62u l=0.13u
X501 VDD a_n727_n3024# a_n727_n3302# VDD sg13_lv_pmos ad=0.3078p pd=2u as=0.3078p ps=2u w=1.62u l=0.385u
X502 VSS a_n1033_n8342# a_n1033_n8064# VSS sg13_lv_nmos ad=0.1577p pd=1.21u as=0.1577p ps=1.21u w=0.83u l=0.13u
.ends

.subckt RM_IHPSG13_1P_CTRL ACLK_N BIST_WE_I ROW_CS RE_I BIST_RE_I CK_I CS_I ECLK DCLK
+ WE_I RCLK WCLK BIST_EN BIST_CK_I BIST_CS_I PULSE_O PULSE_H PULSE_L B_TIEL_O VDD
+ VSS m2_3014_n7620# m2_n46_n7620# m2_1994_n7620# m2_6074_n7620# m2_n964_n7620# m2_n862_n7620#
+ m2_4748_n7620# m2_2096_n7620# m2_4646_n7620# m2_n556_n7620# m2_n454_n7620# m2_3932_n7620#
+ m2_n352_n7620# m2_3830_n7620# m2_4340_n7620# m2_3728_n7620# m2_4238_n7620# m2_5462_n6848#
+ m2_n250_n7620# m2_5360_n6950# m2_n148_n7620# m2_3626_n7620# m2_4136_n7620# m2_158_n7620#
+ m2_3524_n7620# m2_4034_n7620# m2_2912_n7620# m2_3422_n7620# m2_56_n7620# m1_1351_n5492#
X0 a_n523_n6660# a_n319_n6660# VDD VDD sg13_lv_pmos ad=0.2413p pd=1.65u as=0.28155p ps=2u w=1.27u l=0.13u
X1 a_5419_n6569# PULSE_H a_5317_n6569# VSS sg13_lv_nmos ad=0.10545p pd=0.935u as=0.10545p ps=0.935u w=0.555u l=0.13u
X2 VSS a_5929_n6622# a_6133_n6622# VSS sg13_lv_nmos ad=0.2397p pd=2.09u as=0.13395p ps=1.085u w=0.705u l=0.13u
X3 ROW_CS a_n829_n7500# VSS VSS sg13_lv_nmos ad=0.13395p pd=1.085u as=0.2397p ps=2.09u w=0.705u l=0.13u
X4 a_3685_n7032# a_3353_n7400# VSS VSS sg13_lv_nmos ad=0.1783p pd=1.44u as=0.289p ps=2.38u w=0.85u l=0.13u
X5 a_5929_n6622# a_4540_n7124# VDD VDD sg13_lv_pmos ad=0.5508p pd=3.92u as=0.5508p ps=3.92u w=1.62u l=0.13u
X6 a_905_n5820# a_2461_n7395# VSS VSS sg13_lv_nmos ad=0.2397p pd=2.09u as=0.12308p ps=1.085u w=0.705u l=0.13u
X7 a_2359_n6990# WE_I VSS VSS sg13_lv_nmos ad=0.1064p pd=0.94u as=0.1064p ps=0.94u w=0.56u l=0.13u
X8 a_2461_n6562# BIST_EN a_2359_n6242# VDD sg13_lv_pmos ad=0.18715p pd=1.365u as=0.18715p ps=1.365u w=0.985u l=0.13u
X9 PULSE_O a_13_n5718# VDD VDD sg13_lv_pmos ad=0.5508p pd=3.92u as=0.5508p ps=3.92u w=1.62u l=0.13u
X10 a_5317_n7464# a_5019_n6918# VSS VSS sg13_lv_nmos ad=0.3332p pd=2.64u as=0.1502p ps=1.36u w=0.98u l=0.13u
X11 RCLK a_4501_n6300# VSS VSS sg13_lv_nmos ad=0.13395p pd=1.085u as=0.2397p ps=2.09u w=0.705u l=0.13u
X12 a_259_n7466# a_293_n7130# VDD VDD sg13_lv_pmos ad=0.1632p pd=1.64u as=0.14812p ps=1.355u w=0.48u l=0.13u
X13 a_701_n5820# a_803_n5820# VDD VDD sg13_lv_pmos ad=0.25417p pd=2u as=0.17195p ps=1.285u w=0.905u l=0.13u
X14 VDD a_n523_n6660# a_n1033_n6660# VDD sg13_lv_pmos ad=0.28155p pd=2u as=0.3078p ps=2u w=1.62u l=0.13u
X15 VSS a_n829_n7500# ROW_CS VSS sg13_lv_nmos ad=0.13395p pd=1.085u as=0.13395p ps=1.085u w=0.705u l=0.13u
X16 VSS BIST_RE_I a_2563_n6562# VSS sg13_lv_nmos ad=0.12308p pd=1.085u as=0.1064p ps=0.94u w=0.56u l=0.13u
X17 a_421_n6990# a_259_n7466# a_n115_n7500# VSS sg13_lv_nmos ad=0.1783p pd=1.44u as=0.13375p ps=1.23u w=0.85u l=0.13u
X18 VSS a_696_n7125# a_497_n7434# VSS sg13_lv_nmos ad=91.2f pd=0.86u as=0.1632p ps=1.64u w=0.48u l=0.13u
X19 a_5623_n6992# a_5317_n7464# VSS VSS sg13_lv_nmos ad=0.1653p pd=1.25u as=0.13755p ps=1.25u w=0.87u l=0.13u
X20 VDD a_3353_n7400# a_3277_n7302# VDD sg13_lv_pmos ad=91.2f pd=0.86u as=91.2f ps=0.86u w=0.48u l=0.13u
X21 a_115_n5310# ACLK_N a_13_n5718# VSS sg13_lv_nmos ad=91.2f pd=0.86u as=0.13375p ps=1.23u w=0.48u l=0.13u
X22 a_701_n5820# a_905_n5820# a_829_n5334# VSS sg13_lv_nmos ad=0.1862p pd=1.36u as=0.1862p ps=1.36u w=0.98u l=0.13u
X23 WCLK a_4501_n7464# VDD VDD sg13_lv_pmos ad=0.3078p pd=2u as=0.5508p ps=3.92u w=1.62u l=0.13u
X24 a_191_n5717# a_13_n5718# VSS VSS sg13_lv_nmos ad=0.1632p pd=1.64u as=91.2f ps=0.86u w=0.48u l=0.13u
X25 a_3175_n7395# a_293_n7130# a_3073_n6992# VSS sg13_lv_nmos ad=0.13605p pd=1.25u as=0.1653p ps=1.25u w=0.87u l=0.13u
X26 a_n599_n5715# ACLK_N a_n701_n5312# VSS sg13_lv_nmos ad=0.13605p pd=1.25u as=0.1653p ps=1.25u w=0.87u l=0.13u
X27 VDD a_1007_n6660# a_n319_n6660# VDD sg13_lv_pmos ad=0.2763p pd=2u as=0.5508p ps=3.92u w=1.62u l=0.13u
X28 a_4540_n7124# a_5317_n6569# VSS VSS sg13_lv_nmos ad=0.2635p pd=2.23u as=0.32617p ps=1.665u w=0.775u l=0.13u
X29 VSS a_3965_n7397# a_3889_n6990# VSS sg13_lv_nmos ad=91.2f pd=0.86u as=91.2f ps=0.86u w=0.48u l=0.13u
X30 a_905_n5820# a_2461_n7395# VDD VDD sg13_lv_pmos ad=0.5508p pd=3.92u as=0.26017p ps=2u w=1.62u l=0.13u
X31 VSS a_395_n6660# a_319_n6622# VSS sg13_lv_nmos ad=0.13755p pd=1.25u as=0.1653p ps=1.25u w=0.87u l=0.13u
X32 VSS a_803_n5820# a_1033_n6992# VSS sg13_lv_nmos ad=0.13717p pd=1.25u as=0.1653p ps=1.25u w=0.87u l=0.13u
X33 VSS ACLK_N a_n897_n5715# VSS sg13_lv_nmos ad=0.13717p pd=1.25u as=0.1683p ps=1.67u w=0.495u l=0.13u
X34 VDD a_6133_n6622# ECLK VDD sg13_lv_pmos ad=0.5508p pd=3.92u as=0.3078p ps=2u w=1.62u l=0.13u
X35 a_1584_n7469# BIST_EN VSS VSS sg13_lv_nmos ad=0.1904p pd=1.8u as=0.1064p ps=0.94u w=0.56u l=0.13u
X36 a_1543_n6990# BIST_CS_I VSS VSS sg13_lv_nmos ad=0.1064p pd=0.94u as=0.12308p ps=1.085u w=0.56u l=0.13u
X37 VSS a_701_n5820# a_395_n6660# VSS sg13_lv_nmos ad=0.1502p pd=1.36u as=0.17p ps=1.68u w=0.5u l=0.13u
X38 a_293_n7130# a_n319_n6660# VSS VSS sg13_lv_nmos ad=0.13395p pd=1.085u as=0.2397p ps=2.09u w=0.705u l=0.13u
X39 a_2359_n6562# RE_I VSS VSS sg13_lv_nmos ad=0.1064p pd=0.94u as=0.1064p ps=0.94u w=0.56u l=0.13u
X40 VSS a_n1033_n6660# ACLK_N VSS sg13_lv_nmos ad=0.2397p pd=2.09u as=0.13395p ps=1.085u w=0.705u l=0.13u
X41 a_1415_n6660# a_1584_n6031# a_1543_n6242# VDD sg13_lv_pmos ad=0.18715p pd=1.365u as=0.18715p ps=1.365u w=0.985u l=0.13u
X42 a_3685_n6240# a_3353_n6580# VDD VDD sg13_lv_pmos ad=0.1881p pd=1.37u as=0.3366p ps=2.66u w=0.99u l=0.13u
X43 a_4501_n7014# a_4297_n7464# VSS VSS sg13_lv_nmos ad=0.1862p pd=1.36u as=0.3332p ps=2.64u w=0.98u l=0.13u
X44 a_n293_n6622# a_n319_n6660# VSS VSS sg13_lv_nmos ad=0.1862p pd=1.36u as=0.16557p ps=1.36u w=0.98u l=0.13u
X45 VDD a_3965_n6660# a_3889_n6238# VDD sg13_lv_pmos ad=91.2f pd=0.86u as=91.2f ps=0.86u w=0.48u l=0.13u
X46 a_2461_n7395# BIST_EN a_2359_n7395# VDD sg13_lv_pmos ad=0.18715p pd=1.365u as=0.18715p ps=1.365u w=0.985u l=0.13u
X47 a_3277_n6992# a_2877_n7395# a_3175_n7395# VSS sg13_lv_nmos ad=91.2f pd=0.86u as=0.13605p ps=1.25u w=0.48u l=0.13u
X48 a_n13_n6660# a_137_n6072# a_115_n6240# VDD sg13_lv_pmos ad=0.14812p pd=1.355u as=91.2f ps=0.86u w=0.48u l=0.13u
X49 VDD a_4501_n6300# RCLK VDD sg13_lv_pmos ad=0.5508p pd=3.92u as=0.3078p ps=2u w=1.62u l=0.13u
X50 a_5929_n6622# a_4540_n7124# VSS VSS sg13_lv_nmos ad=0.2397p pd=2.09u as=0.2397p ps=2.09u w=0.705u l=0.13u
X51 VDD a_n13_n6660# a_n217_n6660# VDD sg13_lv_pmos ad=91.2f pd=0.86u as=0.1632p ps=1.64u w=0.48u l=0.13u
X52 VDD a_3353_n6580# a_3277_n6234# VDD sg13_lv_pmos ad=91.2f pd=0.86u as=91.2f ps=0.86u w=0.48u l=0.13u
X53 a_3175_n6622# a_293_n7130# a_3073_n6622# VSS sg13_lv_nmos ad=0.13605p pd=1.25u as=0.1653p ps=1.25u w=0.87u l=0.13u
X54 a_4501_n6300# a_4297_n6622# VDD VDD sg13_lv_pmos ad=0.3078p pd=2u as=0.5508p ps=3.92u w=1.62u l=0.13u
X55 a_1149_n6622# a_1109_n6660# VSS VSS sg13_lv_nmos ad=38.4f pd=0.56u as=0.10507p ps=1.085u w=0.32u l=0.2u
X56 ECLK a_6133_n6622# VDD VDD sg13_lv_pmos ad=0.3078p pd=2u as=0.5508p ps=3.92u w=1.62u l=0.13u
X57 a_1747_n6242# BIST_EN a_1415_n6660# VDD sg13_lv_pmos ad=0.18715p pd=1.365u as=0.18715p ps=1.365u w=0.985u l=0.13u
X58 VSS a_6141_n7014# DCLK VSS sg13_lv_nmos ad=0.2397p pd=2.09u as=0.13395p ps=1.085u w=0.705u l=0.13u
X59 a_115_n5618# a_n897_n5715# a_13_n5718# VDD sg13_lv_pmos ad=91.2f pd=0.86u as=0.1511p ps=1.37u w=0.48u l=0.13u
X60 a_3787_n6620# a_293_n7130# a_3685_n6240# VDD sg13_lv_pmos ad=0.1511p pd=1.37u as=0.1881p ps=1.37u w=0.99u l=0.13u
X61 VSS a_3965_n6660# a_3889_n6546# VSS sg13_lv_nmos ad=91.2f pd=0.86u as=91.2f ps=0.86u w=0.48u l=0.13u
X62 VDD a_n829_n7500# ROW_CS VDD sg13_lv_pmos ad=0.3078p pd=2u as=0.3078p ps=2u w=1.62u l=0.13u
X63 a_n421_n5720# a_n599_n5715# VDD VDD sg13_lv_pmos ad=0.1632p pd=1.64u as=91.2f ps=0.86u w=0.48u l=0.13u
X64 a_191_n5717# a_13_n5718# VDD VDD sg13_lv_pmos ad=0.1632p pd=1.64u as=91.2f ps=0.86u w=0.48u l=0.13u
X65 a_829_n5334# a_1007_n5820# a_701_n5820# VSS sg13_lv_nmos ad=0.3332p pd=2.64u as=0.1862p ps=1.36u w=0.98u l=0.13u
X66 VSS a_n523_n6660# a_n1033_n6660# VSS sg13_lv_nmos ad=0.16557p pd=1.36u as=0.13395p ps=1.085u w=0.705u l=0.13u
X67 VDD a_n421_n7500# a_n829_n7500# VDD sg13_lv_pmos ad=0.5508p pd=3.92u as=0.3078p ps=2u w=1.62u l=0.13u
X68 VDD a_803_n5820# a_5019_n6918# VDD sg13_lv_pmos ad=0.2508p pd=2u as=0.1634p ps=1.24u w=0.86u l=0.13u
X69 a_n701_n5715# a_n1007_n5784# VDD VDD sg13_lv_pmos ad=0.18525p pd=1.355u as=0.14812p ps=1.355u w=0.975u l=0.13u
X70 a_4540_n7124# a_5317_n6569# VDD VDD sg13_lv_pmos ad=0.5219p pd=3.75u as=0.5668p ps=2.425u w=1.535u l=0.13u
X71 a_3353_n6580# a_3175_n6622# VSS VSS sg13_lv_nmos ad=0.1632p pd=1.64u as=91.2f ps=0.86u w=0.48u l=0.13u
X72 VSS a_5873_n7154# a_5827_n6914# VSS sg13_lv_nmos ad=91.2f pd=0.86u as=91.2f ps=0.86u w=0.48u l=0.13u
X73 VDD a_497_n7434# a_421_n7398# VDD sg13_lv_pmos ad=0.3366p pd=2.66u as=0.1881p ps=1.37u w=0.99u l=0.13u
X74 a_5419_n6569# a_5019_n6569# a_5317_n6569# VDD sg13_lv_pmos ad=0.15675p pd=1.205u as=0.15675p ps=1.205u w=0.825u l=0.13u
X75 a_5725_n7395# a_1109_n6660# a_5623_n7395# VDD sg13_lv_pmos ad=0.14812p pd=1.355u as=0.18525p ps=1.355u w=0.975u l=0.13u
X76 a_1584_n6031# BIST_EN VSS VSS sg13_lv_nmos ad=0.1904p pd=1.8u as=0.1064p ps=0.94u w=0.56u l=0.13u
X77 VSS a_1109_n6660# a_5427_n7395# VSS sg13_lv_nmos ad=0.13755p pd=1.25u as=0.17p ps=1.68u w=0.5u l=0.13u
X78 a_1543_n6562# BIST_CK_I VSS VSS sg13_lv_nmos ad=0.1064p pd=0.94u as=0.12308p ps=1.085u w=0.56u l=0.13u
X79 a_5113_n6918# a_905_n5820# a_5019_n6918# VSS sg13_lv_nmos ad=95f pd=0.88u as=0.17p ps=1.68u w=0.5u l=0.13u
X80 VDD a_3965_n7397# a_3889_n7298# VDD sg13_lv_pmos ad=91.2f pd=0.86u as=91.2f ps=0.86u w=0.48u l=0.13u
X81 VDD a_n421_n5720# a_n497_n5622# VDD sg13_lv_pmos ad=91.2f pd=0.86u as=91.2f ps=0.86u w=0.48u l=0.13u
X82 VDD a_n319_n6660# a_293_n7130# VDD sg13_lv_pmos ad=0.5508p pd=3.92u as=0.3078p ps=2u w=1.62u l=0.13u
X83 a_n829_n7500# a_n421_n7500# VDD VDD sg13_lv_pmos ad=0.3078p pd=2u as=0.3078p ps=2u w=1.62u l=0.13u
X84 a_5317_n7464# a_5019_n6918# VDD VDD sg13_lv_pmos ad=0.5508p pd=3.92u as=0.2508p ps=2u w=1.62u l=0.13u
X85 a_1415_n7500# a_1584_n7469# a_1543_n7395# VDD sg13_lv_pmos ad=0.18715p pd=1.365u as=0.18715p ps=1.365u w=0.985u l=0.13u
X86 ACLK_N a_n1033_n6660# VDD VDD sg13_lv_pmos ad=0.3078p pd=2u as=0.3078p ps=2u w=1.62u l=0.13u
X87 VDD a_293_n7130# a_2877_n6622# VDD sg13_lv_pmos ad=0.14812p pd=1.355u as=0.1632p ps=1.64u w=0.48u l=0.13u
X88 a_3685_n6578# a_3353_n6580# VSS VSS sg13_lv_nmos ad=0.1783p pd=1.44u as=0.289p ps=2.38u w=0.85u l=0.13u
X89 a_3685_n7398# a_3353_n7400# VDD VDD sg13_lv_pmos ad=0.1881p pd=1.37u as=0.3366p ps=2.66u w=0.99u l=0.13u
X90 VSS a_5215_n6569# a_5419_n6569# VSS sg13_lv_nmos ad=0.32617p pd=1.665u as=0.10545p ps=0.935u w=0.555u l=0.13u
X91 VSS a_6133_n6622# ECLK VSS sg13_lv_nmos ad=0.2397p pd=2.09u as=0.13395p ps=1.085u w=0.705u l=0.13u
X92 a_5827_n7296# a_5427_n7395# a_5725_n7395# VDD sg13_lv_pmos ad=91.2f pd=0.86u as=0.14812p ps=1.355u w=0.48u l=0.13u
X93 a_696_n7125# a_293_n7130# a_829_n7302# VDD sg13_lv_pmos ad=0.14927p pd=1.355u as=91.2f ps=0.86u w=0.48u l=0.13u
X94 VSS PULSE_H a_5019_n6569# VSS sg13_lv_nmos ad=0.10282p pd=0.935u as=0.1632p ps=1.64u w=0.48u l=0.13u
X95 a_3965_n7397# a_3787_n7398# VSS VSS sg13_lv_nmos ad=0.1632p pd=1.64u as=91.2f ps=0.86u w=0.48u l=0.13u
X96 a_2461_n7395# a_2163_n7395# a_2359_n6990# VSS sg13_lv_nmos ad=0.1064p pd=0.94u as=0.1064p ps=0.94u w=0.56u l=0.13u
X97 a_2563_n6242# a_2163_n6562# a_2461_n6562# VDD sg13_lv_pmos ad=0.18715p pd=1.365u as=0.18715p ps=1.365u w=0.985u l=0.13u
X98 VSS a_n115_n7500# a_n421_n7500# VSS sg13_lv_nmos ad=0.3332p pd=2.64u as=0.3332p ps=2.64u w=0.98u l=0.13u
X99 a_259_n7466# a_293_n7130# VSS VSS sg13_lv_nmos ad=0.1683p pd=1.67u as=0.13717p ps=1.25u w=0.495u l=0.13u
X100 VSS a_4501_n6300# RCLK VSS sg13_lv_nmos ad=0.2397p pd=2.09u as=0.13395p ps=1.085u w=0.705u l=0.13u
X101 a_3787_n7398# a_293_n7130# a_3685_n7398# VDD sg13_lv_pmos ad=0.1511p pd=1.37u as=0.1881p ps=1.37u w=0.99u l=0.13u
X102 a_1747_n7395# BIST_EN a_1415_n7500# VDD sg13_lv_pmos ad=0.18715p pd=1.365u as=0.18715p ps=1.365u w=0.985u l=0.13u
X103 a_931_n5784# a_905_n5820# a_701_n5820# VDD sg13_lv_pmos ad=0.3078p pd=2u as=0.25417p ps=2u w=1.62u l=0.13u
X104 VDD a_n1033_n6660# ACLK_N VDD sg13_lv_pmos ad=0.3078p pd=2u as=0.3078p ps=2u w=1.62u l=0.13u
X105 a_3965_n6660# a_3787_n6620# VDD VDD sg13_lv_pmos ad=0.1632p pd=1.64u as=91.2f ps=0.86u w=0.48u l=0.13u
X106 a_4501_n6622# a_4297_n6622# VSS VSS sg13_lv_nmos ad=0.1862p pd=1.36u as=0.3332p ps=2.64u w=0.98u l=0.13u
X107 a_n1033_n6660# a_n523_n6660# VDD VDD sg13_lv_pmos ad=0.3078p pd=2u as=0.5508p ps=3.92u w=1.62u l=0.13u
X108 ECLK a_6133_n6622# VSS VSS sg13_lv_nmos ad=0.13395p pd=1.085u as=0.2397p ps=2.09u w=0.705u l=0.13u
X109 ROW_CS a_n829_n7500# VSS VSS sg13_lv_nmos ad=0.13395p pd=1.085u as=0.13395p ps=1.085u w=0.705u l=0.13u
X110 a_829_n6992# a_497_n7434# VSS VSS sg13_lv_nmos ad=91.2f pd=0.86u as=91.2f ps=0.86u w=0.48u l=0.13u
X111 a_5725_n7395# a_5427_n7395# a_5623_n6992# VSS sg13_lv_nmos ad=0.13605p pd=1.25u as=0.1653p ps=1.25u w=0.87u l=0.13u
X112 a_3353_n7400# a_3175_n7395# VDD VDD sg13_lv_pmos ad=0.1632p pd=1.64u as=91.2f ps=0.86u w=0.48u l=0.13u
X113 a_n1007_n5784# PULSE_O VDD VDD sg13_lv_pmos ad=0.5508p pd=3.92u as=0.5508p ps=3.92u w=1.62u l=0.13u
X114 a_137_n6072# a_n319_n6660# VDD VDD sg13_lv_pmos ad=0.17p pd=1.68u as=0.14962p ps=1.355u w=0.5u l=0.13u
X115 VDD a_4501_n7464# WCLK VDD sg13_lv_pmos ad=0.5508p pd=3.92u as=0.3078p ps=2u w=1.62u l=0.13u
X116 a_n701_n5312# a_n1007_n5784# VSS VSS sg13_lv_nmos ad=0.1653p pd=1.25u as=0.13717p ps=1.25u w=0.87u l=0.13u
X117 a_3965_n6660# a_3787_n6620# VSS VSS sg13_lv_nmos ad=0.1632p pd=1.64u as=91.2f ps=0.86u w=0.48u l=0.13u
X118 a_4501_n7464# a_4297_n7464# VDD VDD sg13_lv_pmos ad=0.3078p pd=2u as=0.5508p ps=3.92u w=1.62u l=0.13u
X119 DCLK a_6141_n7014# VDD VDD sg13_lv_pmos ad=0.3078p pd=2u as=0.28155p ps=2u w=1.62u l=0.13u
X120 a_n421_n5720# a_n599_n5715# VSS VSS sg13_lv_nmos ad=0.1632p pd=1.64u as=91.2f ps=0.86u w=0.48u l=0.13u
X121 a_137_n6072# a_n319_n6660# VSS VSS sg13_lv_nmos ad=0.17p pd=1.68u as=0.13755p ps=1.25u w=0.5u l=0.13u
X122 a_5873_n7154# a_5725_n7395# VSS VSS sg13_lv_nmos ad=0.1632p pd=1.64u as=91.2f ps=0.86u w=0.48u l=0.13u
X123 a_6141_n7014# a_5873_n7154# VDD VDD sg13_lv_pmos ad=0.2413p pd=1.65u as=0.4318p ps=3.22u w=1.27u l=0.13u
X124 a_2461_n6562# a_2163_n6562# a_2359_n6562# VSS sg13_lv_nmos ad=0.1064p pd=0.94u as=0.1064p ps=0.94u w=0.56u l=0.13u
X125 a_217_n6990# a_21_n7466# VSS VSS sg13_lv_nmos ad=91.2f pd=0.86u as=91.2f ps=0.86u w=0.48u l=0.13u
X126 a_1415_n7500# BIST_EN a_1543_n6990# VSS sg13_lv_nmos ad=0.1064p pd=0.94u as=0.1064p ps=0.94u w=0.56u l=0.13u
X127 VSS a_n319_n6660# a_293_n7130# VSS sg13_lv_nmos ad=0.2397p pd=2.09u as=0.13395p ps=1.085u w=0.705u l=0.13u
X128 ACLK_N a_n1033_n6660# VSS VSS sg13_lv_nmos ad=0.13395p pd=1.085u as=0.13395p ps=1.085u w=0.705u l=0.13u
X129 a_1149_n6217# a_1109_n6660# VDD VDD sg13_lv_pmos ad=0.144p pd=1.44u as=0.2763p ps=2u w=1.2u l=0.2u
X130 VDD BIST_EN a_2163_n6562# VDD sg13_lv_pmos ad=0.16165p pd=1.365u as=0.2193p ps=1.97u w=0.645u l=0.13u
X131 a_4501_n7464# a_4540_n7124# a_4501_n7014# VSS sg13_lv_nmos ad=0.3332p pd=2.64u as=0.1862p ps=1.36u w=0.98u l=0.13u
X132 VDD a_293_n7130# a_2877_n7395# VDD sg13_lv_pmos ad=0.14812p pd=1.355u as=0.1632p ps=1.64u w=0.48u l=0.13u
X133 a_2563_n7395# a_2163_n7395# a_2461_n7395# VDD sg13_lv_pmos ad=0.18715p pd=1.365u as=0.18715p ps=1.365u w=0.985u l=0.13u
X134 VDD a_1007_n5820# a_931_n5784# VDD sg13_lv_pmos ad=0.5508p pd=3.92u as=0.3078p ps=2u w=1.62u l=0.13u
X135 a_115_n6240# a_n217_n6660# VDD VDD sg13_lv_pmos ad=91.2f pd=0.86u as=91.2f ps=0.86u w=0.48u l=0.13u
X136 a_3965_n7397# a_3787_n7398# VDD VDD sg13_lv_pmos ad=0.1632p pd=1.64u as=91.2f ps=0.86u w=0.48u l=0.13u
X137 VSS a_3353_n7400# a_3277_n6992# VSS sg13_lv_nmos ad=91.2f pd=0.86u as=91.2f ps=0.86u w=0.48u l=0.13u
X138 VSS a_n421_n5720# a_n497_n5312# VSS sg13_lv_nmos ad=91.2f pd=0.86u as=91.2f ps=0.86u w=0.48u l=0.13u
X139 a_319_n6240# a_n319_n6660# a_n13_n6660# VDD sg13_lv_pmos ad=0.18525p pd=1.355u as=0.14812p ps=1.355u w=0.975u l=0.13u
X140 a_3353_n6580# a_3175_n6622# VDD VDD sg13_lv_pmos ad=0.1632p pd=1.64u as=91.2f ps=0.86u w=0.48u l=0.13u
X141 VDD a_4540_n7124# a_4501_n6300# VDD sg13_lv_pmos ad=0.5508p pd=3.92u as=0.3078p ps=2u w=1.62u l=0.13u
X142 a_3787_n7398# a_2877_n7395# a_3685_n7032# VSS sg13_lv_nmos ad=0.13375p pd=1.23u as=0.1783p ps=1.44u w=0.85u l=0.13u
X143 a_n13_n6660# a_n319_n6660# a_115_n6622# VSS sg13_lv_nmos ad=0.13605p pd=1.25u as=91.2f ps=0.86u w=0.48u l=0.13u
X144 VDD a_6133_n6622# ECLK VDD sg13_lv_pmos ad=0.3078p pd=2u as=0.3078p ps=2u w=1.62u l=0.13u
X145 VDD a_1109_n6660# a_6141_n7014# VDD sg13_lv_pmos ad=0.28155p pd=2u as=0.2413p ps=1.65u w=1.27u l=0.13u
X146 VSS a_n13_n6660# a_n217_n6660# VSS sg13_lv_nmos ad=91.2f pd=0.86u as=0.1632p ps=1.64u w=0.48u l=0.13u
X147 a_6133_n6622# a_5929_n6622# VDD VDD sg13_lv_pmos ad=0.3078p pd=2u as=0.5508p ps=3.92u w=1.62u l=0.13u
X148 a_1747_n6990# a_1584_n7469# a_1415_n7500# VSS sg13_lv_nmos ad=0.1064p pd=0.94u as=0.1064p ps=0.94u w=0.56u l=0.13u
X149 VDD CK_I a_1747_n6242# VDD sg13_lv_pmos ad=0.16165p pd=1.365u as=0.18715p ps=1.365u w=0.985u l=0.13u
X150 VSS a_n1033_n6660# ACLK_N VSS sg13_lv_nmos ad=0.13395p pd=1.085u as=0.13395p ps=1.085u w=0.705u l=0.13u
X151 ROW_CS a_n829_n7500# VDD VDD sg13_lv_pmos ad=0.3078p pd=2u as=0.5508p ps=3.92u w=1.62u l=0.13u
X152 a_n1033_n6660# a_n523_n6660# VSS VSS sg13_lv_nmos ad=0.13395p pd=1.085u as=0.2397p ps=2.09u w=0.705u l=0.13u
X153 a_4297_n7464# a_3787_n7398# VSS VSS sg13_lv_nmos ad=0.3332p pd=2.64u as=0.3332p ps=2.64u w=0.98u l=0.13u
X154 VDD BIST_EN a_2163_n7395# VDD sg13_lv_pmos ad=0.16165p pd=1.365u as=0.2193p ps=1.97u w=0.645u l=0.13u
X155 VDD ACLK_N a_n897_n5715# VDD sg13_lv_pmos ad=0.14812p pd=1.355u as=0.1632p ps=1.64u w=0.48u l=0.13u
X156 a_3073_n6240# a_1007_n5820# VDD VDD sg13_lv_pmos ad=0.18525p pd=1.355u as=0.14812p ps=1.355u w=0.975u l=0.13u
X157 a_4297_n6622# a_3787_n6620# VDD VDD sg13_lv_pmos ad=0.5508p pd=3.92u as=0.5508p ps=3.92u w=1.62u l=0.13u
X158 a_3787_n6620# a_2877_n6622# a_3685_n6578# VSS sg13_lv_nmos ad=0.13375p pd=1.23u as=0.1783p ps=1.44u w=0.85u l=0.13u
X159 VDD a_5215_n6569# a_5419_n6569# VDD sg13_lv_pmos ad=0.5668p pd=2.425u as=0.15675p ps=1.205u w=0.825u l=0.13u
X160 WCLK a_4501_n7464# VSS VSS sg13_lv_nmos ad=0.13395p pd=1.085u as=0.2397p ps=2.09u w=0.705u l=0.13u
X161 a_n89_n5352# a_n421_n5720# VSS VSS sg13_lv_nmos ad=0.1783p pd=1.44u as=0.289p ps=2.38u w=0.85u l=0.13u
X162 a_1415_n6660# BIST_EN a_1543_n6562# VSS sg13_lv_nmos ad=0.1064p pd=0.94u as=0.1064p ps=0.94u w=0.56u l=0.13u
X163 VSS a_803_n5820# a_5113_n6918# VSS sg13_lv_nmos ad=0.1502p pd=1.36u as=95f ps=0.88u w=0.5u l=0.13u
X164 VDD a_n829_n7500# ROW_CS VDD sg13_lv_pmos ad=0.3078p pd=2u as=0.3078p ps=2u w=1.62u l=0.13u
X165 a_n497_n5622# ACLK_N a_n599_n5715# VDD sg13_lv_pmos ad=91.2f pd=0.86u as=0.14927p ps=1.355u w=0.48u l=0.13u
X166 VDD a_n115_n7500# a_n421_n7500# VDD sg13_lv_pmos ad=0.5508p pd=3.92u as=0.5508p ps=3.92u w=1.62u l=0.13u
X167 a_13_n5718# ACLK_N a_n89_n5718# VDD sg13_lv_pmos ad=0.1511p pd=1.37u as=0.1881p ps=1.37u w=0.99u l=0.13u
X168 a_1007_n6660# a_1109_n6660# a_1149_n6622# VSS sg13_lv_nmos ad=0.1088p pd=1.32u as=38.4f ps=0.56u w=0.32u l=0.2u
X169 a_3277_n6544# a_2877_n6622# a_3175_n6622# VSS sg13_lv_nmos ad=91.2f pd=0.86u as=0.13605p ps=1.25u w=0.48u l=0.13u
X170 VDD a_5873_n7154# a_5827_n7296# VDD sg13_lv_pmos ad=91.2f pd=0.86u as=91.2f ps=0.86u w=0.48u l=0.13u
X171 a_5215_n6569# PULSE_L VSS VSS sg13_lv_nmos ad=0.10545p pd=0.935u as=0.10282p ps=0.935u w=0.555u l=0.13u
X172 a_217_n7298# a_21_n7466# VDD VDD sg13_lv_pmos ad=91.2f pd=0.86u as=91.2f ps=0.86u w=0.48u l=0.13u
X173 a_2563_n6990# BIST_EN a_2461_n7395# VSS sg13_lv_nmos ad=0.1064p pd=0.94u as=0.1064p ps=0.94u w=0.56u l=0.13u
X174 a_n89_n5718# a_n421_n5720# VDD VDD sg13_lv_pmos ad=0.1881p pd=1.37u as=0.3366p ps=2.66u w=0.99u l=0.13u
X175 VDD BIST_RE_I a_2563_n6242# VDD sg13_lv_pmos ad=0.26017p pd=2u as=0.18715p ps=1.365u w=0.985u l=0.13u
X176 VDD a_1109_n6660# a_5427_n7395# VDD sg13_lv_pmos ad=0.14962p pd=1.355u as=0.17p ps=1.68u w=0.5u l=0.13u
X177 ACLK_N a_n1033_n6660# VDD VDD sg13_lv_pmos ad=0.3078p pd=2u as=0.5508p ps=3.92u w=1.62u l=0.13u
X178 a_1747_n6562# a_1584_n6031# a_1415_n6660# VSS sg13_lv_nmos ad=0.1064p pd=0.94u as=0.1064p ps=0.94u w=0.56u l=0.13u
X179 a_3073_n7395# a_905_n5820# VDD VDD sg13_lv_pmos ad=0.18525p pd=1.355u as=0.14812p ps=1.355u w=0.975u l=0.13u
X180 VDD CS_I a_1747_n7395# VDD sg13_lv_pmos ad=0.16165p pd=1.365u as=0.18715p ps=1.365u w=0.985u l=0.13u
X181 a_4501_n6300# a_4540_n7124# a_4501_n6622# VSS sg13_lv_nmos ad=0.3332p pd=2.64u as=0.1862p ps=1.36u w=0.98u l=0.13u
X182 VSS a_293_n7130# a_2877_n6622# VSS sg13_lv_nmos ad=0.13717p pd=1.25u as=0.1683p ps=1.67u w=0.495u l=0.13u
X183 VSS a_6133_n6622# ECLK VSS sg13_lv_nmos ad=0.13395p pd=1.085u as=0.13395p ps=1.085u w=0.705u l=0.13u
X184 a_1033_n7395# a_259_n7466# a_696_n7125# VDD sg13_lv_pmos ad=0.18525p pd=1.355u as=0.14927p ps=1.355u w=0.975u l=0.13u
X185 VDD a_696_n7125# a_497_n7434# VDD sg13_lv_pmos ad=91.2f pd=0.86u as=0.1632p ps=1.64u w=0.48u l=0.13u
X186 VDD a_n217_n6660# a_n523_n6660# VDD sg13_lv_pmos ad=0.4318p pd=3.22u as=0.2413p ps=1.65u w=1.27u l=0.13u
X187 a_5317_n6569# a_5019_n6569# a_5215_n6569# VSS sg13_lv_nmos ad=0.10545p pd=0.935u as=0.10545p ps=0.935u w=0.555u l=0.13u
X188 a_6133_n6622# a_5929_n6622# VSS VSS sg13_lv_nmos ad=0.13395p pd=1.085u as=0.2397p ps=2.09u w=0.705u l=0.13u
X189 VSS a_n829_n7500# ROW_CS VSS sg13_lv_nmos ad=0.13395p pd=1.085u as=0.13395p ps=1.085u w=0.705u l=0.13u
X190 VSS a_n421_n7500# a_n829_n7500# VSS sg13_lv_nmos ad=0.2397p pd=2.09u as=0.13395p ps=1.085u w=0.705u l=0.13u
X191 a_696_n7125# a_259_n7466# a_829_n6992# VSS sg13_lv_nmos ad=0.13605p pd=1.25u as=91.2f ps=0.86u w=0.48u l=0.13u
X192 VSS a_1415_n6660# a_1109_n6660# VSS sg13_lv_nmos ad=0.12308p pd=1.085u as=0.2397p ps=2.09u w=0.705u l=0.13u
X193 VSS BIST_EN a_2163_n7395# VSS sg13_lv_nmos ad=0.1064p pd=0.94u as=0.1904p ps=1.8u w=0.56u l=0.13u
X194 VDD a_1415_n6660# a_1109_n6660# VDD sg13_lv_pmos ad=0.26017p pd=2u as=0.5508p ps=3.92u w=1.62u l=0.13u
X195 a_2359_n6242# RE_I VDD VDD sg13_lv_pmos ad=0.18715p pd=1.365u as=0.16165p ps=1.365u w=0.985u l=0.13u
X196 VDD a_4540_n7124# a_4501_n7464# VDD sg13_lv_pmos ad=0.5508p pd=3.92u as=0.3078p ps=2u w=1.62u l=0.13u
X197 a_4297_n6622# a_3787_n6620# VSS VSS sg13_lv_nmos ad=0.3332p pd=2.64u as=0.3332p ps=2.64u w=0.98u l=0.13u
X198 VDD a_701_n5820# a_395_n6660# VDD sg13_lv_pmos ad=0.17195p pd=1.285u as=0.3077p ps=2.49u w=0.905u l=0.13u
X199 VDD a_6141_n7014# DCLK VDD sg13_lv_pmos ad=0.5508p pd=3.92u as=0.3078p ps=2u w=1.62u l=0.13u
X200 a_n829_n7500# a_n421_n7500# VSS VSS sg13_lv_nmos ad=0.13395p pd=1.085u as=0.13395p ps=1.085u w=0.705u l=0.13u
X201 VSS a_293_n7130# a_2877_n7395# VSS sg13_lv_nmos ad=0.13717p pd=1.25u as=0.1683p ps=1.67u w=0.495u l=0.13u
X202 a_2563_n6562# BIST_EN a_2461_n6562# VSS sg13_lv_nmos ad=0.1064p pd=0.94u as=0.1064p ps=0.94u w=0.56u l=0.13u
X203 VSS a_n115_n7500# a_21_n7466# VSS sg13_lv_nmos ad=91.2f pd=0.86u as=0.1632p ps=1.64u w=0.48u l=0.13u
X204 a_n115_n7500# a_293_n7130# a_217_n6990# VSS sg13_lv_nmos ad=0.13375p pd=1.23u as=91.2f ps=0.86u w=0.48u l=0.13u
X205 PULSE_O a_13_n5718# VSS VSS sg13_lv_nmos ad=0.3332p pd=2.64u as=0.3332p ps=2.64u w=0.98u l=0.13u
X206 a_3277_n7302# a_293_n7130# a_3175_n7395# VDD sg13_lv_pmos ad=91.2f pd=0.86u as=0.14927p ps=1.355u w=0.48u l=0.13u
X207 VDD BIST_WE_I a_2563_n7395# VDD sg13_lv_pmos ad=0.26017p pd=2u as=0.18715p ps=1.365u w=0.985u l=0.13u
X208 a_829_n5334# a_803_n5820# VSS VSS sg13_lv_nmos ad=0.1862p pd=1.36u as=0.1502p ps=1.36u w=0.98u l=0.13u
X209 a_3353_n7400# a_3175_n7395# VSS VSS sg13_lv_nmos ad=0.1632p pd=1.64u as=91.2f ps=0.86u w=0.48u l=0.13u
X210 VSS a_191_n5717# a_115_n5310# VSS sg13_lv_nmos ad=91.2f pd=0.86u as=91.2f ps=0.86u w=0.48u l=0.13u
X211 VDD a_395_n6660# a_319_n6240# VDD sg13_lv_pmos ad=0.14962p pd=1.355u as=0.18525p ps=1.355u w=0.975u l=0.13u
X212 a_4297_n7464# a_3787_n7398# VDD VDD sg13_lv_pmos ad=0.5508p pd=3.92u as=0.5508p ps=3.92u w=1.62u l=0.13u
X213 a_6235_n7014# a_5873_n7154# a_6141_n7014# VSS sg13_lv_nmos ad=0.1862p pd=1.36u as=0.3332p ps=2.64u w=0.98u l=0.13u
X214 a_n497_n5312# a_n897_n5715# a_n599_n5715# VSS sg13_lv_nmos ad=91.2f pd=0.86u as=0.13605p ps=1.25u w=0.48u l=0.13u
X215 a_13_n5718# a_n897_n5715# a_n89_n5352# VSS sg13_lv_nmos ad=0.13375p pd=1.23u as=0.1783p ps=1.44u w=0.85u l=0.13u
X216 a_3889_n6990# a_293_n7130# a_3787_n7398# VSS sg13_lv_nmos ad=91.2f pd=0.86u as=0.13375p ps=1.23u w=0.48u l=0.13u
X217 a_3073_n6992# a_905_n5820# VSS VSS sg13_lv_nmos ad=0.1653p pd=1.25u as=0.13717p ps=1.25u w=0.87u l=0.13u
X218 ACLK_N a_n1033_n6660# VSS VSS sg13_lv_nmos ad=0.13395p pd=1.085u as=0.2397p ps=2.09u w=0.705u l=0.13u
X219 a_115_n6622# a_n217_n6660# VSS VSS sg13_lv_nmos ad=91.2f pd=0.86u as=91.2f ps=0.86u w=0.48u l=0.13u
X220 VDD PULSE_H a_5019_n6569# VDD sg13_lv_pmos ad=0.14818p pd=1.205u as=0.1972p ps=1.84u w=0.58u l=0.13u
X221 a_5873_n7154# a_5725_n7395# VDD VDD sg13_lv_pmos ad=0.1632p pd=1.64u as=91.2f ps=0.86u w=0.48u l=0.13u
X222 a_319_n6622# a_137_n6072# a_n13_n6660# VSS sg13_lv_nmos ad=0.1653p pd=1.25u as=0.13605p ps=1.25u w=0.87u l=0.13u
X223 ECLK a_6133_n6622# VDD VDD sg13_lv_pmos ad=0.3078p pd=2u as=0.3078p ps=2u w=1.62u l=0.13u
X224 VSS CS_I a_1747_n6990# VSS sg13_lv_nmos ad=0.1064p pd=0.94u as=0.1064p ps=0.94u w=0.56u l=0.13u
X225 a_1033_n6992# a_293_n7130# a_696_n7125# VSS sg13_lv_nmos ad=0.1653p pd=1.25u as=0.13605p ps=1.25u w=0.87u l=0.13u
X226 VDD a_5929_n6622# a_6133_n6622# VDD sg13_lv_pmos ad=0.5508p pd=3.92u as=0.3078p ps=2u w=1.62u l=0.13u
X227 VSS BIST_EN a_2163_n6562# VSS sg13_lv_nmos ad=0.1064p pd=0.94u as=0.1904p ps=1.8u w=0.56u l=0.13u
X228 VSS a_1415_n7500# a_803_n5820# VSS sg13_lv_nmos ad=0.12308p pd=1.085u as=0.2397p ps=2.09u w=0.705u l=0.13u
X229 a_1543_n6242# BIST_CK_I VDD VDD sg13_lv_pmos ad=0.18715p pd=1.365u as=0.26017p ps=2u w=0.985u l=0.13u
X230 a_n523_n6660# a_n217_n6660# a_n293_n6622# VSS sg13_lv_nmos ad=0.3332p pd=2.64u as=0.1862p ps=1.36u w=0.98u l=0.13u
X231 a_3889_n6238# a_2877_n6622# a_3787_n6620# VDD sg13_lv_pmos ad=91.2f pd=0.86u as=0.1511p ps=1.37u w=0.48u l=0.13u
X232 a_2359_n7395# WE_I VDD VDD sg13_lv_pmos ad=0.18715p pd=1.365u as=0.16165p ps=1.365u w=0.985u l=0.13u
X233 a_3175_n6622# a_2877_n6622# a_3073_n6240# VDD sg13_lv_pmos ad=0.14927p pd=1.355u as=0.18525p ps=1.355u w=0.975u l=0.13u
X234 VSS a_1109_n6660# a_6235_n7014# VSS sg13_lv_nmos ad=0.16557p pd=1.36u as=0.1862p ps=1.36u w=0.98u l=0.13u
X235 RCLK a_4501_n6300# VDD VDD sg13_lv_pmos ad=0.3078p pd=2u as=0.5508p ps=3.92u w=1.62u l=0.13u
X236 a_1007_n5820# a_2461_n6562# VSS VSS sg13_lv_nmos ad=0.2397p pd=2.09u as=0.12308p ps=1.085u w=0.705u l=0.13u
X237 a_3073_n6622# a_1007_n5820# VSS VSS sg13_lv_nmos ad=0.1653p pd=1.25u as=0.13717p ps=1.25u w=0.87u l=0.13u
X238 B_TIEL_O a_n1033_n7500# VSS VSS sg13_lv_nmos ad=0.1632p pd=1.64u as=0.1632p ps=1.64u w=0.48u l=0.13u
X239 a_n1033_n7500# a_n1033_n7500# VDD VDD sg13_lv_pmos ad=0.1632p pd=1.64u as=0.1632p ps=1.64u w=0.48u l=0.13u
X240 a_1007_n6660# a_1109_n6660# a_1149_n6217# VDD sg13_lv_pmos ad=0.408p pd=3.08u as=0.144p ps=1.44u w=1.2u l=0.2u
X241 a_1007_n5820# a_2461_n6562# VDD VDD sg13_lv_pmos ad=0.5508p pd=3.92u as=0.26017p ps=2u w=1.62u l=0.13u
X242 a_3277_n6234# a_293_n7130# a_3175_n6622# VDD sg13_lv_pmos ad=91.2f pd=0.86u as=0.14927p ps=1.355u w=0.48u l=0.13u
X243 a_5215_n6569# PULSE_L VDD VDD sg13_lv_pmos ad=0.15675p pd=1.205u as=0.14818p ps=1.205u w=0.825u l=0.13u
X244 VSS a_4501_n7464# WCLK VSS sg13_lv_nmos ad=0.2397p pd=2.09u as=0.13395p ps=1.085u w=0.705u l=0.13u
X245 VSS a_1007_n6660# a_n319_n6660# VSS sg13_lv_nmos ad=0.10507p pd=1.085u as=0.2397p ps=2.09u w=0.705u l=0.13u
X246 a_1584_n6031# BIST_EN VDD VDD sg13_lv_pmos ad=0.2193p pd=1.97u as=0.16165p ps=1.365u w=0.645u l=0.13u
X247 DCLK a_6141_n7014# VSS VSS sg13_lv_nmos ad=0.13395p pd=1.085u as=0.16557p ps=1.36u w=0.705u l=0.13u
X248 ROW_CS a_n829_n7500# VDD VDD sg13_lv_pmos ad=0.3078p pd=2u as=0.3078p ps=2u w=1.62u l=0.13u
X249 VDD a_191_n5717# a_115_n5618# VDD sg13_lv_pmos ad=91.2f pd=0.86u as=91.2f ps=0.86u w=0.48u l=0.13u
X250 a_3889_n6546# a_293_n7130# a_3787_n6620# VSS sg13_lv_nmos ad=91.2f pd=0.86u as=0.13375p ps=1.23u w=0.48u l=0.13u
X251 a_5019_n6918# a_905_n5820# VDD VDD sg13_lv_pmos ad=0.1634p pd=1.24u as=0.2924p ps=2.4u w=0.86u l=0.13u
X252 a_n1007_n5784# PULSE_O VSS VSS sg13_lv_nmos ad=0.2397p pd=2.09u as=0.2397p ps=2.09u w=0.705u l=0.13u
X253 a_n599_n5715# a_n897_n5715# a_n701_n5715# VDD sg13_lv_pmos ad=0.14927p pd=1.355u as=0.18525p ps=1.355u w=0.975u l=0.13u
X254 VSS a_3353_n6580# a_3277_n6544# VSS sg13_lv_nmos ad=91.2f pd=0.86u as=91.2f ps=0.86u w=0.48u l=0.13u
X255 a_5827_n6914# a_1109_n6660# a_5725_n7395# VSS sg13_lv_nmos ad=91.2f pd=0.86u as=0.13605p ps=1.25u w=0.48u l=0.13u
X256 VDD a_n115_n7500# a_21_n7466# VDD sg13_lv_pmos ad=91.2f pd=0.86u as=0.1632p ps=1.64u w=0.48u l=0.13u
X257 a_421_n7398# a_293_n7130# a_n115_n7500# VDD sg13_lv_pmos ad=0.1881p pd=1.37u as=0.1511p ps=1.37u w=0.99u l=0.13u
X258 a_n115_n7500# a_259_n7466# a_217_n7298# VDD sg13_lv_pmos ad=0.1511p pd=1.37u as=91.2f ps=0.86u w=0.48u l=0.13u
X259 a_5317_n6569# PULSE_H a_5215_n6569# VDD sg13_lv_pmos ad=0.15675p pd=1.205u as=0.15675p ps=1.205u w=0.825u l=0.13u
X260 VSS a_497_n7434# a_421_n6990# VSS sg13_lv_nmos ad=0.289p pd=2.38u as=0.1783p ps=1.44u w=0.85u l=0.13u
X261 a_5623_n7395# a_5317_n7464# VDD VDD sg13_lv_pmos ad=0.18525p pd=1.355u as=0.14962p ps=1.355u w=0.975u l=0.13u
X262 VDD a_1415_n7500# a_803_n5820# VDD sg13_lv_pmos ad=0.26017p pd=2u as=0.5508p ps=3.92u w=1.62u l=0.13u
X263 VSS BIST_WE_I a_2563_n6990# VSS sg13_lv_nmos ad=0.12308p pd=1.085u as=0.1064p ps=0.94u w=0.56u l=0.13u
X264 VSS CK_I a_1747_n6562# VSS sg13_lv_nmos ad=0.1064p pd=0.94u as=0.1064p ps=0.94u w=0.56u l=0.13u
X265 a_293_n7130# a_n319_n6660# VDD VDD sg13_lv_pmos ad=0.3078p pd=2u as=0.5508p ps=3.92u w=1.62u l=0.13u
X266 a_3889_n7298# a_2877_n7395# a_3787_n7398# VDD sg13_lv_pmos ad=91.2f pd=0.86u as=0.1511p ps=1.37u w=0.48u l=0.13u
X267 a_3175_n7395# a_2877_n7395# a_3073_n7395# VDD sg13_lv_pmos ad=0.14927p pd=1.355u as=0.18525p ps=1.355u w=0.975u l=0.13u
X268 a_1584_n7469# BIST_EN VDD VDD sg13_lv_pmos ad=0.2193p pd=1.97u as=0.16165p ps=1.365u w=0.645u l=0.13u
X269 VDD a_n1033_n6660# ACLK_N VDD sg13_lv_pmos ad=0.5508p pd=3.92u as=0.3078p ps=2u w=1.62u l=0.13u
X270 a_1543_n7395# BIST_CS_I VDD VDD sg13_lv_pmos ad=0.18715p pd=1.365u as=0.26017p ps=2u w=0.985u l=0.13u
X271 ECLK a_6133_n6622# VSS VSS sg13_lv_nmos ad=0.13395p pd=1.085u as=0.13395p ps=1.085u w=0.705u l=0.13u
X272 VDD a_803_n5820# a_1033_n7395# VDD sg13_lv_pmos ad=0.14812p pd=1.355u as=0.18525p ps=1.355u w=0.975u l=0.13u
X273 a_829_n7302# a_497_n7434# VDD VDD sg13_lv_pmos ad=91.2f pd=0.86u as=91.2f ps=0.86u w=0.48u l=0.13u
.ends

.subckt RM_IHPSG13_1P_COLDRV13_FILL4C2 w_n102_n9345# m3_0_n8450# dw_0_n9300#
X0 a_59_n8122# a_21_n8302# w_n102_n9345# w_n102_n9345# sg13_lv_pmos ad=0.3078p pd=2u as=0.5508p ps=3.92u w=1.62u l=0.385u
X1 dw_0_n9300# a_59_n8744# a_21_n8664# dw_0_n9300# sg13_lv_nmos ad=0.1577p pd=1.21u as=0.2822p ps=2.34u w=0.83u l=0.13u
X2 dw_0_n9300# a_59_n8744# a_21_n8664# dw_0_n9300# sg13_lv_nmos ad=0.2822p pd=2.34u as=0.1577p ps=1.21u w=0.83u l=0.13u
X3 dw_0_n9300# a_59_n8122# a_21_n8302# dw_0_n9300# sg13_lv_nmos ad=0.1577p pd=1.21u as=0.2822p ps=2.34u w=0.83u l=0.13u
X4 dw_0_n9300# a_59_n8122# a_21_n8302# dw_0_n9300# sg13_lv_nmos ad=0.2822p pd=2.34u as=0.1577p ps=1.21u w=0.83u l=0.13u
X5 a_59_n8744# a_21_n8664# w_n102_n9345# w_n102_n9345# sg13_lv_pmos ad=0.3078p pd=2u as=0.5508p ps=3.92u w=1.62u l=0.385u
X6 w_n102_n9345# a_21_n8302# a_59_n8122# w_n102_n9345# sg13_lv_pmos ad=0.5508p pd=3.92u as=0.3078p ps=2u w=1.62u l=0.385u
X7 w_n102_n9345# a_21_n8664# a_59_n8744# w_n102_n9345# sg13_lv_pmos ad=0.5508p pd=3.92u as=0.3078p ps=2u w=1.62u l=0.385u
X8 a_21_n8664# a_59_n8744# dw_0_n9300# dw_0_n9300# sg13_lv_nmos ad=0.1577p pd=1.21u as=0.1577p ps=1.21u w=0.83u l=0.13u
X9 a_21_n8302# a_59_n8122# dw_0_n9300# dw_0_n9300# sg13_lv_nmos ad=0.1577p pd=1.21u as=0.1577p ps=1.21u w=0.83u l=0.13u
.ends

.subckt RM_IHPSG13_1P_DLY_MUX a_89_1220# a_n81_96# dw_n306_n60# w_n306_1197# w_n408_n105#
+ a_n50_1148#
X0 a_13_998# a_n50_1148# dw_n306_n60# dw_n306_n60# sg13_lv_nmos ad=91.2f pd=0.86u as=0.1632p ps=1.64u w=0.48u l=0.13u
X1 a_n13_60# a_89_1220# a_13_1318# w_n306_1197# sg13_lv_pmos ad=0.18715p pd=1.365u as=0.18715p ps=1.365u w=0.985u l=0.13u
X2 a_905_60# a_633_938# a_937_1434# w_n306_1197# sg13_lv_pmos ad=0.2448p pd=2.12u as=0.1152p ps=1.04u w=0.72u l=0.16u
X3 a_937_938# a_633_938# dw_n306_n60# dw_n306_n60# sg13_lv_nmos ad=48f pd=0.62u as=57f ps=0.68u w=0.3u l=0.16u
X4 dw_n306_n60# a_701_60# a_733_682# dw_n306_n60# sg13_lv_nmos ad=57f pd=0.68u as=48f ps=0.62u w=0.3u l=0.16u
X5 w_n306_1197# a_123_102# a_217_1318# w_n306_1197# sg13_lv_pmos ad=0.16165p pd=1.365u as=0.18715p ps=1.365u w=0.985u l=0.13u
X6 w_n408_n105# a_701_60# a_733_102# w_n408_n105# sg13_lv_pmos ad=0.1368p pd=1.1u as=0.1152p ps=1.04u w=0.72u l=0.16u
X7 a_905_60# a_633_938# a_937_938# dw_n306_n60# sg13_lv_nmos ad=0.102p pd=1.28u as=48f ps=0.62u w=0.3u l=0.16u
X8 a_733_682# a_701_60# a_395_60# dw_n306_n60# sg13_lv_nmos ad=48f pd=0.62u as=0.102p ps=1.28u w=0.3u l=0.16u
X9 a_937_1434# a_633_938# w_n306_1197# w_n306_1197# sg13_lv_pmos ad=0.1152p pd=1.04u as=0.1368p ps=1.1u w=0.72u l=0.16u
X10 dw_n306_n60# a_n13_60# a_n81_96# dw_n306_n60# sg13_lv_nmos ad=0.2397p pd=2.09u as=0.2397p ps=2.09u w=0.705u l=0.13u
X11 a_733_102# a_701_60# a_395_60# w_n408_n105# sg13_lv_pmos ad=0.1152p pd=1.04u as=0.2448p ps=2.12u w=0.72u l=0.16u
X12 a_937_682# a_905_60# dw_n306_n60# dw_n306_n60# sg13_lv_nmos ad=48f pd=0.62u as=57f ps=0.68u w=0.3u l=0.16u
X13 a_937_102# a_905_60# w_n408_n105# w_n408_n105# sg13_lv_pmos ad=0.1152p pd=1.04u as=0.1368p ps=1.1u w=0.72u l=0.16u
X14 a_701_60# a_905_60# a_937_682# dw_n306_n60# sg13_lv_nmos ad=0.102p pd=1.28u as=48f ps=0.62u w=0.3u l=0.16u
X15 a_701_60# a_905_60# a_937_102# w_n408_n105# sg13_lv_pmos ad=0.2448p pd=2.12u as=0.1152p ps=1.04u w=0.72u l=0.16u
X16 a_50_1124# a_89_1220# w_n306_1197# w_n306_1197# sg13_lv_pmos ad=0.2193p pd=1.97u as=0.16165p ps=1.365u w=0.645u l=0.13u
X17 w_n306_1197# a_n50_1148# a_733_1434# w_n306_1197# sg13_lv_pmos ad=0.1368p pd=1.1u as=0.1152p ps=1.04u w=0.72u l=0.16u
X18 a_217_998# a_89_1220# a_n13_60# dw_n306_n60# sg13_lv_nmos ad=91.2f pd=0.86u as=91.2f ps=0.86u w=0.48u l=0.13u
X19 dw_n306_n60# a_123_102# a_217_998# dw_n306_n60# sg13_lv_nmos ad=91.2f pd=0.86u as=91.2f ps=0.86u w=0.48u l=0.13u
X20 a_50_1124# a_89_1220# dw_n306_n60# dw_n306_n60# sg13_lv_nmos ad=0.1632p pd=1.64u as=91.2f ps=0.86u w=0.48u l=0.13u
X21 dw_n306_n60# a_n50_1148# a_733_938# dw_n306_n60# sg13_lv_nmos ad=57f pd=0.68u as=48f ps=0.62u w=0.3u l=0.16u
X22 w_n408_n105# a_n13_60# a_n81_96# w_n408_n105# sg13_lv_pmos ad=0.5508p pd=3.92u as=0.5508p ps=3.92u w=1.62u l=0.13u
X23 a_223_682# a_191_60# a_123_102# dw_n306_n60# sg13_lv_nmos ad=48f pd=0.62u as=0.102p ps=1.28u w=0.3u l=0.16u
X24 a_733_1434# a_n50_1148# a_633_938# w_n306_1197# sg13_lv_pmos ad=0.1152p pd=1.04u as=0.2448p ps=2.12u w=0.72u l=0.16u
X25 dw_n306_n60# a_191_60# a_223_682# dw_n306_n60# sg13_lv_nmos ad=57f pd=0.68u as=48f ps=0.62u w=0.3u l=0.16u
X26 a_223_102# a_191_60# a_123_102# w_n408_n105# sg13_lv_pmos ad=0.1152p pd=1.04u as=0.2448p ps=2.12u w=0.72u l=0.16u
X27 w_n408_n105# a_191_60# a_223_102# w_n408_n105# sg13_lv_pmos ad=0.1368p pd=1.1u as=0.1152p ps=1.04u w=0.72u l=0.16u
X28 a_217_1318# a_50_1124# a_n13_60# w_n306_1197# sg13_lv_pmos ad=0.18715p pd=1.365u as=0.18715p ps=1.365u w=0.985u l=0.13u
X29 a_191_60# a_395_60# a_427_682# dw_n306_n60# sg13_lv_nmos ad=0.102p pd=1.28u as=48f ps=0.62u w=0.3u l=0.16u
X30 a_427_682# a_395_60# dw_n306_n60# dw_n306_n60# sg13_lv_nmos ad=48f pd=0.62u as=57f ps=0.68u w=0.3u l=0.16u
X31 a_191_60# a_395_60# a_427_102# w_n408_n105# sg13_lv_pmos ad=0.2448p pd=2.12u as=0.1152p ps=1.04u w=0.72u l=0.16u
X32 a_n13_60# a_50_1124# a_13_998# dw_n306_n60# sg13_lv_nmos ad=91.2f pd=0.86u as=91.2f ps=0.86u w=0.48u l=0.13u
X33 a_733_938# a_n50_1148# a_633_938# dw_n306_n60# sg13_lv_nmos ad=48f pd=0.62u as=0.102p ps=1.28u w=0.3u l=0.16u
X34 a_427_102# a_395_60# w_n408_n105# w_n408_n105# sg13_lv_pmos ad=0.1152p pd=1.04u as=0.1368p ps=1.1u w=0.72u l=0.16u
X35 a_13_1318# a_n50_1148# w_n306_1197# w_n306_1197# sg13_lv_pmos ad=0.18715p pd=1.365u as=0.3349p ps=2.65u w=0.985u l=0.13u
.ends

.subckt RM_IHPSG13_1P_BITKIT_EDGE_LR LWL VSS VDD dw_n311_n199#
X0 VSS LWL VSS dw_n311_n199# sg13_lv_nmos ad=57f pd=0.68u as=0 ps=0 w=0.3u l=0.13u
X1 VSS a_n263_38# VSS dw_n311_n199# sg13_lv_nmos ad=0.1095p pd=1.33u as=0 ps=0 w=0.3u l=0.13u
.ends

.subckt RM_IHPSG13_1P_BITKIT_16x2_EDGE_LR LWL<1> LWL<2> LWL<3> LWL<4> LWL<5> LWL<7>
+ LWL<8> LWL<9> LWL<10> LWL<11> LWL<12> LWL<14> LWL<15> LWL<0> LWL<6> LWL<13> RM_IHPSG13_1P_BITKIT_EDGE_LR_9/VSS
+ RM_IHPSG13_1P_BITKIT_EDGE_LR_9/VDD
XRM_IHPSG13_1P_BITKIT_EDGE_LR_1 LWL<3> RM_IHPSG13_1P_BITKIT_EDGE_LR_9/VSS RM_IHPSG13_1P_BITKIT_EDGE_LR_9/VDD
+ RM_IHPSG13_1P_BITKIT_EDGE_LR_9/VSS RM_IHPSG13_1P_BITKIT_EDGE_LR
XRM_IHPSG13_1P_BITKIT_EDGE_LR_0 LWL<1> RM_IHPSG13_1P_BITKIT_EDGE_LR_9/VSS RM_IHPSG13_1P_BITKIT_EDGE_LR_9/VDD
+ RM_IHPSG13_1P_BITKIT_EDGE_LR_9/VSS RM_IHPSG13_1P_BITKIT_EDGE_LR
XRM_IHPSG13_1P_BITKIT_EDGE_LR_2 LWL<5> RM_IHPSG13_1P_BITKIT_EDGE_LR_9/VSS RM_IHPSG13_1P_BITKIT_EDGE_LR_9/VDD
+ RM_IHPSG13_1P_BITKIT_EDGE_LR_9/VSS RM_IHPSG13_1P_BITKIT_EDGE_LR
XRM_IHPSG13_1P_BITKIT_EDGE_LR_3 LWL<7> RM_IHPSG13_1P_BITKIT_EDGE_LR_9/VSS RM_IHPSG13_1P_BITKIT_EDGE_LR_9/VDD
+ RM_IHPSG13_1P_BITKIT_EDGE_LR_9/VSS RM_IHPSG13_1P_BITKIT_EDGE_LR
XRM_IHPSG13_1P_BITKIT_EDGE_LR_4 LWL<9> RM_IHPSG13_1P_BITKIT_EDGE_LR_9/VSS RM_IHPSG13_1P_BITKIT_EDGE_LR_9/VDD
+ RM_IHPSG13_1P_BITKIT_EDGE_LR_9/VSS RM_IHPSG13_1P_BITKIT_EDGE_LR
XRM_IHPSG13_1P_BITKIT_EDGE_LR_5 LWL<15> RM_IHPSG13_1P_BITKIT_EDGE_LR_9/VSS RM_IHPSG13_1P_BITKIT_EDGE_LR_9/VDD
+ RM_IHPSG13_1P_BITKIT_EDGE_LR_9/VSS RM_IHPSG13_1P_BITKIT_EDGE_LR
XRM_IHPSG13_1P_BITKIT_EDGE_LR_6 LWL<13> RM_IHPSG13_1P_BITKIT_EDGE_LR_9/VSS RM_IHPSG13_1P_BITKIT_EDGE_LR_9/VDD
+ RM_IHPSG13_1P_BITKIT_EDGE_LR_9/VSS RM_IHPSG13_1P_BITKIT_EDGE_LR
XRM_IHPSG13_1P_BITKIT_EDGE_LR_7 LWL<11> RM_IHPSG13_1P_BITKIT_EDGE_LR_9/VSS RM_IHPSG13_1P_BITKIT_EDGE_LR_9/VDD
+ RM_IHPSG13_1P_BITKIT_EDGE_LR_9/VSS RM_IHPSG13_1P_BITKIT_EDGE_LR
XRM_IHPSG13_1P_BITKIT_EDGE_LR_8 LWL<12> RM_IHPSG13_1P_BITKIT_EDGE_LR_9/VSS RM_IHPSG13_1P_BITKIT_EDGE_LR_9/VDD
+ RM_IHPSG13_1P_BITKIT_EDGE_LR_9/VSS RM_IHPSG13_1P_BITKIT_EDGE_LR
XRM_IHPSG13_1P_BITKIT_EDGE_LR_10 LWL<2> RM_IHPSG13_1P_BITKIT_EDGE_LR_9/VSS RM_IHPSG13_1P_BITKIT_EDGE_LR_9/VDD
+ RM_IHPSG13_1P_BITKIT_EDGE_LR_9/VSS RM_IHPSG13_1P_BITKIT_EDGE_LR
XRM_IHPSG13_1P_BITKIT_EDGE_LR_11 LWL<4> RM_IHPSG13_1P_BITKIT_EDGE_LR_9/VSS RM_IHPSG13_1P_BITKIT_EDGE_LR_9/VDD
+ RM_IHPSG13_1P_BITKIT_EDGE_LR_9/VSS RM_IHPSG13_1P_BITKIT_EDGE_LR
XRM_IHPSG13_1P_BITKIT_EDGE_LR_9 LWL<0> RM_IHPSG13_1P_BITKIT_EDGE_LR_9/VSS RM_IHPSG13_1P_BITKIT_EDGE_LR_9/VDD
+ RM_IHPSG13_1P_BITKIT_EDGE_LR_9/VSS RM_IHPSG13_1P_BITKIT_EDGE_LR
XRM_IHPSG13_1P_BITKIT_EDGE_LR_12 LWL<6> RM_IHPSG13_1P_BITKIT_EDGE_LR_9/VSS RM_IHPSG13_1P_BITKIT_EDGE_LR_9/VDD
+ RM_IHPSG13_1P_BITKIT_EDGE_LR_9/VSS RM_IHPSG13_1P_BITKIT_EDGE_LR
XRM_IHPSG13_1P_BITKIT_EDGE_LR_13 LWL<8> RM_IHPSG13_1P_BITKIT_EDGE_LR_9/VSS RM_IHPSG13_1P_BITKIT_EDGE_LR_9/VDD
+ RM_IHPSG13_1P_BITKIT_EDGE_LR_9/VSS RM_IHPSG13_1P_BITKIT_EDGE_LR
XRM_IHPSG13_1P_BITKIT_EDGE_LR_14 LWL<10> RM_IHPSG13_1P_BITKIT_EDGE_LR_9/VSS RM_IHPSG13_1P_BITKIT_EDGE_LR_9/VDD
+ RM_IHPSG13_1P_BITKIT_EDGE_LR_9/VSS RM_IHPSG13_1P_BITKIT_EDGE_LR
XRM_IHPSG13_1P_BITKIT_EDGE_LR_15 LWL<14> RM_IHPSG13_1P_BITKIT_EDGE_LR_9/VSS RM_IHPSG13_1P_BITKIT_EDGE_LR_9/VDD
+ RM_IHPSG13_1P_BITKIT_EDGE_LR_9/VSS RM_IHPSG13_1P_BITKIT_EDGE_LR
.ends

.subckt RM_IHPSG13_1P_BITKIT_CELL BLT_TOP BLT_BOT VSS VDD BLC_TOP BLC_BOT RWL LWL
+ VSS_uq0 dw_n311_n199# w_n115_n199#
X0 VDD a_n263_38# a_n229_n38# w_n115_n199# sg13_lv_pmos ad=74.24999f pd=1.19u as=86.99999f ps=1.36u w=0.15u l=0.13u
R0 BLT_TOP BLT_BOT 0.264000
X1 a_n229_n38# LWL BLT_BOT dw_n311_n199# sg13_lv_nmos ad=57f pd=0.68u as=0.1095p ps=1.33u w=0.3u l=0.13u
X2 a_n263_38# a_n229_n38# VDD w_n115_n199# sg13_lv_pmos ad=86.99999f pd=1.36u as=74.24999f ps=1.19u w=0.15u l=0.13u
X3 VSS a_n263_38# a_n229_n38# dw_n311_n199# sg13_lv_nmos ad=0.1095p pd=1.33u as=57f ps=0.68u w=0.3u l=0.13u
R1 BLC_TOP BLC_BOT 0.264000
R2 LWL RWL 0.264000
X4 a_n263_38# a_n229_n38# VSS_uq0 dw_n311_n199# sg13_lv_nmos ad=57f pd=0.68u as=0.1095p ps=1.33u w=0.3u l=0.13u
X5 BLC_TOP RWL a_n263_38# dw_n311_n199# sg13_lv_nmos ad=0.1095p pd=1.33u as=57f ps=0.68u w=0.3u l=0.13u
.ends

.subckt RM_IHPSG13_1P_BITKIT_CELL_2x1 RM_IHPSG13_1P_BITKIT_CELL_0/BLT_BOT RM_IHPSG13_1P_BITKIT_CELL_1/BLC_BOT
+ RM_IHPSG13_1P_BITKIT_CELL_0/RWL RM_IHPSG13_1P_BITKIT_CELL_1/LWL RM_IHPSG13_1P_BITKIT_CELL_1/BLT_BOT
+ RM_IHPSG13_1P_BITKIT_CELL_1/w_n115_n199# RM_IHPSG13_1P_BITKIT_CELL_1/RWL RM_IHPSG13_1P_BITKIT_CELL_1/VDD
+ RM_IHPSG13_1P_BITKIT_CELL_1/VSS w_115_n199# RM_IHPSG13_1P_BITKIT_CELL_0/BLC_BOT
+ RM_IHPSG13_1P_BITKIT_CELL_0/LWL
XRM_IHPSG13_1P_BITKIT_CELL_0 RM_IHPSG13_1P_BITKIT_CELL_1/BLT_TOP RM_IHPSG13_1P_BITKIT_CELL_0/BLT_BOT
+ RM_IHPSG13_1P_BITKIT_CELL_1/VSS RM_IHPSG13_1P_BITKIT_CELL_1/VDD RM_IHPSG13_1P_BITKIT_CELL_1/BLC_TOP
+ RM_IHPSG13_1P_BITKIT_CELL_0/BLC_BOT RM_IHPSG13_1P_BITKIT_CELL_0/RWL RM_IHPSG13_1P_BITKIT_CELL_0/LWL
+ RM_IHPSG13_1P_BITKIT_CELL_1/VSS w_115_n199# RM_IHPSG13_1P_BITKIT_CELL_1/w_n115_n199#
+ RM_IHPSG13_1P_BITKIT_CELL
XRM_IHPSG13_1P_BITKIT_CELL_1 RM_IHPSG13_1P_BITKIT_CELL_1/BLT_TOP RM_IHPSG13_1P_BITKIT_CELL_1/BLT_BOT
+ RM_IHPSG13_1P_BITKIT_CELL_1/VSS RM_IHPSG13_1P_BITKIT_CELL_1/VDD RM_IHPSG13_1P_BITKIT_CELL_1/BLC_TOP
+ RM_IHPSG13_1P_BITKIT_CELL_1/BLC_BOT RM_IHPSG13_1P_BITKIT_CELL_1/RWL RM_IHPSG13_1P_BITKIT_CELL_1/LWL
+ RM_IHPSG13_1P_BITKIT_CELL_1/VSS w_115_n199# RM_IHPSG13_1P_BITKIT_CELL_1/w_n115_n199#
+ RM_IHPSG13_1P_BITKIT_CELL
.ends

.subckt RM_IHPSG13_1P_BITKIT_16x2_SRAM A_BLT_BOT<1> A_BLT_TOP<1> A_BLC_BOT<1> A_BLC_TOP<1>
+ A_BLC_BOT<0> A_BLC_TOP<0> A_BLT_BOT<0> A_BLT_TOP<0> A_LWL<12> A_LWL<10> A_LWL<9>
+ A_LWL<8> A_LWL<6> A_LWL<5> A_LWL<4> A_LWL<3> A_LWL<1> A_RWL<10> A_RWL<12> A_RWL<15>
+ A_RWL<14> A_RWL<0> A_RWL<8> A_RWL<7> A_RWL<5> A_RWL<1> A_RWL<3> A_LWL<2> A_RWL<6>
+ A_LWL<15> A_RWL<9> A_RWL<2> A_LWL<13> A_LWL<0> A_RWL<4> A_LWL<11> A_RWL<13> A_LWL<7>
+ A_LWL<14> VDD A_RWL<11> VSS
XRM_IHPSG13_1P_BITKIT_CELL_2x1_3 RM_IHPSG13_1P_BITKIT_CELL_2x1_9/RM_IHPSG13_1P_BITKIT_CELL_0/BLT_BOT
+ RM_IHPSG13_1P_BITKIT_CELL_2x1_8/RM_IHPSG13_1P_BITKIT_CELL_1/BLC_BOT RM_IHPSG13_1P_BITKIT_CELL_2x1_3/RM_IHPSG13_1P_BITKIT_CELL_0/RWL
+ A_LWL<13> RM_IHPSG13_1P_BITKIT_CELL_2x1_8/RM_IHPSG13_1P_BITKIT_CELL_1/BLT_BOT VDD
+ RM_IHPSG13_1P_BITKIT_CELL_2x1_3/RM_IHPSG13_1P_BITKIT_CELL_1/RWL VDD VSS VSS RM_IHPSG13_1P_BITKIT_CELL_2x1_9/RM_IHPSG13_1P_BITKIT_CELL_0/BLC_BOT
+ A_LWL<12> RM_IHPSG13_1P_BITKIT_CELL_2x1
XRM_IHPSG13_1P_BITKIT_CELL_2x1_4 A_BLT_TOP<1> RM_IHPSG13_1P_BITKIT_CELL_2x1_4/RM_IHPSG13_1P_BITKIT_CELL_1/BLC_BOT
+ RM_IHPSG13_1P_BITKIT_CELL_2x1_8/RM_IHPSG13_1P_BITKIT_CELL_0/RWL A_RWL<14> RM_IHPSG13_1P_BITKIT_CELL_2x1_4/RM_IHPSG13_1P_BITKIT_CELL_1/BLT_BOT
+ VDD RM_IHPSG13_1P_BITKIT_CELL_2x1_8/RM_IHPSG13_1P_BITKIT_CELL_1/RWL VDD VSS VSS
+ A_BLC_TOP<1> A_RWL<15> RM_IHPSG13_1P_BITKIT_CELL_2x1
XRM_IHPSG13_1P_BITKIT_CELL_2x1_5 RM_IHPSG13_1P_BITKIT_CELL_2x1_5/RM_IHPSG13_1P_BITKIT_CELL_0/BLT_BOT
+ RM_IHPSG13_1P_BITKIT_CELL_2x1_5/RM_IHPSG13_1P_BITKIT_CELL_1/BLC_BOT RM_IHPSG13_1P_BITKIT_CELL_2x1_9/RM_IHPSG13_1P_BITKIT_CELL_0/RWL
+ A_RWL<10> RM_IHPSG13_1P_BITKIT_CELL_2x1_5/RM_IHPSG13_1P_BITKIT_CELL_1/BLT_BOT VDD
+ RM_IHPSG13_1P_BITKIT_CELL_2x1_9/RM_IHPSG13_1P_BITKIT_CELL_1/RWL VDD VSS VSS RM_IHPSG13_1P_BITKIT_CELL_2x1_5/RM_IHPSG13_1P_BITKIT_CELL_0/BLC_BOT
+ A_RWL<11> RM_IHPSG13_1P_BITKIT_CELL_2x1
XRM_IHPSG13_1P_BITKIT_CELL_2x1_6 RM_IHPSG13_1P_BITKIT_CELL_2x1_6/RM_IHPSG13_1P_BITKIT_CELL_0/BLT_BOT
+ RM_IHPSG13_1P_BITKIT_CELL_2x1_6/RM_IHPSG13_1P_BITKIT_CELL_1/BLC_BOT RM_IHPSG13_1P_BITKIT_CELL_2x1_6/RM_IHPSG13_1P_BITKIT_CELL_0/RWL
+ A_RWL<6> RM_IHPSG13_1P_BITKIT_CELL_2x1_6/RM_IHPSG13_1P_BITKIT_CELL_1/BLT_BOT VDD
+ RM_IHPSG13_1P_BITKIT_CELL_2x1_6/RM_IHPSG13_1P_BITKIT_CELL_1/RWL VDD VSS VSS RM_IHPSG13_1P_BITKIT_CELL_2x1_6/RM_IHPSG13_1P_BITKIT_CELL_0/BLC_BOT
+ A_RWL<7> RM_IHPSG13_1P_BITKIT_CELL_2x1
XRM_IHPSG13_1P_BITKIT_CELL_2x1_7 RM_IHPSG13_1P_BITKIT_CELL_2x1_7/RM_IHPSG13_1P_BITKIT_CELL_0/BLT_BOT
+ RM_IHPSG13_1P_BITKIT_CELL_2x1_7/RM_IHPSG13_1P_BITKIT_CELL_1/BLC_BOT RM_IHPSG13_1P_BITKIT_CELL_2x1_7/RM_IHPSG13_1P_BITKIT_CELL_0/RWL
+ A_RWL<2> RM_IHPSG13_1P_BITKIT_CELL_2x1_7/RM_IHPSG13_1P_BITKIT_CELL_1/BLT_BOT VDD
+ RM_IHPSG13_1P_BITKIT_CELL_2x1_7/RM_IHPSG13_1P_BITKIT_CELL_1/RWL VDD VSS VSS RM_IHPSG13_1P_BITKIT_CELL_2x1_7/RM_IHPSG13_1P_BITKIT_CELL_0/BLC_BOT
+ A_RWL<3> RM_IHPSG13_1P_BITKIT_CELL_2x1
XRM_IHPSG13_1P_BITKIT_CELL_2x1_8 A_BLT_TOP<0> RM_IHPSG13_1P_BITKIT_CELL_2x1_8/RM_IHPSG13_1P_BITKIT_CELL_1/BLC_BOT
+ RM_IHPSG13_1P_BITKIT_CELL_2x1_8/RM_IHPSG13_1P_BITKIT_CELL_0/RWL A_LWL<14> RM_IHPSG13_1P_BITKIT_CELL_2x1_8/RM_IHPSG13_1P_BITKIT_CELL_1/BLT_BOT
+ VDD RM_IHPSG13_1P_BITKIT_CELL_2x1_8/RM_IHPSG13_1P_BITKIT_CELL_1/RWL VDD VSS VSS
+ A_BLC_TOP<0> A_LWL<15> RM_IHPSG13_1P_BITKIT_CELL_2x1
XRM_IHPSG13_1P_BITKIT_CELL_2x1_9 RM_IHPSG13_1P_BITKIT_CELL_2x1_9/RM_IHPSG13_1P_BITKIT_CELL_0/BLT_BOT
+ RM_IHPSG13_1P_BITKIT_CELL_2x1_9/RM_IHPSG13_1P_BITKIT_CELL_1/BLC_BOT RM_IHPSG13_1P_BITKIT_CELL_2x1_9/RM_IHPSG13_1P_BITKIT_CELL_0/RWL
+ A_LWL<10> RM_IHPSG13_1P_BITKIT_CELL_2x1_9/RM_IHPSG13_1P_BITKIT_CELL_1/BLT_BOT VDD
+ RM_IHPSG13_1P_BITKIT_CELL_2x1_9/RM_IHPSG13_1P_BITKIT_CELL_1/RWL VDD VSS VSS RM_IHPSG13_1P_BITKIT_CELL_2x1_9/RM_IHPSG13_1P_BITKIT_CELL_0/BLC_BOT
+ A_LWL<11> RM_IHPSG13_1P_BITKIT_CELL_2x1
XRM_IHPSG13_1P_BITKIT_CELL_2x1_10 RM_IHPSG13_1P_BITKIT_CELL_2x1_2/RM_IHPSG13_1P_BITKIT_CELL_0/BLT_BOT
+ RM_IHPSG13_1P_BITKIT_CELL_2x1_1/RM_IHPSG13_1P_BITKIT_CELL_1/BLC_BOT RM_IHPSG13_1P_BITKIT_CELL_2x1_6/RM_IHPSG13_1P_BITKIT_CELL_0/RWL
+ A_LWL<6> RM_IHPSG13_1P_BITKIT_CELL_2x1_1/RM_IHPSG13_1P_BITKIT_CELL_1/BLT_BOT VDD
+ RM_IHPSG13_1P_BITKIT_CELL_2x1_6/RM_IHPSG13_1P_BITKIT_CELL_1/RWL VDD VSS VSS RM_IHPSG13_1P_BITKIT_CELL_2x1_2/RM_IHPSG13_1P_BITKIT_CELL_0/BLC_BOT
+ A_LWL<7> RM_IHPSG13_1P_BITKIT_CELL_2x1
XRM_IHPSG13_1P_BITKIT_CELL_2x1_11 RM_IHPSG13_1P_BITKIT_CELL_2x1_1/RM_IHPSG13_1P_BITKIT_CELL_0/BLT_BOT
+ RM_IHPSG13_1P_BITKIT_CELL_2x1_0/RM_IHPSG13_1P_BITKIT_CELL_1/BLC_BOT RM_IHPSG13_1P_BITKIT_CELL_2x1_7/RM_IHPSG13_1P_BITKIT_CELL_0/RWL
+ A_LWL<2> RM_IHPSG13_1P_BITKIT_CELL_2x1_0/RM_IHPSG13_1P_BITKIT_CELL_1/BLT_BOT VDD
+ RM_IHPSG13_1P_BITKIT_CELL_2x1_7/RM_IHPSG13_1P_BITKIT_CELL_1/RWL VDD VSS VSS RM_IHPSG13_1P_BITKIT_CELL_2x1_1/RM_IHPSG13_1P_BITKIT_CELL_0/BLC_BOT
+ A_LWL<3> RM_IHPSG13_1P_BITKIT_CELL_2x1
XRM_IHPSG13_1P_BITKIT_CELL_2x1_13 RM_IHPSG13_1P_BITKIT_CELL_2x1_5/RM_IHPSG13_1P_BITKIT_CELL_0/BLT_BOT
+ RM_IHPSG13_1P_BITKIT_CELL_2x1_4/RM_IHPSG13_1P_BITKIT_CELL_1/BLC_BOT RM_IHPSG13_1P_BITKIT_CELL_2x1_3/RM_IHPSG13_1P_BITKIT_CELL_0/RWL
+ A_RWL<13> RM_IHPSG13_1P_BITKIT_CELL_2x1_4/RM_IHPSG13_1P_BITKIT_CELL_1/BLT_BOT VDD
+ RM_IHPSG13_1P_BITKIT_CELL_2x1_3/RM_IHPSG13_1P_BITKIT_CELL_1/RWL VDD VSS VSS RM_IHPSG13_1P_BITKIT_CELL_2x1_5/RM_IHPSG13_1P_BITKIT_CELL_0/BLC_BOT
+ A_RWL<12> RM_IHPSG13_1P_BITKIT_CELL_2x1
XRM_IHPSG13_1P_BITKIT_CELL_2x1_12 RM_IHPSG13_1P_BITKIT_CELL_2x1_6/RM_IHPSG13_1P_BITKIT_CELL_0/BLT_BOT
+ RM_IHPSG13_1P_BITKIT_CELL_2x1_5/RM_IHPSG13_1P_BITKIT_CELL_1/BLC_BOT RM_IHPSG13_1P_BITKIT_CELL_2x1_2/RM_IHPSG13_1P_BITKIT_CELL_0/RWL
+ A_RWL<9> RM_IHPSG13_1P_BITKIT_CELL_2x1_5/RM_IHPSG13_1P_BITKIT_CELL_1/BLT_BOT VDD
+ RM_IHPSG13_1P_BITKIT_CELL_2x1_2/RM_IHPSG13_1P_BITKIT_CELL_1/RWL VDD VSS VSS RM_IHPSG13_1P_BITKIT_CELL_2x1_6/RM_IHPSG13_1P_BITKIT_CELL_0/BLC_BOT
+ A_RWL<8> RM_IHPSG13_1P_BITKIT_CELL_2x1
XRM_IHPSG13_1P_BITKIT_CELL_2x1_14 RM_IHPSG13_1P_BITKIT_CELL_2x1_7/RM_IHPSG13_1P_BITKIT_CELL_0/BLT_BOT
+ RM_IHPSG13_1P_BITKIT_CELL_2x1_6/RM_IHPSG13_1P_BITKIT_CELL_1/BLC_BOT RM_IHPSG13_1P_BITKIT_CELL_2x1_1/RM_IHPSG13_1P_BITKIT_CELL_0/RWL
+ A_RWL<5> RM_IHPSG13_1P_BITKIT_CELL_2x1_6/RM_IHPSG13_1P_BITKIT_CELL_1/BLT_BOT VDD
+ RM_IHPSG13_1P_BITKIT_CELL_2x1_1/RM_IHPSG13_1P_BITKIT_CELL_1/RWL VDD VSS VSS RM_IHPSG13_1P_BITKIT_CELL_2x1_7/RM_IHPSG13_1P_BITKIT_CELL_0/BLC_BOT
+ A_RWL<4> RM_IHPSG13_1P_BITKIT_CELL_2x1
XRM_IHPSG13_1P_BITKIT_CELL_2x1_15 A_BLT_BOT<1> RM_IHPSG13_1P_BITKIT_CELL_2x1_7/RM_IHPSG13_1P_BITKIT_CELL_1/BLC_BOT
+ RM_IHPSG13_1P_BITKIT_CELL_2x1_0/RM_IHPSG13_1P_BITKIT_CELL_0/RWL A_RWL<1> RM_IHPSG13_1P_BITKIT_CELL_2x1_7/RM_IHPSG13_1P_BITKIT_CELL_1/BLT_BOT
+ VDD RM_IHPSG13_1P_BITKIT_CELL_2x1_0/RM_IHPSG13_1P_BITKIT_CELL_1/RWL VDD VSS VSS
+ A_BLC_BOT<1> A_RWL<0> RM_IHPSG13_1P_BITKIT_CELL_2x1
XRM_IHPSG13_1P_BITKIT_CELL_2x1_0 A_BLT_BOT<0> RM_IHPSG13_1P_BITKIT_CELL_2x1_0/RM_IHPSG13_1P_BITKIT_CELL_1/BLC_BOT
+ RM_IHPSG13_1P_BITKIT_CELL_2x1_0/RM_IHPSG13_1P_BITKIT_CELL_0/RWL A_LWL<1> RM_IHPSG13_1P_BITKIT_CELL_2x1_0/RM_IHPSG13_1P_BITKIT_CELL_1/BLT_BOT
+ VDD RM_IHPSG13_1P_BITKIT_CELL_2x1_0/RM_IHPSG13_1P_BITKIT_CELL_1/RWL VDD VSS VSS
+ A_BLC_BOT<0> A_LWL<0> RM_IHPSG13_1P_BITKIT_CELL_2x1
XRM_IHPSG13_1P_BITKIT_CELL_2x1_1 RM_IHPSG13_1P_BITKIT_CELL_2x1_1/RM_IHPSG13_1P_BITKIT_CELL_0/BLT_BOT
+ RM_IHPSG13_1P_BITKIT_CELL_2x1_1/RM_IHPSG13_1P_BITKIT_CELL_1/BLC_BOT RM_IHPSG13_1P_BITKIT_CELL_2x1_1/RM_IHPSG13_1P_BITKIT_CELL_0/RWL
+ A_LWL<5> RM_IHPSG13_1P_BITKIT_CELL_2x1_1/RM_IHPSG13_1P_BITKIT_CELL_1/BLT_BOT VDD
+ RM_IHPSG13_1P_BITKIT_CELL_2x1_1/RM_IHPSG13_1P_BITKIT_CELL_1/RWL VDD VSS VSS RM_IHPSG13_1P_BITKIT_CELL_2x1_1/RM_IHPSG13_1P_BITKIT_CELL_0/BLC_BOT
+ A_LWL<4> RM_IHPSG13_1P_BITKIT_CELL_2x1
XRM_IHPSG13_1P_BITKIT_CELL_2x1_2 RM_IHPSG13_1P_BITKIT_CELL_2x1_2/RM_IHPSG13_1P_BITKIT_CELL_0/BLT_BOT
+ RM_IHPSG13_1P_BITKIT_CELL_2x1_9/RM_IHPSG13_1P_BITKIT_CELL_1/BLC_BOT RM_IHPSG13_1P_BITKIT_CELL_2x1_2/RM_IHPSG13_1P_BITKIT_CELL_0/RWL
+ A_LWL<9> RM_IHPSG13_1P_BITKIT_CELL_2x1_9/RM_IHPSG13_1P_BITKIT_CELL_1/BLT_BOT VDD
+ RM_IHPSG13_1P_BITKIT_CELL_2x1_2/RM_IHPSG13_1P_BITKIT_CELL_1/RWL VDD VSS VSS RM_IHPSG13_1P_BITKIT_CELL_2x1_2/RM_IHPSG13_1P_BITKIT_CELL_0/BLC_BOT
+ A_LWL<8> RM_IHPSG13_1P_BITKIT_CELL_2x1
.ends

.subckt RM_IHPSG13_1P_COLUMN_256 RM_IHPSG13_1P_BITKIT_16x2_SRAM_0[0]/A_BLT_BOT<0>
+ RM_IHPSG13_1P_BITKIT_16x2_SRAM_0[0]/A_BLT_BOT<1> RM_IHPSG13_1P_BITKIT_16x2_SRAM_0[0]/A_BLC_BOT<0>
+ RM_IHPSG13_1P_BITKIT_16x2_SRAM_1[3]/A_RWL<6> RM_IHPSG13_1P_BITKIT_16x2_SRAM_0[3]/A_RWL<11>
+ RM_IHPSG13_1P_BITKIT_16x2_SRAM_0[0]/A_BLC_BOT<1> RM_IHPSG13_1P_BITKIT_16x2_SRAM_3[1]/A_LWL<12>
+ RM_IHPSG13_1P_BITKIT_16x2_SRAM_1[3]/A_RWL<8> RM_IHPSG13_1P_BITKIT_16x2_SRAM_0[3]/A_RWL<9>
+ RM_IHPSG13_1P_BITKIT_16x2_SRAM_0[3]/A_LWL<4> RM_IHPSG13_1P_BITKIT_16x2_SRAM_3[2]/A_LWL<9>
+ RM_IHPSG13_1P_BITKIT_16x2_SRAM_2[3]/A_LWL<1> RM_IHPSG13_1P_BITKIT_16x2_SRAM_0[3]/A_RWL<14>
+ RM_IHPSG13_1P_BITKIT_16x2_SRAM_0[2]/A_RWL<14> RM_IHPSG13_1P_BITKIT_16x2_SRAM_2[0]/A_LWL<11>
+ RM_IHPSG13_1P_BITKIT_16x2_SRAM_2[3]/A_LWL<4> RM_IHPSG13_1P_BITKIT_16x2_SRAM_3[2]/A_LWL<12>
+ RM_IHPSG13_1P_BITKIT_16x2_SRAM_1[2]/A_LWL<9> RM_IHPSG13_1P_BITKIT_16x2_SRAM_3[3]/A_RWL<9>
+ RM_IHPSG13_1P_BITKIT_16x2_SRAM_1[3]/A_LWL<2> RM_IHPSG13_1P_BITKIT_16x2_SRAM_0[3]/A_LWL<1>
+ RM_IHPSG13_1P_BITKIT_16x2_SRAM_2[3]/A_RWL<7> RM_IHPSG13_1P_BITKIT_16x2_SRAM_0[0]/A_RWL<0>
+ RM_IHPSG13_1P_BITKIT_16x2_SRAM_2[0]/A_RWL<1> RM_IHPSG13_1P_BITKIT_16x2_SRAM_0[2]/A_RWL<13>
+ RM_IHPSG13_1P_BITKIT_16x2_SRAM_2[3]/A_RWL<5> RM_IHPSG13_1P_BITKIT_16x2_SRAM_2[3]/A_LWL<3>
+ RM_IHPSG13_1P_BITKIT_16x2_SRAM_3[0]/A_RWL<13> RM_IHPSG13_1P_BITKIT_16x2_SRAM_1[0]/A_RWL<3>
+ RM_IHPSG13_1P_BITKIT_16x2_SRAM_3[1]/A_LWL<15> RM_IHPSG13_1P_BITKIT_16x2_SRAM_2[0]/A_LWL<14>
+ RM_IHPSG13_1P_BITKIT_16x2_SRAM_0[3]/A_RWL<7> RM_IHPSG13_1P_BITKIT_16x2_SRAM_3[0]/A_RWL<0>
+ RM_IHPSG13_1P_BITKIT_16x2_SRAM_3[2]/A_LWL<15> RM_IHPSG13_1P_BITKIT_16x2_SRAM_3[3]/A_RWL<4>
+ RM_IHPSG13_1P_BITKIT_16x2_SRAM_3[2]/A_LWL<7> RM_IHPSG13_1P_BITKIT_16x2_SRAM_0[0]/A_LWL<0>
+ RM_IHPSG13_1P_BITKIT_16x2_SRAM_1[3]/A_LWL<9> RM_IHPSG13_1P_BITKIT_16x2_SRAM_3[0]/A_RWL<3>
+ RM_IHPSG13_1P_BITKIT_16x2_SRAM_0[0]/A_RWL<5> RM_IHPSG13_1P_BITKIT_16x2_SRAM_0[3]/A_RWL<13>
+ RM_IHPSG13_1P_BITKIT_16x2_SRAM_2[3]/A_LWL<8> RM_IHPSG13_1P_BITKIT_16x2_SRAM_0[3]/A_LWL<7>
+ RM_IHPSG13_1P_BITKIT_16x2_SRAM_3[0]/A_LWL<15> RM_IHPSG13_1P_BITKIT_16x2_SRAM_3[3]/A_LWL<13>
+ RM_IHPSG13_1P_BITKIT_16x2_SRAM_2[3]/A_LWL<6> RM_IHPSG13_1P_BITKIT_16x2_SRAM_2[1]/A_LWL<10>
+ RM_IHPSG13_1P_BITKIT_16x2_SRAM_3[3]/A_LWL<0> RM_IHPSG13_1P_BITKIT_16x2_SRAM_3[0]/A_RWL<4>
+ RM_IHPSG13_1P_BITKIT_16x2_SRAM_2[2]/A_LWL<10> RM_IHPSG13_1P_BITKIT_16x2_SRAM_3[1]/A_RWL<13>
+ RM_IHPSG13_1P_BITKIT_16x2_SRAM_1[0]/A_RWL<6> RM_IHPSG13_1P_BITKIT_16x2_SRAM_3[3]/A_LWL<9>
+ RM_IHPSG13_1P_BITKIT_16x2_SRAM_1[0]/A_RWL<4> RM_IHPSG13_1P_BITKIT_16x2_SRAM_0[3]/A_RWL<10>
+ RM_IHPSG13_1P_BITKIT_16x2_SRAM_2[1]/A_LWL<14> RM_IHPSG13_1P_BITKIT_16x2_SRAM_3[0]/A_RWL<5>
+ RM_IHPSG13_1P_BITKIT_16x2_SRAM_0[3]/A_LWL<8> RM_IHPSG13_1P_BITKIT_16x2_SRAM_3[3]/A_LWL<7>
+ RM_IHPSG13_1P_BITKIT_16x2_SRAM_2[2]/A_LWL<8> RM_IHPSG13_1P_BITKIT_16x2_SRAM_3[3]/A_LWL<15>
+ RM_IHPSG13_1P_BITKIT_16x2_SRAM_3[2]/A_LWL<13> RM_IHPSG13_1P_BITKIT_16x2_SRAM_2[0]/A_LWL<1>
+ RM_IHPSG13_1P_BITKIT_16x2_SRAM_0[0]/A_LWL<1> RM_IHPSG13_1P_BITKIT_16x2_SRAM_1[3]/A_LWL<0>
+ RM_IHPSG13_1P_BITKIT_16x2_SRAM_2[0]/A_LWL<10> RM_IHPSG13_1P_BITKIT_16x2_SRAM_3[3]/A_LWL<11>
+ RM_IHPSG13_1P_BITKIT_16x2_SRAM_0[0]/A_LWL<3> RM_IHPSG13_1P_BITKIT_16x2_SRAM_3[0]/A_RWL<6>
+ RM_IHPSG13_1P_BITKIT_16x2_SRAM_2[3]/A_LWL<5> RM_IHPSG13_1P_BITKIT_16x2_SRAM_2[0]/A_RWL<7>
+ RM_IHPSG13_1P_BITKIT_16x2_SRAM_3[1]/A_RWL<15> RM_IHPSG13_1P_BITKIT_16x2_SRAM_0[1]/A_RWL<0>
+ RM_IHPSG13_1P_BITKIT_16x2_SRAM_3[0]/A_RWL<2> RM_IHPSG13_1P_BITKIT_16x2_SRAM_2[0]/A_RWL<11>
+ RM_IHPSG13_1P_BITKIT_16x2_SRAM_2[0]/A_LWL<2> RM_IHPSG13_1P_BITKIT_16x2_SRAM_3[0]/A_RWL<15>
+ RM_IHPSG13_1P_BITKIT_16x2_SRAM_0[0]/A_LWL<4> RM_IHPSG13_1P_BITKIT_16x2_SRAM_1[0]/A_LWL<12>
+ RM_IHPSG13_1P_BITKIT_16x2_SRAM_2[0]/A_RWL<8> RM_IHPSG13_1P_BITKIT_16x2_SRAM_1[0]/A_RWL<9>
+ RM_IHPSG13_1P_BITKIT_16x2_SRAM_3[1]/A_LWL<13> RM_IHPSG13_1P_BITKIT_16x2_SRAM_1[3]/A_RWL<9>
+ RM_IHPSG13_1P_BITKIT_16x2_SRAM_2[3]/A_LWL<10> RM_IHPSG13_1P_BITKIT_16x2_SRAM_3[2]/A_RWL<13>
+ RM_IHPSG13_1P_BITKIT_16x2_SRAM_3[2]/A_LWL<11> RM_IHPSG13_1P_BITKIT_16x2_SRAM_0[0]/A_RWL<7>
+ RM_IHPSG13_1P_BITKIT_16x2_SRAM_0[3]/A_LWL<5> RM_IHPSG13_1P_BITKIT_16x2_SRAM_1[0]/A_RWL<2>
+ RM_IHPSG13_1P_BITKIT_16x2_SRAM_2[2]/A_LWL<14> RM_IHPSG13_1P_BITKIT_16x2_SRAM_3[0]/A_LWL<3>
+ RM_IHPSG13_1P_BITKIT_16x2_SRAM_2[0]/A_LWL<4> RM_IHPSG13_1P_BITKIT_16x2_SRAM_3[3]/A_LWL<14>
+ RM_IHPSG13_1P_BITKIT_16x2_SRAM_2[1]/A_RWL<10> RM_IHPSG13_1P_BITKIT_16x2_SRAM_1[0]/A_LWL<5>
+ RM_IHPSG13_1P_BITKIT_16x2_SRAM_3[1]/A_RWL<0> RM_IHPSG13_1P_BITKIT_16x2_SRAM_2[0]/A_RWL<10>
+ RM_IHPSG13_1P_BITKIT_16x2_SRAM_2[0]/A_RWL<12> RM_IHPSG13_1P_BITKIT_16x2_SRAM_3[3]/A_RWL<11>
+ RM_IHPSG13_1P_BITKIT_16x2_SRAM_0[0]/A_LWL<6> RM_IHPSG13_1P_BITKIT_16x2_SRAM_2[1]/A_RWL<1>
+ RM_IHPSG13_1P_BITKIT_16x2_SRAM_2[3]/A_RWL<8> RM_IHPSG13_1P_BITKIT_16x2_SRAM_1[1]/A_RWL<2>
+ RM_IHPSG13_1P_BITKIT_16x2_SRAM_2[0]/A_RWL<14> RM_IHPSG13_1P_BITKIT_16x2_SRAM_3[0]/A_LWL<13>
+ RM_IHPSG13_1P_BITKIT_16x2_SRAM_3[2]/A_RWL<15> RM_IHPSG13_1P_BITKIT_16x2_SRAM_2[1]/A_RWL<11>
+ RM_IHPSG13_1P_BITKIT_16x2_SRAM_3[1]/A_LWL<11> RM_IHPSG13_1P_BITKIT_16x2_SRAM_3[0]/A_LWL<0>
+ RM_IHPSG13_1P_BITKIT_16x2_SRAM_3[3]/A_RWL<12> RM_IHPSG13_1P_BITKIT_16x2_SRAM_0[0]/A_LWL<7>
+ RM_IHPSG13_1P_BITKIT_16x2_SRAM_1[0]/A_LWL<15> RM_IHPSG13_1P_BITKIT_16x2_SRAM_1[1]/A_RWL<3>
+ RM_IHPSG13_1P_BITKIT_16x2_SRAM_1[1]/A_LWL<12> RM_IHPSG13_1P_BITKIT_16x2_SRAM_0[1]/A_RWL<4>
+ RM_IHPSG13_1P_BITKIT_16x2_SRAM_3[0]/A_LWL<5> RM_IHPSG13_1P_BITKIT_16x2_SRAM_2[0]/A_LWL<6>
+ RM_IHPSG13_1P_BITKIT_16x2_SRAM_3[2]/A_LWL<14> RM_IHPSG13_1P_BITKIT_16x2_SRAM_1[0]/A_LWL<7>
+ RM_IHPSG13_1P_BITKIT_16x2_SRAM_3[1]/A_RWL<2> RM_IHPSG13_1P_BITKIT_16x2_SRAM_3[2]/A_RWL<11>
+ RM_IHPSG13_1P_BITKIT_16x2_SRAM_3[3]/A_RWL<13> RM_IHPSG13_1P_BITKIT_16x2_SRAM_0[0]/A_LWL<8>
+ RM_IHPSG13_1P_BITKIT_16x2_SRAM_2[3]/A_RWL<6> RM_IHPSG13_1P_BITKIT_16x2_SRAM_1[1]/A_RWL<4>
+ RM_IHPSG13_1P_BITKIT_16x2_SRAM_0[0]/A_RWL<1> RM_IHPSG13_1P_BITKIT_16x2_SRAM_1[1]/A_LWL<13>
+ RM_IHPSG13_1P_BITKIT_16x2_SRAM_1[0]/A_LWL<13> RM_IHPSG13_1P_BITKIT_16x2_SRAM_0[1]/A_RWL<5>
+ RM_IHPSG13_1P_BITKIT_16x2_SRAM_3[0]/A_LWL<6> RM_IHPSG13_1P_BITKIT_16x2_SRAM_2[3]/A_LWL<12>
+ RM_IHPSG13_1P_BITKIT_16x2_SRAM_1[1]/A_LWL<11> RM_IHPSG13_1P_BITKIT_16x2_SRAM_0[0]/A_RWL<8>
+ RM_IHPSG13_1P_BITKIT_16x2_SRAM_1[0]/A_LWL<0> RM_IHPSG13_1P_BITKIT_16x2_SRAM_0[3]/A_LWL<3>
+ RM_IHPSG13_1P_BITKIT_16x2_SRAM_2[1]/A_RWL<12> RM_IHPSG13_1P_BITKIT_16x2_SRAM_2[0]/A_RWL<9>
+ RM_IHPSG13_1P_BITKIT_16x2_SRAM_3[1]/A_RWL<3> RM_IHPSG13_1P_BITKIT_16x2_SRAM_2[3]/A_LWL<2>
+ RM_IHPSG13_1P_BITKIT_16x2_SRAM_3[3]/A_RWL<14> RM_IHPSG13_1P_BITKIT_16x2_SRAM_2[2]/A_RWL<10>
+ RM_IHPSG13_1P_BITKIT_16x2_SRAM_2[0]/A_LWL<5> RM_IHPSG13_1P_BITKIT_16x2_SRAM_3[3]/A_LWL<4>
+ RM_IHPSG13_1P_BITKIT_16x2_SRAM_2[1]/A_RWL<3> RM_IHPSG13_1P_BITKIT_16x2_SRAM_3[0]/A_LWL<7>
+ RM_IHPSG13_1P_BITKIT_16x2_SRAM_0[0]/A_LWL<10> RM_IHPSG13_1P_BITKIT_16x2_SRAM_1[1]/A_LWL<0>
+ RM_IHPSG13_1P_BITKIT_16x2_SRAM_2[0]/A_LWL<8> RM_IHPSG13_1P_BITKIT_16x2_SRAM_3[1]/A_LWL<14>
+ RM_IHPSG13_1P_BITKIT_16x2_SRAM_1[2]/A_LWL<11> RM_IHPSG13_1P_BITKIT_16x2_SRAM_2[1]/A_RWL<14>
+ RM_IHPSG13_1P_BITKIT_16x2_SRAM_0[1]/A_LWL<1> RM_IHPSG13_1P_BITKIT_16x2_SRAM_1[0]/A_LWL<9>
+ RM_IHPSG13_1P_BITKIT_16x2_SRAM_3[1]/A_RWL<4> RM_IHPSG13_1P_BITKIT_16x2_SRAM_1[0]/A_RWL<0>
+ RM_IHPSG13_1P_BITKIT_16x2_SRAM_3[1]/A_RWL<11> RM_IHPSG13_1P_BITKIT_16x2_SRAM_3[3]/A_RWL<15>
+ RM_IHPSG13_1P_BITKIT_16x2_SRAM_0[3]/A_RWL<6> RM_IHPSG13_1P_BITKIT_16x2_SRAM_2[1]/A_RWL<5>
+ RM_IHPSG13_1P_BITKIT_16x2_SRAM_2[2]/A_RWL<11> RM_IHPSG13_1P_BITKIT_16x2_SRAM_3[0]/A_RWL<1>
+ RM_IHPSG13_1P_BITKIT_16x2_SRAM_3[3]/A_RWL<5> RM_IHPSG13_1P_BITKIT_16x2_SRAM_1[1]/A_RWL<6>
+ RM_IHPSG13_1P_BITKIT_16x2_SRAM_3[0]/A_RWL<8> RM_IHPSG13_1P_BITKIT_16x2_SRAM_1[1]/A_LWL<15>
+ RM_IHPSG13_1P_BITKIT_16x2_SRAM_0[1]/A_RWL<7> RM_IHPSG13_1P_BITKIT_16x2_SRAM_3[3]/A_LWL<3>
+ RM_IHPSG13_1P_BITKIT_16x2_SRAM_0[0]/A_LWL<11> RM_IHPSG13_1P_BITKIT_16x2_SRAM_2[2]/A_LWL<12>
+ RM_IHPSG13_1P_BITKIT_16x2_SRAM_1[0]/A_LWL<11> RM_IHPSG13_1P_BITKIT_16x2_SRAM_1[2]/A_LWL<12>
+ RM_IHPSG13_1P_BITKIT_16x2_SRAM_3[2]/A_RWL<14> RM_IHPSG13_1P_BITKIT_16x2_SRAM_3[1]/A_RWL<5>
+ RM_IHPSG13_1P_BITKIT_16x2_SRAM_0[0]/A_LWL<5> RM_IHPSG13_1P_BITKIT_16x2_SRAM_1[3]/A_LWL<4>
+ RM_IHPSG13_1P_BITKIT_16x2_SRAM_0[1]/A_RWL<1> RM_IHPSG13_1P_BITKIT_16x2_SRAM_0[1]/A_RWL<3>
+ RM_IHPSG13_1P_BITKIT_16x2_SRAM_3[1]/A_LWL<0> RM_IHPSG13_1P_BITKIT_16x2_SRAM_2[0]/A_RWL<3>
+ RM_IHPSG13_1P_BITKIT_16x2_SRAM_2[3]/A_LWL<9> RM_IHPSG13_1P_BITKIT_16x2_SRAM_2[1]/A_LWL<1>
+ RM_IHPSG13_1P_BITKIT_16x2_SRAM_3[0]/A_LWL<9> RM_IHPSG13_1P_BITKIT_16x2_SRAM_0[1]/A_RWL<8>
+ RM_IHPSG13_1P_BITKIT_16x2_SRAM_1[1]/A_LWL<14> RM_IHPSG13_1P_BITKIT_16x2_SRAM_0[0]/A_LWL<2>
+ RM_IHPSG13_1P_BITKIT_16x2_SRAM_2[2]/A_RWL<12> RM_IHPSG13_1P_BITKIT_16x2_SRAM_1[1]/A_LWL<2>
+ RM_IHPSG13_1P_BITKIT_16x2_SRAM_0[3]/A_LWL<6> RM_IHPSG13_1P_BITKIT_16x2_SRAM_3[0]/A_LWL<14>
+ RM_IHPSG13_1P_BITKIT_16x2_SRAM_1[2]/A_LWL<13> RM_IHPSG13_1P_BITKIT_16x2_SRAM_0[1]/A_LWL<3>
+ RM_IHPSG13_1P_BITKIT_16x2_SRAM_1[0]/A_RWL<12> RM_IHPSG13_1P_BITKIT_16x2_SRAM_3[1]/A_RWL<6>
+ RM_IHPSG13_1P_BITKIT_16x2_SRAM_3[0]/A_RWL<11> RM_IHPSG13_1P_BITKIT_16x2_SRAM_3[3]/A_LWL<1>
+ RM_IHPSG13_1P_BITKIT_16x2_SRAM_2[1]/A_RWL<7> RM_IHPSG13_1P_BITKIT_16x2_SRAM_2[1]/A_RWL<6>
+ RM_IHPSG13_1P_BITKIT_16x2_SRAM_0[2]/A_RWL<0> RM_IHPSG13_1P_BITKIT_16x2_SRAM_2[3]/A_RWL<10>
+ RM_IHPSG13_1P_BITKIT_16x2_SRAM_2[1]/A_LWL<2> RM_IHPSG13_1P_BITKIT_16x2_SRAM_0[0]/A_LWL<13>
+ RM_IHPSG13_1P_BITKIT_16x2_SRAM_2[1]/A_LWL<12> RM_IHPSG13_1P_BITKIT_16x2_SRAM_1[1]/A_RWL<0>
+ RM_IHPSG13_1P_BITKIT_16x2_SRAM_1[2]/A_LWL<14> RM_IHPSG13_1P_BITKIT_16x2_SRAM_1[0]/A_RWL<5>
+ RM_IHPSG13_1P_BITKIT_16x2_SRAM_0[1]/A_LWL<10> RM_IHPSG13_1P_BITKIT_16x2_SRAM_0[1]/A_LWL<4>
+ RM_IHPSG13_1P_BITKIT_16x2_SRAM_3[1]/A_RWL<14> RM_IHPSG13_1P_BITKIT_16x2_SRAM_3[1]/A_RWL<1>
+ RM_IHPSG13_1P_BITKIT_16x2_SRAM_1[0]/A_RWL<13> RM_IHPSG13_1P_BITKIT_16x2_SRAM_1[3]/A_LWL<11>
+ RM_IHPSG13_1P_BITKIT_16x2_SRAM_2[1]/A_RWL<8> RM_IHPSG13_1P_BITKIT_16x2_SRAM_1[0]/A_LWL<3>
+ RM_IHPSG13_1P_BITKIT_16x2_SRAM_2[2]/A_RWL<14> RM_IHPSG13_1P_BITKIT_16x2_SRAM_1[3]/A_LWL<7>
+ RM_IHPSG13_1P_BITKIT_16x2_SRAM_0[0]/A_RWL<3> RM_IHPSG13_1P_BITKIT_16x2_SRAM_0[3]/A_LWL<9>
+ RM_IHPSG13_1P_BITKIT_16x2_SRAM_3[0]/A_LWL<2> RM_IHPSG13_1P_BITKIT_16x2_SRAM_1[1]/A_RWL<9>
+ RM_IHPSG13_1P_BITKIT_16x2_SRAM_3[3]/A_LWL<6> RM_IHPSG13_1P_BITKIT_16x2_SRAM_2[2]/A_LWL<9>
+ RM_IHPSG13_1P_BITKIT_16x2_SRAM_2[1]/A_LWL<3> RM_IHPSG13_1P_BITKIT_16x2_SRAM_0[0]/A_LWL<14>
+ RM_IHPSG13_1P_BITKIT_16x2_SRAM_1[0]/A_LWL<14> RM_IHPSG13_1P_BITKIT_16x2_SRAM_2[3]/A_LWL<15>
+ RM_IHPSG13_1P_BITKIT_16x2_SRAM_1[2]/A_LWL<15> RM_IHPSG13_1P_BITKIT_16x2_SRAM_0[1]/A_LWL<11>
+ RM_IHPSG13_1P_BITKIT_16x2_SRAM_0[1]/A_LWL<5> RM_IHPSG13_1P_BITKIT_16x2_SRAM_1[0]/A_RWL<11>
+ RM_IHPSG13_1P_BITKIT_16x2_SRAM_2[2]/A_RWL<0> RM_IHPSG13_1P_BITKIT_16x2_SRAM_1[3]/A_LWL<1>
+ RM_IHPSG13_1P_BITKIT_16x2_SRAM_3[1]/A_RWL<8> RM_IHPSG13_1P_BITKIT_16x2_SRAM_0[2]/A_RWL<1>
+ RM_IHPSG13_1P_BITKIT_16x2_SRAM_3[3]/A_LWL<10> RM_IHPSG13_1P_BITKIT_16x2_SRAM_1[3]/A_LWL<12>
+ RM_IHPSG13_1P_BITKIT_16x2_SRAM_1[2]/A_RWL<1> RM_IHPSG13_1P_BITKIT_16x2_SRAM_0[1]/A_RWL<6>
+ RM_IHPSG13_1P_BITKIT_16x2_SRAM_2[1]/A_RWL<9> RM_IHPSG13_1P_BITKIT_16x2_SRAM_1[1]/A_RWL<11>
+ RM_IHPSG13_1P_BITKIT_16x2_SRAM_2[0]/A_RWL<6> RM_IHPSG13_1P_BITKIT_16x2_SRAM_3[1]/A_LWL<3>
+ RM_IHPSG13_1P_BITKIT_16x2_SRAM_2[0]/A_RWL<4> RM_IHPSG13_1P_BITKIT_16x2_SRAM_3[3]/A_RWL<7>
+ RM_IHPSG13_1P_BITKIT_16x2_SRAM_0[1]/A_LWL<2> RM_IHPSG13_1P_BITKIT_16x2_SRAM_2[3]/A_RWL<12>
+ RM_IHPSG13_1P_BITKIT_16x2_SRAM_2[1]/A_LWL<4> RM_IHPSG13_1P_BITKIT_16x2_SRAM_2[0]/A_LWL<12>
+ RM_IHPSG13_1P_BITKIT_16x2_SRAM_1[1]/A_LWL<5> RM_IHPSG13_1P_BITKIT_16x2_SRAM_3[2]/A_RWL<0>
+ RM_IHPSG13_1P_BITKIT_16x2_SRAM_0[1]/A_LWL<12> RM_IHPSG13_1P_BITKIT_16x2_SRAM_0[1]/A_LWL<6>
+ RM_IHPSG13_1P_BITKIT_16x2_SRAM_2[2]/A_RWL<1> RM_IHPSG13_1P_BITKIT_16x2_SRAM_3[0]/A_RWL<14>
+ RM_IHPSG13_1P_BITKIT_16x2_SRAM_1[0]/A_RWL<15> RM_IHPSG13_1P_BITKIT_16x2_SRAM_1[1]/A_LWL<4>
+ RM_IHPSG13_1P_BITKIT_16x2_SRAM_1[3]/A_LWL<13> RM_IHPSG13_1P_BITKIT_16x2_SRAM_1[2]/A_RWL<2>
+ RM_IHPSG13_1P_BITKIT_16x2_SRAM_1[1]/A_RWL<12> RM_IHPSG13_1P_BITKIT_16x2_SRAM_3[0]/A_LWL<4>
+ RM_IHPSG13_1P_BITKIT_16x2_SRAM_0[2]/A_LWL<9> RM_IHPSG13_1P_BITKIT_16x2_SRAM_0[2]/A_RWL<3>
+ RM_IHPSG13_1P_BITKIT_16x2_SRAM_3[1]/A_LWL<4> RM_IHPSG13_1P_BITKIT_16x2_SRAM_2[1]/A_LWL<5>
+ RM_IHPSG13_1P_BITKIT_16x2_SRAM_1[2]/A_RWL<0> RM_IHPSG13_1P_BITKIT_16x2_SRAM_1[1]/A_RWL<5>
+ RM_IHPSG13_1P_BITKIT_16x2_SRAM_2[2]/A_LWL<15> RM_IHPSG13_1P_BITKIT_16x2_SRAM_3[2]/A_RWL<1>
+ RM_IHPSG13_1P_BITKIT_16x2_SRAM_1[3]/A_LWL<10> RM_IHPSG13_1P_BITKIT_16x2_SRAM_0[1]/A_LWL<7>
+ RM_IHPSG13_1P_BITKIT_16x2_SRAM_1[1]/A_LWL<3> RM_IHPSG13_1P_BITKIT_16x2_SRAM_1[0]/A_LWL<6>
+ RM_IHPSG13_1P_BITKIT_16x2_SRAM_3[2]/A_LWL<10> RM_IHPSG13_1P_BITKIT_16x2_SRAM_1[3]/A_LWL<14>
+ RM_IHPSG13_1P_BITKIT_16x2_SRAM_3[1]/A_LWL<1> RM_IHPSG13_1P_BITKIT_16x2_SRAM_3[1]/A_LWL<2>
+ RM_IHPSG13_1P_BITKIT_16x2_SRAM_0[0]/A_RWL<6> RM_IHPSG13_1P_BITKIT_16x2_SRAM_1[2]/A_RWL<3>
+ RM_IHPSG13_1P_BITKIT_16x2_SRAM_0[2]/A_LWL<10> RM_IHPSG13_1P_BITKIT_16x2_SRAM_1[3]/A_RWL<7>
+ RM_IHPSG13_1P_BITKIT_16x2_SRAM_1[1]/A_RWL<13> RM_IHPSG13_1P_BITKIT_16x2_SRAM_0[2]/A_RWL<4>
+ RM_IHPSG13_1P_BITKIT_16x2_SRAM_0[0]/A_LWL<12> RM_IHPSG13_1P_BITKIT_16x2_SRAM_2[3]/A_RWL<14>
+ RM_IHPSG13_1P_BITKIT_16x2_SRAM_2[1]/A_LWL<6> RM_IHPSG13_1P_BITKIT_16x2_SRAM_1[1]/A_LWL<7>
+ RM_IHPSG13_1P_BITKIT_16x2_SRAM_3[2]/A_RWL<2> RM_IHPSG13_1P_BITKIT_16x2_SRAM_1[0]/A_RWL<14>
+ RM_IHPSG13_1P_BITKIT_16x2_SRAM_0[1]/A_LWL<14> RM_IHPSG13_1P_BITKIT_16x2_SRAM_0[1]/A_LWL<8>
+ RM_IHPSG13_1P_BITKIT_16x2_SRAM_2[2]/A_RWL<3> RM_IHPSG13_1P_BITKIT_16x2_SRAM_1[3]/A_LWL<15>
+ RM_IHPSG13_1P_BITKIT_16x2_SRAM_1[0]/A_LWL<4> RM_IHPSG13_1P_BITKIT_16x2_SRAM_1[2]/A_RWL<4>
+ RM_IHPSG13_1P_BITKIT_16x2_SRAM_0[3]/A_RWL<8> RM_IHPSG13_1P_BITKIT_16x2_SRAM_2[1]/A_RWL<4>
+ RM_IHPSG13_1P_BITKIT_16x2_SRAM_2[0]/A_RWL<13> RM_IHPSG13_1P_BITKIT_16x2_SRAM_3[3]/A_RWL<10>
+ RM_IHPSG13_1P_BITKIT_16x2_SRAM_1[1]/A_RWL<14> RM_IHPSG13_1P_BITKIT_16x2_SRAM_0[2]/A_RWL<5>
+ RM_IHPSG13_1P_BITKIT_16x2_SRAM_0[0]/A_RWL<10> RM_IHPSG13_1P_BITKIT_16x2_SRAM_2[3]/A_RWL<9>
+ RM_IHPSG13_1P_BITKIT_16x2_SRAM_3[1]/A_LWL<6> RM_IHPSG13_1P_BITKIT_16x2_SRAM_2[0]/A_LWL<9>
+ RM_IHPSG13_1P_BITKIT_16x2_SRAM_2[3]/A_RWL<15> RM_IHPSG13_1P_BITKIT_16x2_SRAM_1[2]/A_RWL<11>
+ RM_IHPSG13_1P_BITKIT_16x2_SRAM_2[0]/A_LWL<7> RM_IHPSG13_1P_BITKIT_16x2_SRAM_3[3]/A_LWL<8>
+ RM_IHPSG13_1P_BITKIT_16x2_SRAM_2[1]/A_LWL<15> RM_IHPSG13_1P_BITKIT_16x2_SRAM_1[2]/A_LWL<10>
+ RM_IHPSG13_1P_BITKIT_16x2_SRAM_0[1]/A_LWL<9> RM_IHPSG13_1P_BITKIT_16x2_SRAM_1[1]/A_LWL<1>
+ RM_IHPSG13_1P_BITKIT_16x2_SRAM_3[1]/A_LWL<10> RM_IHPSG13_1P_BITKIT_16x2_SRAM_3[0]/A_LWL<1>
+ RM_IHPSG13_1P_BITKIT_16x2_SRAM_0[2]/A_LWL<12> RM_IHPSG13_1P_BITKIT_16x2_SRAM_1[1]/A_RWL<15>
+ RM_IHPSG13_1P_BITKIT_16x2_SRAM_0[2]/A_RWL<6> RM_IHPSG13_1P_BITKIT_16x2_SRAM_0[0]/A_RWL<11>
+ RM_IHPSG13_1P_BITKIT_16x2_SRAM_3[1]/A_LWL<7> RM_IHPSG13_1P_BITKIT_16x2_SRAM_3[1]/A_RWL<7>
+ RM_IHPSG13_1P_BITKIT_16x2_SRAM_1[2]/A_RWL<5> RM_IHPSG13_1P_BITKIT_16x2_SRAM_1[2]/A_LWL<0>
+ RM_IHPSG13_1P_BITKIT_16x2_SRAM_1[2]/A_RWL<12> RM_IHPSG13_1P_BITKIT_16x2_SRAM_2[1]/A_LWL<8>
+ RM_IHPSG13_1P_BITKIT_16x2_SRAM_2[2]/A_RWL<2> RM_IHPSG13_1P_BITKIT_16x2_SRAM_0[2]/A_LWL<1>
+ RM_IHPSG13_1P_BITKIT_16x2_SRAM_0[3]/A_RWL<15> RM_IHPSG13_1P_BITKIT_16x2_SRAM_1[1]/A_LWL<9>
+ RM_IHPSG13_1P_BITKIT_16x2_SRAM_3[2]/A_RWL<4> RM_IHPSG13_1P_BITKIT_16x2_SRAM_3[0]/A_RWL<12>
+ RM_IHPSG13_1P_BITKIT_16x2_SRAM_1[1]/A_LWL<6> RM_IHPSG13_1P_BITKIT_16x2_SRAM_3[3]/A_RWL<8>
+ RM_IHPSG13_1P_BITKIT_16x2_SRAM_2[2]/A_RWL<15> RM_IHPSG13_1P_BITKIT_16x2_SRAM_2[2]/A_RWL<5>
+ RM_IHPSG13_1P_BITKIT_16x2_SRAM_1[2]/A_RWL<6> RM_IHPSG13_1P_BITKIT_16x2_SRAM_3[2]/A_RWL<10>
+ RM_IHPSG13_1P_BITKIT_16x2_SRAM_0[0]/A_LWL<9> RM_IHPSG13_1P_BITKIT_16x2_SRAM_0[0]/A_RWL<12>
+ RM_IHPSG13_1P_BITKIT_16x2_SRAM_0[2]/A_RWL<7> RM_IHPSG13_1P_BITKIT_16x2_SRAM_1[3]/A_LWL<8>
+ RM_IHPSG13_1P_BITKIT_16x2_SRAM_0[3]/A_LWL<10> RM_IHPSG13_1P_BITKIT_16x2_SRAM_1[2]/A_LWL<1>
+ RM_IHPSG13_1P_BITKIT_16x2_SRAM_2[1]/A_LWL<9> RM_IHPSG13_1P_BITKIT_16x2_SRAM_1[2]/A_RWL<13>
+ RM_IHPSG13_1P_BITKIT_16x2_SRAM_0[1]/A_LWL<15> RM_IHPSG13_1P_BITKIT_16x2_SRAM_3[2]/A_LWL<8>
+ RM_IHPSG13_1P_BITKIT_16x2_SRAM_0[2]/A_LWL<2> RM_IHPSG13_1P_BITKIT_16x2_SRAM_2[0]/A_LWL<15>
+ RM_IHPSG13_1P_BITKIT_16x2_SRAM_2[3]/A_LWL<13> RM_IHPSG13_1P_BITKIT_16x2_SRAM_3[2]/A_RWL<5>
+ RM_IHPSG13_1P_BITKIT_16x2_SRAM_1[3]/A_RWL<10> RM_IHPSG13_1P_BITKIT_16x2_SRAM_1[1]/A_LWL<10>
+ RM_IHPSG13_1P_BITKIT_16x2_SRAM_0[0]/A_RWL<9> RM_IHPSG13_1P_BITKIT_16x2_SRAM_1[0]/A_LWL<1>
+ RM_IHPSG13_1P_BITKIT_16x2_SRAM_2[2]/A_RWL<6> RM_IHPSG13_1P_BITKIT_16x2_SRAM_2[2]/A_RWL<4>
+ RM_IHPSG13_1P_BITKIT_16x2_SRAM_2[1]/A_RWL<13> RM_IHPSG13_1P_BITKIT_16x2_SRAM_0[3]/A_LWL<2>
+ RM_IHPSG13_1P_BITKIT_16x2_SRAM_2[3]/A_LWL<0> RM_IHPSG13_1P_BITKIT_16x2_SRAM_3[2]/A_LWL<0>
+ RM_IHPSG13_1P_BITKIT_16x2_SRAM_1[2]/A_RWL<7> RM_IHPSG13_1P_BITKIT_16x2_SRAM_0[2]/A_LWL<14>
+ RM_IHPSG13_1P_BITKIT_16x2_SRAM_1[1]/A_RWL<7> RM_IHPSG13_1P_BITKIT_16x2_SRAM_2[2]/A_LWL<1>
+ RM_IHPSG13_1P_BITKIT_16x2_SRAM_0[0]/A_RWL<13> RM_IHPSG13_1P_BITKIT_16x2_SRAM_2[1]/A_LWL<7>
+ RM_IHPSG13_1P_BITKIT_16x2_SRAM_0[2]/A_RWL<8> RM_IHPSG13_1P_BITKIT_16x2_SRAM_3[0]/A_RWL<7>
+ RM_IHPSG13_1P_BITKIT_16x2_SRAM_3[1]/A_LWL<9> RM_IHPSG13_1P_BITKIT_16x2_SRAM_3[3]/A_LWL<5>
+ RM_IHPSG13_1P_BITKIT_16x2_SRAM_0[2]/A_RWL<2> RM_IHPSG13_1P_BITKIT_16x2_SRAM_1[2]/A_LWL<2>
+ RM_IHPSG13_1P_BITKIT_16x2_SRAM_1[2]/A_RWL<14> RM_IHPSG13_1P_BITKIT_16x2_SRAM_2[1]/A_RWL<2>
+ RM_IHPSG13_1P_BITKIT_16x2_SRAM_0[1]/A_RWL<10> RM_IHPSG13_1P_BITKIT_16x2_SRAM_0[2]/A_LWL<3>
+ RM_IHPSG13_1P_BITKIT_16x2_SRAM_0[2]/A_RWL<15> RM_IHPSG13_1P_BITKIT_16x2_SRAM_3[2]/A_RWL<6>
+ RM_IHPSG13_1P_BITKIT_16x2_SRAM_1[3]/A_RWL<11> RM_IHPSG13_1P_BITKIT_16x2_SRAM_2[1]/A_RWL<15>
+ RM_IHPSG13_1P_BITKIT_16x2_SRAM_2[2]/A_RWL<7> RM_IHPSG13_1P_BITKIT_16x2_SRAM_1[2]/A_RWL<10>
+ RM_IHPSG13_1P_BITKIT_16x2_SRAM_0[3]/A_RWL<0> RM_IHPSG13_1P_BITKIT_16x2_SRAM_1[0]/A_RWL<1>
+ RM_IHPSG13_1P_BITKIT_16x2_SRAM_3[2]/A_LWL<1> RM_IHPSG13_1P_BITKIT_16x2_SRAM_1[2]/A_RWL<8>
+ RM_IHPSG13_1P_BITKIT_16x2_SRAM_0[2]/A_LWL<15> RM_IHPSG13_1P_BITKIT_16x2_SRAM_1[3]/A_RWL<5>
+ RM_IHPSG13_1P_BITKIT_16x2_SRAM_3[1]/A_RWL<10> RM_IHPSG13_1P_BITKIT_16x2_SRAM_0[0]/A_RWL<14>
+ RM_IHPSG13_1P_BITKIT_16x2_SRAM_2[2]/A_LWL<2> RM_IHPSG13_1P_BITKIT_16x2_SRAM_1[2]/A_LWL<8>
+ RM_IHPSG13_1P_BITKIT_16x2_SRAM_1[0]/A_RWL<8> RM_IHPSG13_1P_BITKIT_16x2_SRAM_0[3]/A_LWL<12>
+ RM_IHPSG13_1P_BITKIT_16x2_SRAM_1[2]/A_LWL<3> RM_IHPSG13_1P_BITKIT_16x2_SRAM_3[1]/A_LWL<8>
+ RM_IHPSG13_1P_BITKIT_16x2_SRAM_3[1]/A_RWL<12> RM_IHPSG13_1P_BITKIT_16x2_SRAM_1[3]/A_LWL<3>
+ RM_IHPSG13_1P_BITKIT_16x2_SRAM_1[2]/A_RWL<15> RM_IHPSG13_1P_BITKIT_16x2_SRAM_0[0]/A_LWL<15>
+ RM_IHPSG13_1P_BITKIT_16x2_SRAM_3[0]/A_RWL<9> RM_IHPSG13_1P_BITKIT_16x2_SRAM_0[1]/A_RWL<11>
+ RM_IHPSG13_1P_BITKIT_16x2_SRAM_3[3]/A_LWL<2> RM_IHPSG13_1P_BITKIT_16x2_SRAM_0[2]/A_LWL<4>
+ RM_IHPSG13_1P_BITKIT_16x2_SRAM_2[2]/A_LWL<13> RM_IHPSG13_1P_BITKIT_16x2_SRAM_3[2]/A_RWL<7>
+ RM_IHPSG13_1P_BITKIT_16x2_SRAM_1[3]/A_RWL<12> RM_IHPSG13_1P_BITKIT_16x2_SRAM_0[3]/A_LWL<0>
+ RM_IHPSG13_1P_BITKIT_16x2_SRAM_1[0]/A_LWL<10> RM_IHPSG13_1P_BITKIT_16x2_SRAM_1[3]/A_RWL<0>
+ RM_IHPSG13_1P_BITKIT_16x2_SRAM_2[2]/A_RWL<8> RM_IHPSG13_1P_BITKIT_16x2_SRAM_2[3]/A_LWL<11>
+ RM_IHPSG13_1P_BITKIT_16x2_SRAM_2[2]/A_LWL<0> RM_IHPSG13_1P_BITKIT_16x2_SRAM_0[3]/A_RWL<1>
+ RM_IHPSG13_1P_BITKIT_16x2_SRAM_3[2]/A_LWL<2> RM_IHPSG13_1P_BITKIT_16x2_SRAM_1[2]/A_RWL<9>
+ RM_IHPSG13_1P_BITKIT_16x2_SRAM_1[0]/A_RWL<7> RM_IHPSG13_1P_BITKIT_16x2_SRAM_1[3]/A_LWL<5>
+ RM_IHPSG13_1P_BITKIT_16x2_SRAM_2[2]/A_LWL<3> RM_IHPSG13_1P_BITKIT_16x2_SRAM_0[1]/A_RWL<2>
+ RM_IHPSG13_1P_BITKIT_16x2_SRAM_0[3]/A_LWL<13> RM_IHPSG13_1P_BITKIT_16x2_SRAM_1[2]/A_LWL<4>
+ RM_IHPSG13_1P_BITKIT_16x2_SRAM_2[0]/A_RWL<2> RM_IHPSG13_1P_BITKIT_16x2_SRAM_0[1]/A_RWL<12>
+ RM_IHPSG13_1P_BITKIT_16x2_SRAM_2[0]/A_RWL<0> RM_IHPSG13_1P_BITKIT_16x2_SRAM_3[3]/A_RWL<3>
+ RM_IHPSG13_1P_BITKIT_16x2_SRAM_0[1]/A_RWL<9> RM_IHPSG13_1P_BITKIT_16x2_SRAM_0[2]/A_LWL<5>
+ RM_IHPSG13_1P_BITKIT_16x2_SRAM_2[3]/A_RWL<4> RM_IHPSG13_1P_BITKIT_16x2_SRAM_2[3]/A_RWL<0>
+ RM_IHPSG13_1P_BITKIT_16x2_SRAM_3[2]/A_RWL<8> RM_IHPSG13_1P_BITKIT_16x2_SRAM_2[2]/A_RWL<13>
+ RM_IHPSG13_1P_BITKIT_16x2_SRAM_1[3]/A_RWL<13> RM_IHPSG13_1P_BITKIT_16x2_SRAM_2[0]/A_RWL<15>
+ RM_IHPSG13_1P_BITKIT_16x2_SRAM_1[3]/A_RWL<1> RM_IHPSG13_1P_BITKIT_16x2_SRAM_2[2]/A_RWL<9>
+ RM_IHPSG13_1P_BITKIT_16x2_SRAM_1[1]/A_RWL<10> RM_IHPSG13_1P_BITKIT_16x2_SRAM_2[2]/A_LWL<7>
+ RM_IHPSG13_1P_BITKIT_16x2_SRAM_0[3]/A_RWL<2> RM_IHPSG13_1P_BITKIT_16x2_SRAM_3[2]/A_LWL<3>
+ RM_IHPSG13_1P_BITKIT_16x2_SRAM_3[0]/A_RWL<10> RM_IHPSG13_1P_BITKIT_16x2_SRAM_2[2]/A_LWL<4>
+ RM_IHPSG13_1P_BITKIT_16x2_SRAM_1[1]/A_LWL<8> RM_IHPSG13_1P_BITKIT_16x2_SRAM_0[3]/A_LWL<14>
+ RM_IHPSG13_1P_BITKIT_16x2_SRAM_3[0]/A_LWL<8> RM_IHPSG13_1P_BITKIT_16x2_SRAM_3[3]/A_RWL<0>
+ RM_IHPSG13_1P_BITKIT_16x2_SRAM_0[2]/A_LWL<13> RM_IHPSG13_1P_BITKIT_16x2_SRAM_0[1]/A_RWL<13>
+ RM_IHPSG13_1P_BITKIT_16x2_SRAM_3[0]/A_LWL<10> RM_IHPSG13_1P_BITKIT_16x2_SRAM_2[1]/A_LWL<13>
+ RM_IHPSG13_1P_BITKIT_16x2_SRAM_0[2]/A_LWL<6> RM_IHPSG13_1P_BITKIT_16x2_SRAM_2[3]/A_RWL<1>
+ RM_IHPSG13_1P_BITKIT_16x2_SRAM_3[2]/A_RWL<9> RM_IHPSG13_1P_BITKIT_16x2_SRAM_0[3]/A_LWL<11>
+ RM_IHPSG13_1P_BITKIT_16x2_SRAM_1[3]/A_RWL<14> RM_IHPSG13_1P_BITKIT_16x2_SRAM_0[2]/A_LWL<0>
+ RM_IHPSG13_1P_BITKIT_16x2_SRAM_1[1]/A_RWL<1> RM_IHPSG13_1P_BITKIT_16x2_SRAM_0[2]/A_RWL<10>
+ RM_IHPSG13_1P_BITKIT_16x2_SRAM_1[3]/A_RWL<2> RM_IHPSG13_1P_BITKIT_16x2_SRAM_2[2]/A_LWL<11>
+ RM_IHPSG13_1P_BITKIT_16x2_SRAM_2[1]/A_LWL<0> RM_IHPSG13_1P_BITKIT_16x2_SRAM_0[3]/A_RWL<3>
+ RM_IHPSG13_1P_BITKIT_16x2_SRAM_3[2]/A_LWL<4> RM_IHPSG13_1P_BITKIT_16x2_SRAM_1[1]/A_RWL<8>
+ RM_IHPSG13_1P_BITKIT_16x2_SRAM_1[2]/A_LWL<5> RM_IHPSG13_1P_BITKIT_16x2_SRAM_1[0]/A_LWL<2>
+ RM_IHPSG13_1P_BITKIT_16x2_SRAM_3[2]/A_RWL<12> RM_IHPSG13_1P_BITKIT_16x2_SRAM_2[2]/A_LWL<5>
+ RM_IHPSG13_1P_BITKIT_16x2_SRAM_1[3]/A_LWL<6> RM_IHPSG13_1P_BITKIT_16x2_SRAM_3[1]/A_RWL<9>
+ RM_IHPSG13_1P_BITKIT_16x2_SRAM_3[1]/A_LWL<5> RM_IHPSG13_1P_BITKIT_16x2_SRAM_0[0]/A_RWL<2>
+ RM_IHPSG13_1P_BITKIT_16x2_SRAM_0[3]/A_LWL<15> RM_IHPSG13_1P_BITKIT_16x2_SRAM_1[2]/A_LWL<6>
+ RM_IHPSG13_1P_BITKIT_16x2_SRAM_3[3]/A_RWL<1> RM_IHPSG13_1P_BITKIT_16x2_SRAM_0[1]/A_RWL<14>
+ RM_IHPSG13_1P_BITKIT_16x2_SRAM_3[2]/A_RWL<3> RM_IHPSG13_1P_BITKIT_16x2_SRAM_3[0]/A_LWL<11>
+ RM_IHPSG13_1P_BITKIT_16x2_SRAM_0[2]/A_LWL<7> RM_IHPSG13_1P_BITKIT_16x2_SRAM_0[0]/A_RWL<15>
+ RM_IHPSG13_1P_BITKIT_16x2_SRAM_2[3]/A_RWL<2> RM_IHPSG13_1P_BITKIT_16x2_SRAM_2[3]/A_LWL<14>
+ RM_IHPSG13_1P_BITKIT_16x2_SRAM_1[3]/A_RWL<15> RM_IHPSG13_1P_BITKIT_16x2_SRAM_0[2]/A_RWL<11>
+ RM_IHPSG13_1P_BITKIT_16x2_SRAM_1[3]/A_RWL<3> RM_IHPSG13_1P_BITKIT_16x2_SRAM_1[0]/A_RWL<10>
+ RM_IHPSG13_1P_BITKIT_16x2_SRAM_0[3]/A_RWL<4> RM_IHPSG13_1P_BITKIT_16x2_SRAM_2[3]/A_RWL<11>
+ RM_IHPSG13_1P_BITKIT_16x2_SRAM_3[2]/A_LWL<5> RM_IHPSG13_1P_BITKIT_16x2_SRAM_0[0]/A_RWL<4>
+ RM_IHPSG13_1P_BITKIT_16x2_SRAM_2[2]/A_LWL<6> RM_IHPSG13_1P_BITKIT_16x2_SRAM_1[0]/A_LWL<8>
+ RM_IHPSG13_1P_BITKIT_16x2_SRAM_0[3]/A_RWL<12> RM_IHPSG13_1P_BITKIT_16x2_SRAM_2[1]/A_RWL<0>
+ RM_IHPSG13_1P_BITKIT_16x2_SRAM_3[3]/A_RWL<6> RM_IHPSG13_1P_BITKIT_16x2_SRAM_2[0]/A_RWL<5>
+ RM_IHPSG13_1P_BITKIT_16x2_SRAM_0[2]/A_RWL<9> RM_IHPSG13_1P_BITKIT_16x2_SRAM_1[2]/A_LWL<7>
+ RM_IHPSG13_1P_BITKIT_16x2_SRAM_0[1]/A_LWL<13> RM_IHPSG13_1P_BITKIT_16x2_SRAM_3[3]/A_RWL<2>
+ RM_IHPSG13_1P_BITKIT_16x2_SRAM_2[3]/A_RWL<13> RM_IHPSG13_1P_BITKIT_16x2_SRAM_0[1]/A_RWL<15>
+ RM_IHPSG13_1P_BITKIT_16x2_SRAM_3[0]/A_LWL<12> RM_IHPSG13_1P_BITKIT_16x2_SRAM_0[2]/A_LWL<8>
+ RM_IHPSG13_1P_BITKIT_16x2_SRAM_2[0]/A_LWL<13> RM_IHPSG13_1P_BITKIT_16x2_SRAM_2[3]/A_RWL<3>
+ RM_IHPSG13_1P_BITKIT_16x2_SRAM_0[2]/A_LWL<11> RM_IHPSG13_1P_BITKIT_16x2_SRAM_3[3]/A_LWL<12>
+ RM_IHPSG13_1P_BITKIT_16x2_SRAM_2[0]/A_LWL<3> RM_IHPSG13_1P_BITKIT_16x2_SRAM_0[1]/A_LWL<0>
+ RM_IHPSG13_1P_BITKIT_16x2_SRAM_2[3]/A_LWL<7> RM_IHPSG13_1P_BITKIT_16x2_SRAM_0[2]/A_RWL<12>
+ RM_IHPSG13_1P_BITKIT_16x2_SRAM_1[3]/A_RWL<4> RM_IHPSG13_1P_BITKIT_16x2_SRAM_2[1]/A_LWL<11>
+ RM_IHPSG13_1P_BITKIT_16x2_SRAM_2[0]/A_LWL<0> RM_IHPSG13_1P_BITKIT_16x2_SRAM_3[3]/VSS
+ RM_IHPSG13_1P_BITKIT_16x2_SRAM_0[3]/A_RWL<5> RM_IHPSG13_1P_BITKIT_16x2_SRAM_3[3]/VDD
+ RM_IHPSG13_1P_BITKIT_16x2_SRAM_3[2]/A_LWL<6>
XRM_IHPSG13_1P_BITKIT_16x2_SRAM_0[0] RM_IHPSG13_1P_BITKIT_16x2_SRAM_0[0]/A_BLT_BOT<1>
+ RM_IHPSG13_1P_BITKIT_16x2_SRAM_2[1]/A_BLT_BOT<1> RM_IHPSG13_1P_BITKIT_16x2_SRAM_0[0]/A_BLC_BOT<1>
+ RM_IHPSG13_1P_BITKIT_16x2_SRAM_2[1]/A_BLC_BOT<1> RM_IHPSG13_1P_BITKIT_16x2_SRAM_0[0]/A_BLC_BOT<0>
+ RM_IHPSG13_1P_BITKIT_16x2_SRAM_2[1]/A_BLC_BOT<0> RM_IHPSG13_1P_BITKIT_16x2_SRAM_0[0]/A_BLT_BOT<0>
+ RM_IHPSG13_1P_BITKIT_16x2_SRAM_2[1]/A_BLT_BOT<0> RM_IHPSG13_1P_BITKIT_16x2_SRAM_0[0]/A_LWL<12>
+ RM_IHPSG13_1P_BITKIT_16x2_SRAM_0[0]/A_LWL<10> RM_IHPSG13_1P_BITKIT_16x2_SRAM_0[0]/A_LWL<9>
+ RM_IHPSG13_1P_BITKIT_16x2_SRAM_0[0]/A_LWL<8> RM_IHPSG13_1P_BITKIT_16x2_SRAM_0[0]/A_LWL<6>
+ RM_IHPSG13_1P_BITKIT_16x2_SRAM_0[0]/A_LWL<5> RM_IHPSG13_1P_BITKIT_16x2_SRAM_0[0]/A_LWL<4>
+ RM_IHPSG13_1P_BITKIT_16x2_SRAM_0[0]/A_LWL<3> RM_IHPSG13_1P_BITKIT_16x2_SRAM_0[0]/A_LWL<1>
+ RM_IHPSG13_1P_BITKIT_16x2_SRAM_0[0]/A_RWL<10> RM_IHPSG13_1P_BITKIT_16x2_SRAM_0[0]/A_RWL<12>
+ RM_IHPSG13_1P_BITKIT_16x2_SRAM_0[0]/A_RWL<15> RM_IHPSG13_1P_BITKIT_16x2_SRAM_0[0]/A_RWL<14>
+ RM_IHPSG13_1P_BITKIT_16x2_SRAM_0[0]/A_RWL<0> RM_IHPSG13_1P_BITKIT_16x2_SRAM_0[0]/A_RWL<8>
+ RM_IHPSG13_1P_BITKIT_16x2_SRAM_0[0]/A_RWL<7> RM_IHPSG13_1P_BITKIT_16x2_SRAM_0[0]/A_RWL<5>
+ RM_IHPSG13_1P_BITKIT_16x2_SRAM_0[0]/A_RWL<1> RM_IHPSG13_1P_BITKIT_16x2_SRAM_0[0]/A_RWL<3>
+ RM_IHPSG13_1P_BITKIT_16x2_SRAM_0[0]/A_LWL<2> RM_IHPSG13_1P_BITKIT_16x2_SRAM_0[0]/A_RWL<6>
+ RM_IHPSG13_1P_BITKIT_16x2_SRAM_0[0]/A_LWL<15> RM_IHPSG13_1P_BITKIT_16x2_SRAM_0[0]/A_RWL<9>
+ RM_IHPSG13_1P_BITKIT_16x2_SRAM_0[0]/A_RWL<2> RM_IHPSG13_1P_BITKIT_16x2_SRAM_0[0]/A_LWL<13>
+ RM_IHPSG13_1P_BITKIT_16x2_SRAM_0[0]/A_LWL<0> RM_IHPSG13_1P_BITKIT_16x2_SRAM_0[0]/A_RWL<4>
+ RM_IHPSG13_1P_BITKIT_16x2_SRAM_0[0]/A_LWL<11> RM_IHPSG13_1P_BITKIT_16x2_SRAM_0[0]/A_RWL<13>
+ RM_IHPSG13_1P_BITKIT_16x2_SRAM_0[0]/A_LWL<7> RM_IHPSG13_1P_BITKIT_16x2_SRAM_0[0]/A_LWL<14>
+ RM_IHPSG13_1P_BITKIT_16x2_SRAM_3[3]/VDD RM_IHPSG13_1P_BITKIT_16x2_SRAM_0[0]/A_RWL<11>
+ RM_IHPSG13_1P_BITKIT_16x2_SRAM_3[3]/VSS RM_IHPSG13_1P_BITKIT_16x2_SRAM
XRM_IHPSG13_1P_BITKIT_16x2_SRAM_0[1] RM_IHPSG13_1P_BITKIT_16x2_SRAM_2[1]/A_BLT_BOT<1>
+ RM_IHPSG13_1P_BITKIT_16x2_SRAM_2[2]/A_BLT_BOT<1> RM_IHPSG13_1P_BITKIT_16x2_SRAM_2[1]/A_BLC_BOT<1>
+ RM_IHPSG13_1P_BITKIT_16x2_SRAM_2[2]/A_BLC_BOT<1> RM_IHPSG13_1P_BITKIT_16x2_SRAM_2[1]/A_BLC_BOT<0>
+ RM_IHPSG13_1P_BITKIT_16x2_SRAM_2[2]/A_BLC_BOT<0> RM_IHPSG13_1P_BITKIT_16x2_SRAM_2[1]/A_BLT_BOT<0>
+ RM_IHPSG13_1P_BITKIT_16x2_SRAM_2[2]/A_BLT_BOT<0> RM_IHPSG13_1P_BITKIT_16x2_SRAM_0[1]/A_LWL<12>
+ RM_IHPSG13_1P_BITKIT_16x2_SRAM_0[1]/A_LWL<10> RM_IHPSG13_1P_BITKIT_16x2_SRAM_0[1]/A_LWL<9>
+ RM_IHPSG13_1P_BITKIT_16x2_SRAM_0[1]/A_LWL<8> RM_IHPSG13_1P_BITKIT_16x2_SRAM_0[1]/A_LWL<6>
+ RM_IHPSG13_1P_BITKIT_16x2_SRAM_0[1]/A_LWL<5> RM_IHPSG13_1P_BITKIT_16x2_SRAM_0[1]/A_LWL<4>
+ RM_IHPSG13_1P_BITKIT_16x2_SRAM_0[1]/A_LWL<3> RM_IHPSG13_1P_BITKIT_16x2_SRAM_0[1]/A_LWL<1>
+ RM_IHPSG13_1P_BITKIT_16x2_SRAM_0[1]/A_RWL<10> RM_IHPSG13_1P_BITKIT_16x2_SRAM_0[1]/A_RWL<12>
+ RM_IHPSG13_1P_BITKIT_16x2_SRAM_0[1]/A_RWL<15> RM_IHPSG13_1P_BITKIT_16x2_SRAM_0[1]/A_RWL<14>
+ RM_IHPSG13_1P_BITKIT_16x2_SRAM_0[1]/A_RWL<0> RM_IHPSG13_1P_BITKIT_16x2_SRAM_0[1]/A_RWL<8>
+ RM_IHPSG13_1P_BITKIT_16x2_SRAM_0[1]/A_RWL<7> RM_IHPSG13_1P_BITKIT_16x2_SRAM_0[1]/A_RWL<5>
+ RM_IHPSG13_1P_BITKIT_16x2_SRAM_0[1]/A_RWL<1> RM_IHPSG13_1P_BITKIT_16x2_SRAM_0[1]/A_RWL<3>
+ RM_IHPSG13_1P_BITKIT_16x2_SRAM_0[1]/A_LWL<2> RM_IHPSG13_1P_BITKIT_16x2_SRAM_0[1]/A_RWL<6>
+ RM_IHPSG13_1P_BITKIT_16x2_SRAM_0[1]/A_LWL<15> RM_IHPSG13_1P_BITKIT_16x2_SRAM_0[1]/A_RWL<9>
+ RM_IHPSG13_1P_BITKIT_16x2_SRAM_0[1]/A_RWL<2> RM_IHPSG13_1P_BITKIT_16x2_SRAM_0[1]/A_LWL<13>
+ RM_IHPSG13_1P_BITKIT_16x2_SRAM_0[1]/A_LWL<0> RM_IHPSG13_1P_BITKIT_16x2_SRAM_0[1]/A_RWL<4>
+ RM_IHPSG13_1P_BITKIT_16x2_SRAM_0[1]/A_LWL<11> RM_IHPSG13_1P_BITKIT_16x2_SRAM_0[1]/A_RWL<13>
+ RM_IHPSG13_1P_BITKIT_16x2_SRAM_0[1]/A_LWL<7> RM_IHPSG13_1P_BITKIT_16x2_SRAM_0[1]/A_LWL<14>
+ RM_IHPSG13_1P_BITKIT_16x2_SRAM_3[3]/VDD RM_IHPSG13_1P_BITKIT_16x2_SRAM_0[1]/A_RWL<11>
+ RM_IHPSG13_1P_BITKIT_16x2_SRAM_3[3]/VSS RM_IHPSG13_1P_BITKIT_16x2_SRAM
XRM_IHPSG13_1P_BITKIT_16x2_SRAM_0[2] RM_IHPSG13_1P_BITKIT_16x2_SRAM_2[2]/A_BLT_BOT<1>
+ RM_IHPSG13_1P_BITKIT_16x2_SRAM_2[3]/A_BLT_BOT<1> RM_IHPSG13_1P_BITKIT_16x2_SRAM_2[2]/A_BLC_BOT<1>
+ RM_IHPSG13_1P_BITKIT_16x2_SRAM_2[3]/A_BLC_BOT<1> RM_IHPSG13_1P_BITKIT_16x2_SRAM_2[2]/A_BLC_BOT<0>
+ RM_IHPSG13_1P_BITKIT_16x2_SRAM_2[3]/A_BLC_BOT<0> RM_IHPSG13_1P_BITKIT_16x2_SRAM_2[2]/A_BLT_BOT<0>
+ RM_IHPSG13_1P_BITKIT_16x2_SRAM_2[3]/A_BLT_BOT<0> RM_IHPSG13_1P_BITKIT_16x2_SRAM_0[2]/A_LWL<12>
+ RM_IHPSG13_1P_BITKIT_16x2_SRAM_0[2]/A_LWL<10> RM_IHPSG13_1P_BITKIT_16x2_SRAM_0[2]/A_LWL<9>
+ RM_IHPSG13_1P_BITKIT_16x2_SRAM_0[2]/A_LWL<8> RM_IHPSG13_1P_BITKIT_16x2_SRAM_0[2]/A_LWL<6>
+ RM_IHPSG13_1P_BITKIT_16x2_SRAM_0[2]/A_LWL<5> RM_IHPSG13_1P_BITKIT_16x2_SRAM_0[2]/A_LWL<4>
+ RM_IHPSG13_1P_BITKIT_16x2_SRAM_0[2]/A_LWL<3> RM_IHPSG13_1P_BITKIT_16x2_SRAM_0[2]/A_LWL<1>
+ RM_IHPSG13_1P_BITKIT_16x2_SRAM_0[2]/A_RWL<10> RM_IHPSG13_1P_BITKIT_16x2_SRAM_0[2]/A_RWL<12>
+ RM_IHPSG13_1P_BITKIT_16x2_SRAM_0[2]/A_RWL<15> RM_IHPSG13_1P_BITKIT_16x2_SRAM_0[2]/A_RWL<14>
+ RM_IHPSG13_1P_BITKIT_16x2_SRAM_0[2]/A_RWL<0> RM_IHPSG13_1P_BITKIT_16x2_SRAM_0[2]/A_RWL<8>
+ RM_IHPSG13_1P_BITKIT_16x2_SRAM_0[2]/A_RWL<7> RM_IHPSG13_1P_BITKIT_16x2_SRAM_0[2]/A_RWL<5>
+ RM_IHPSG13_1P_BITKIT_16x2_SRAM_0[2]/A_RWL<1> RM_IHPSG13_1P_BITKIT_16x2_SRAM_0[2]/A_RWL<3>
+ RM_IHPSG13_1P_BITKIT_16x2_SRAM_0[2]/A_LWL<2> RM_IHPSG13_1P_BITKIT_16x2_SRAM_0[2]/A_RWL<6>
+ RM_IHPSG13_1P_BITKIT_16x2_SRAM_0[2]/A_LWL<15> RM_IHPSG13_1P_BITKIT_16x2_SRAM_0[2]/A_RWL<9>
+ RM_IHPSG13_1P_BITKIT_16x2_SRAM_0[2]/A_RWL<2> RM_IHPSG13_1P_BITKIT_16x2_SRAM_0[2]/A_LWL<13>
+ RM_IHPSG13_1P_BITKIT_16x2_SRAM_0[2]/A_LWL<0> RM_IHPSG13_1P_BITKIT_16x2_SRAM_0[2]/A_RWL<4>
+ RM_IHPSG13_1P_BITKIT_16x2_SRAM_0[2]/A_LWL<11> RM_IHPSG13_1P_BITKIT_16x2_SRAM_0[2]/A_RWL<13>
+ RM_IHPSG13_1P_BITKIT_16x2_SRAM_0[2]/A_LWL<7> RM_IHPSG13_1P_BITKIT_16x2_SRAM_0[2]/A_LWL<14>
+ RM_IHPSG13_1P_BITKIT_16x2_SRAM_3[3]/VDD RM_IHPSG13_1P_BITKIT_16x2_SRAM_0[2]/A_RWL<11>
+ RM_IHPSG13_1P_BITKIT_16x2_SRAM_3[3]/VSS RM_IHPSG13_1P_BITKIT_16x2_SRAM
XRM_IHPSG13_1P_BITKIT_16x2_SRAM_0[3] RM_IHPSG13_1P_BITKIT_16x2_SRAM_2[3]/A_BLT_BOT<1>
+ RM_IHPSG13_1P_BITKIT_16x2_SRAM_1[0]/A_BLT_BOT<1> RM_IHPSG13_1P_BITKIT_16x2_SRAM_2[3]/A_BLC_BOT<1>
+ RM_IHPSG13_1P_BITKIT_16x2_SRAM_1[0]/A_BLC_BOT<1> RM_IHPSG13_1P_BITKIT_16x2_SRAM_2[3]/A_BLC_BOT<0>
+ RM_IHPSG13_1P_BITKIT_16x2_SRAM_1[0]/A_BLC_BOT<0> RM_IHPSG13_1P_BITKIT_16x2_SRAM_2[3]/A_BLT_BOT<0>
+ RM_IHPSG13_1P_BITKIT_16x2_SRAM_1[0]/A_BLT_BOT<0> RM_IHPSG13_1P_BITKIT_16x2_SRAM_0[3]/A_LWL<12>
+ RM_IHPSG13_1P_BITKIT_16x2_SRAM_0[3]/A_LWL<10> RM_IHPSG13_1P_BITKIT_16x2_SRAM_0[3]/A_LWL<9>
+ RM_IHPSG13_1P_BITKIT_16x2_SRAM_0[3]/A_LWL<8> RM_IHPSG13_1P_BITKIT_16x2_SRAM_0[3]/A_LWL<6>
+ RM_IHPSG13_1P_BITKIT_16x2_SRAM_0[3]/A_LWL<5> RM_IHPSG13_1P_BITKIT_16x2_SRAM_0[3]/A_LWL<4>
+ RM_IHPSG13_1P_BITKIT_16x2_SRAM_0[3]/A_LWL<3> RM_IHPSG13_1P_BITKIT_16x2_SRAM_0[3]/A_LWL<1>
+ RM_IHPSG13_1P_BITKIT_16x2_SRAM_0[3]/A_RWL<10> RM_IHPSG13_1P_BITKIT_16x2_SRAM_0[3]/A_RWL<12>
+ RM_IHPSG13_1P_BITKIT_16x2_SRAM_0[3]/A_RWL<15> RM_IHPSG13_1P_BITKIT_16x2_SRAM_0[3]/A_RWL<14>
+ RM_IHPSG13_1P_BITKIT_16x2_SRAM_0[3]/A_RWL<0> RM_IHPSG13_1P_BITKIT_16x2_SRAM_0[3]/A_RWL<8>
+ RM_IHPSG13_1P_BITKIT_16x2_SRAM_0[3]/A_RWL<7> RM_IHPSG13_1P_BITKIT_16x2_SRAM_0[3]/A_RWL<5>
+ RM_IHPSG13_1P_BITKIT_16x2_SRAM_0[3]/A_RWL<1> RM_IHPSG13_1P_BITKIT_16x2_SRAM_0[3]/A_RWL<3>
+ RM_IHPSG13_1P_BITKIT_16x2_SRAM_0[3]/A_LWL<2> RM_IHPSG13_1P_BITKIT_16x2_SRAM_0[3]/A_RWL<6>
+ RM_IHPSG13_1P_BITKIT_16x2_SRAM_0[3]/A_LWL<15> RM_IHPSG13_1P_BITKIT_16x2_SRAM_0[3]/A_RWL<9>
+ RM_IHPSG13_1P_BITKIT_16x2_SRAM_0[3]/A_RWL<2> RM_IHPSG13_1P_BITKIT_16x2_SRAM_0[3]/A_LWL<13>
+ RM_IHPSG13_1P_BITKIT_16x2_SRAM_0[3]/A_LWL<0> RM_IHPSG13_1P_BITKIT_16x2_SRAM_0[3]/A_RWL<4>
+ RM_IHPSG13_1P_BITKIT_16x2_SRAM_0[3]/A_LWL<11> RM_IHPSG13_1P_BITKIT_16x2_SRAM_0[3]/A_RWL<13>
+ RM_IHPSG13_1P_BITKIT_16x2_SRAM_0[3]/A_LWL<7> RM_IHPSG13_1P_BITKIT_16x2_SRAM_0[3]/A_LWL<14>
+ RM_IHPSG13_1P_BITKIT_16x2_SRAM_3[3]/VDD RM_IHPSG13_1P_BITKIT_16x2_SRAM_0[3]/A_RWL<11>
+ RM_IHPSG13_1P_BITKIT_16x2_SRAM_3[3]/VSS RM_IHPSG13_1P_BITKIT_16x2_SRAM
XRM_IHPSG13_1P_BITKIT_16x2_SRAM_1[0] RM_IHPSG13_1P_BITKIT_16x2_SRAM_1[0]/A_BLT_BOT<1>
+ RM_IHPSG13_1P_BITKIT_16x2_SRAM_2[1]/A_BLT_BOT<1> RM_IHPSG13_1P_BITKIT_16x2_SRAM_1[0]/A_BLC_BOT<1>
+ RM_IHPSG13_1P_BITKIT_16x2_SRAM_2[1]/A_BLC_BOT<1> RM_IHPSG13_1P_BITKIT_16x2_SRAM_1[0]/A_BLC_BOT<0>
+ RM_IHPSG13_1P_BITKIT_16x2_SRAM_2[1]/A_BLC_BOT<0> RM_IHPSG13_1P_BITKIT_16x2_SRAM_1[0]/A_BLT_BOT<0>
+ RM_IHPSG13_1P_BITKIT_16x2_SRAM_2[1]/A_BLT_BOT<0> RM_IHPSG13_1P_BITKIT_16x2_SRAM_1[0]/A_LWL<12>
+ RM_IHPSG13_1P_BITKIT_16x2_SRAM_1[0]/A_LWL<10> RM_IHPSG13_1P_BITKIT_16x2_SRAM_1[0]/A_LWL<9>
+ RM_IHPSG13_1P_BITKIT_16x2_SRAM_1[0]/A_LWL<8> RM_IHPSG13_1P_BITKIT_16x2_SRAM_1[0]/A_LWL<6>
+ RM_IHPSG13_1P_BITKIT_16x2_SRAM_1[0]/A_LWL<5> RM_IHPSG13_1P_BITKIT_16x2_SRAM_1[0]/A_LWL<4>
+ RM_IHPSG13_1P_BITKIT_16x2_SRAM_1[0]/A_LWL<3> RM_IHPSG13_1P_BITKIT_16x2_SRAM_1[0]/A_LWL<1>
+ RM_IHPSG13_1P_BITKIT_16x2_SRAM_1[0]/A_RWL<10> RM_IHPSG13_1P_BITKIT_16x2_SRAM_1[0]/A_RWL<12>
+ RM_IHPSG13_1P_BITKIT_16x2_SRAM_1[0]/A_RWL<15> RM_IHPSG13_1P_BITKIT_16x2_SRAM_1[0]/A_RWL<14>
+ RM_IHPSG13_1P_BITKIT_16x2_SRAM_1[0]/A_RWL<0> RM_IHPSG13_1P_BITKIT_16x2_SRAM_1[0]/A_RWL<8>
+ RM_IHPSG13_1P_BITKIT_16x2_SRAM_1[0]/A_RWL<7> RM_IHPSG13_1P_BITKIT_16x2_SRAM_1[0]/A_RWL<5>
+ RM_IHPSG13_1P_BITKIT_16x2_SRAM_1[0]/A_RWL<1> RM_IHPSG13_1P_BITKIT_16x2_SRAM_1[0]/A_RWL<3>
+ RM_IHPSG13_1P_BITKIT_16x2_SRAM_1[0]/A_LWL<2> RM_IHPSG13_1P_BITKIT_16x2_SRAM_1[0]/A_RWL<6>
+ RM_IHPSG13_1P_BITKIT_16x2_SRAM_1[0]/A_LWL<15> RM_IHPSG13_1P_BITKIT_16x2_SRAM_1[0]/A_RWL<9>
+ RM_IHPSG13_1P_BITKIT_16x2_SRAM_1[0]/A_RWL<2> RM_IHPSG13_1P_BITKIT_16x2_SRAM_1[0]/A_LWL<13>
+ RM_IHPSG13_1P_BITKIT_16x2_SRAM_1[0]/A_LWL<0> RM_IHPSG13_1P_BITKIT_16x2_SRAM_1[0]/A_RWL<4>
+ RM_IHPSG13_1P_BITKIT_16x2_SRAM_1[0]/A_LWL<11> RM_IHPSG13_1P_BITKIT_16x2_SRAM_1[0]/A_RWL<13>
+ RM_IHPSG13_1P_BITKIT_16x2_SRAM_1[0]/A_LWL<7> RM_IHPSG13_1P_BITKIT_16x2_SRAM_1[0]/A_LWL<14>
+ RM_IHPSG13_1P_BITKIT_16x2_SRAM_3[3]/VDD RM_IHPSG13_1P_BITKIT_16x2_SRAM_1[0]/A_RWL<11>
+ RM_IHPSG13_1P_BITKIT_16x2_SRAM_3[3]/VSS RM_IHPSG13_1P_BITKIT_16x2_SRAM
XRM_IHPSG13_1P_BITKIT_16x2_SRAM_1[1] RM_IHPSG13_1P_BITKIT_16x2_SRAM_2[1]/A_BLT_BOT<1>
+ RM_IHPSG13_1P_BITKIT_16x2_SRAM_2[2]/A_BLT_BOT<1> RM_IHPSG13_1P_BITKIT_16x2_SRAM_2[1]/A_BLC_BOT<1>
+ RM_IHPSG13_1P_BITKIT_16x2_SRAM_2[2]/A_BLC_BOT<1> RM_IHPSG13_1P_BITKIT_16x2_SRAM_2[1]/A_BLC_BOT<0>
+ RM_IHPSG13_1P_BITKIT_16x2_SRAM_2[2]/A_BLC_BOT<0> RM_IHPSG13_1P_BITKIT_16x2_SRAM_2[1]/A_BLT_BOT<0>
+ RM_IHPSG13_1P_BITKIT_16x2_SRAM_2[2]/A_BLT_BOT<0> RM_IHPSG13_1P_BITKIT_16x2_SRAM_1[1]/A_LWL<12>
+ RM_IHPSG13_1P_BITKIT_16x2_SRAM_1[1]/A_LWL<10> RM_IHPSG13_1P_BITKIT_16x2_SRAM_1[1]/A_LWL<9>
+ RM_IHPSG13_1P_BITKIT_16x2_SRAM_1[1]/A_LWL<8> RM_IHPSG13_1P_BITKIT_16x2_SRAM_1[1]/A_LWL<6>
+ RM_IHPSG13_1P_BITKIT_16x2_SRAM_1[1]/A_LWL<5> RM_IHPSG13_1P_BITKIT_16x2_SRAM_1[1]/A_LWL<4>
+ RM_IHPSG13_1P_BITKIT_16x2_SRAM_1[1]/A_LWL<3> RM_IHPSG13_1P_BITKIT_16x2_SRAM_1[1]/A_LWL<1>
+ RM_IHPSG13_1P_BITKIT_16x2_SRAM_1[1]/A_RWL<10> RM_IHPSG13_1P_BITKIT_16x2_SRAM_1[1]/A_RWL<12>
+ RM_IHPSG13_1P_BITKIT_16x2_SRAM_1[1]/A_RWL<15> RM_IHPSG13_1P_BITKIT_16x2_SRAM_1[1]/A_RWL<14>
+ RM_IHPSG13_1P_BITKIT_16x2_SRAM_1[1]/A_RWL<0> RM_IHPSG13_1P_BITKIT_16x2_SRAM_1[1]/A_RWL<8>
+ RM_IHPSG13_1P_BITKIT_16x2_SRAM_1[1]/A_RWL<7> RM_IHPSG13_1P_BITKIT_16x2_SRAM_1[1]/A_RWL<5>
+ RM_IHPSG13_1P_BITKIT_16x2_SRAM_1[1]/A_RWL<1> RM_IHPSG13_1P_BITKIT_16x2_SRAM_1[1]/A_RWL<3>
+ RM_IHPSG13_1P_BITKIT_16x2_SRAM_1[1]/A_LWL<2> RM_IHPSG13_1P_BITKIT_16x2_SRAM_1[1]/A_RWL<6>
+ RM_IHPSG13_1P_BITKIT_16x2_SRAM_1[1]/A_LWL<15> RM_IHPSG13_1P_BITKIT_16x2_SRAM_1[1]/A_RWL<9>
+ RM_IHPSG13_1P_BITKIT_16x2_SRAM_1[1]/A_RWL<2> RM_IHPSG13_1P_BITKIT_16x2_SRAM_1[1]/A_LWL<13>
+ RM_IHPSG13_1P_BITKIT_16x2_SRAM_1[1]/A_LWL<0> RM_IHPSG13_1P_BITKIT_16x2_SRAM_1[1]/A_RWL<4>
+ RM_IHPSG13_1P_BITKIT_16x2_SRAM_1[1]/A_LWL<11> RM_IHPSG13_1P_BITKIT_16x2_SRAM_1[1]/A_RWL<13>
+ RM_IHPSG13_1P_BITKIT_16x2_SRAM_1[1]/A_LWL<7> RM_IHPSG13_1P_BITKIT_16x2_SRAM_1[1]/A_LWL<14>
+ RM_IHPSG13_1P_BITKIT_16x2_SRAM_3[3]/VDD RM_IHPSG13_1P_BITKIT_16x2_SRAM_1[1]/A_RWL<11>
+ RM_IHPSG13_1P_BITKIT_16x2_SRAM_3[3]/VSS RM_IHPSG13_1P_BITKIT_16x2_SRAM
XRM_IHPSG13_1P_BITKIT_16x2_SRAM_1[2] RM_IHPSG13_1P_BITKIT_16x2_SRAM_2[2]/A_BLT_BOT<1>
+ RM_IHPSG13_1P_BITKIT_16x2_SRAM_2[3]/A_BLT_BOT<1> RM_IHPSG13_1P_BITKIT_16x2_SRAM_2[2]/A_BLC_BOT<1>
+ RM_IHPSG13_1P_BITKIT_16x2_SRAM_2[3]/A_BLC_BOT<1> RM_IHPSG13_1P_BITKIT_16x2_SRAM_2[2]/A_BLC_BOT<0>
+ RM_IHPSG13_1P_BITKIT_16x2_SRAM_2[3]/A_BLC_BOT<0> RM_IHPSG13_1P_BITKIT_16x2_SRAM_2[2]/A_BLT_BOT<0>
+ RM_IHPSG13_1P_BITKIT_16x2_SRAM_2[3]/A_BLT_BOT<0> RM_IHPSG13_1P_BITKIT_16x2_SRAM_1[2]/A_LWL<12>
+ RM_IHPSG13_1P_BITKIT_16x2_SRAM_1[2]/A_LWL<10> RM_IHPSG13_1P_BITKIT_16x2_SRAM_1[2]/A_LWL<9>
+ RM_IHPSG13_1P_BITKIT_16x2_SRAM_1[2]/A_LWL<8> RM_IHPSG13_1P_BITKIT_16x2_SRAM_1[2]/A_LWL<6>
+ RM_IHPSG13_1P_BITKIT_16x2_SRAM_1[2]/A_LWL<5> RM_IHPSG13_1P_BITKIT_16x2_SRAM_1[2]/A_LWL<4>
+ RM_IHPSG13_1P_BITKIT_16x2_SRAM_1[2]/A_LWL<3> RM_IHPSG13_1P_BITKIT_16x2_SRAM_1[2]/A_LWL<1>
+ RM_IHPSG13_1P_BITKIT_16x2_SRAM_1[2]/A_RWL<10> RM_IHPSG13_1P_BITKIT_16x2_SRAM_1[2]/A_RWL<12>
+ RM_IHPSG13_1P_BITKIT_16x2_SRAM_1[2]/A_RWL<15> RM_IHPSG13_1P_BITKIT_16x2_SRAM_1[2]/A_RWL<14>
+ RM_IHPSG13_1P_BITKIT_16x2_SRAM_1[2]/A_RWL<0> RM_IHPSG13_1P_BITKIT_16x2_SRAM_1[2]/A_RWL<8>
+ RM_IHPSG13_1P_BITKIT_16x2_SRAM_1[2]/A_RWL<7> RM_IHPSG13_1P_BITKIT_16x2_SRAM_1[2]/A_RWL<5>
+ RM_IHPSG13_1P_BITKIT_16x2_SRAM_1[2]/A_RWL<1> RM_IHPSG13_1P_BITKIT_16x2_SRAM_1[2]/A_RWL<3>
+ RM_IHPSG13_1P_BITKIT_16x2_SRAM_1[2]/A_LWL<2> RM_IHPSG13_1P_BITKIT_16x2_SRAM_1[2]/A_RWL<6>
+ RM_IHPSG13_1P_BITKIT_16x2_SRAM_1[2]/A_LWL<15> RM_IHPSG13_1P_BITKIT_16x2_SRAM_1[2]/A_RWL<9>
+ RM_IHPSG13_1P_BITKIT_16x2_SRAM_1[2]/A_RWL<2> RM_IHPSG13_1P_BITKIT_16x2_SRAM_1[2]/A_LWL<13>
+ RM_IHPSG13_1P_BITKIT_16x2_SRAM_1[2]/A_LWL<0> RM_IHPSG13_1P_BITKIT_16x2_SRAM_1[2]/A_RWL<4>
+ RM_IHPSG13_1P_BITKIT_16x2_SRAM_1[2]/A_LWL<11> RM_IHPSG13_1P_BITKIT_16x2_SRAM_1[2]/A_RWL<13>
+ RM_IHPSG13_1P_BITKIT_16x2_SRAM_1[2]/A_LWL<7> RM_IHPSG13_1P_BITKIT_16x2_SRAM_1[2]/A_LWL<14>
+ RM_IHPSG13_1P_BITKIT_16x2_SRAM_3[3]/VDD RM_IHPSG13_1P_BITKIT_16x2_SRAM_1[2]/A_RWL<11>
+ RM_IHPSG13_1P_BITKIT_16x2_SRAM_3[3]/VSS RM_IHPSG13_1P_BITKIT_16x2_SRAM
XRM_IHPSG13_1P_BITKIT_16x2_SRAM_1[3] RM_IHPSG13_1P_BITKIT_16x2_SRAM_2[3]/A_BLT_BOT<1>
+ RM_IHPSG13_1P_BITKIT_16x2_SRAM_2[0]/A_BLT_BOT<1> RM_IHPSG13_1P_BITKIT_16x2_SRAM_2[3]/A_BLC_BOT<1>
+ RM_IHPSG13_1P_BITKIT_16x2_SRAM_2[0]/A_BLC_BOT<1> RM_IHPSG13_1P_BITKIT_16x2_SRAM_2[3]/A_BLC_BOT<0>
+ RM_IHPSG13_1P_BITKIT_16x2_SRAM_2[0]/A_BLC_BOT<0> RM_IHPSG13_1P_BITKIT_16x2_SRAM_2[3]/A_BLT_BOT<0>
+ RM_IHPSG13_1P_BITKIT_16x2_SRAM_2[0]/A_BLT_BOT<0> RM_IHPSG13_1P_BITKIT_16x2_SRAM_1[3]/A_LWL<12>
+ RM_IHPSG13_1P_BITKIT_16x2_SRAM_1[3]/A_LWL<10> RM_IHPSG13_1P_BITKIT_16x2_SRAM_1[3]/A_LWL<9>
+ RM_IHPSG13_1P_BITKIT_16x2_SRAM_1[3]/A_LWL<8> RM_IHPSG13_1P_BITKIT_16x2_SRAM_1[3]/A_LWL<6>
+ RM_IHPSG13_1P_BITKIT_16x2_SRAM_1[3]/A_LWL<5> RM_IHPSG13_1P_BITKIT_16x2_SRAM_1[3]/A_LWL<4>
+ RM_IHPSG13_1P_BITKIT_16x2_SRAM_1[3]/A_LWL<3> RM_IHPSG13_1P_BITKIT_16x2_SRAM_1[3]/A_LWL<1>
+ RM_IHPSG13_1P_BITKIT_16x2_SRAM_1[3]/A_RWL<10> RM_IHPSG13_1P_BITKIT_16x2_SRAM_1[3]/A_RWL<12>
+ RM_IHPSG13_1P_BITKIT_16x2_SRAM_1[3]/A_RWL<15> RM_IHPSG13_1P_BITKIT_16x2_SRAM_1[3]/A_RWL<14>
+ RM_IHPSG13_1P_BITKIT_16x2_SRAM_1[3]/A_RWL<0> RM_IHPSG13_1P_BITKIT_16x2_SRAM_1[3]/A_RWL<8>
+ RM_IHPSG13_1P_BITKIT_16x2_SRAM_1[3]/A_RWL<7> RM_IHPSG13_1P_BITKIT_16x2_SRAM_1[3]/A_RWL<5>
+ RM_IHPSG13_1P_BITKIT_16x2_SRAM_1[3]/A_RWL<1> RM_IHPSG13_1P_BITKIT_16x2_SRAM_1[3]/A_RWL<3>
+ RM_IHPSG13_1P_BITKIT_16x2_SRAM_1[3]/A_LWL<2> RM_IHPSG13_1P_BITKIT_16x2_SRAM_1[3]/A_RWL<6>
+ RM_IHPSG13_1P_BITKIT_16x2_SRAM_1[3]/A_LWL<15> RM_IHPSG13_1P_BITKIT_16x2_SRAM_1[3]/A_RWL<9>
+ RM_IHPSG13_1P_BITKIT_16x2_SRAM_1[3]/A_RWL<2> RM_IHPSG13_1P_BITKIT_16x2_SRAM_1[3]/A_LWL<13>
+ RM_IHPSG13_1P_BITKIT_16x2_SRAM_1[3]/A_LWL<0> RM_IHPSG13_1P_BITKIT_16x2_SRAM_1[3]/A_RWL<4>
+ RM_IHPSG13_1P_BITKIT_16x2_SRAM_1[3]/A_LWL<11> RM_IHPSG13_1P_BITKIT_16x2_SRAM_1[3]/A_RWL<13>
+ RM_IHPSG13_1P_BITKIT_16x2_SRAM_1[3]/A_LWL<7> RM_IHPSG13_1P_BITKIT_16x2_SRAM_1[3]/A_LWL<14>
+ RM_IHPSG13_1P_BITKIT_16x2_SRAM_3[3]/VDD RM_IHPSG13_1P_BITKIT_16x2_SRAM_1[3]/A_RWL<11>
+ RM_IHPSG13_1P_BITKIT_16x2_SRAM_3[3]/VSS RM_IHPSG13_1P_BITKIT_16x2_SRAM
XRM_IHPSG13_1P_BITKIT_16x2_SRAM_2[0] RM_IHPSG13_1P_BITKIT_16x2_SRAM_2[0]/A_BLT_BOT<1>
+ RM_IHPSG13_1P_BITKIT_16x2_SRAM_2[1]/A_BLT_BOT<1> RM_IHPSG13_1P_BITKIT_16x2_SRAM_2[0]/A_BLC_BOT<1>
+ RM_IHPSG13_1P_BITKIT_16x2_SRAM_2[1]/A_BLC_BOT<1> RM_IHPSG13_1P_BITKIT_16x2_SRAM_2[0]/A_BLC_BOT<0>
+ RM_IHPSG13_1P_BITKIT_16x2_SRAM_2[1]/A_BLC_BOT<0> RM_IHPSG13_1P_BITKIT_16x2_SRAM_2[0]/A_BLT_BOT<0>
+ RM_IHPSG13_1P_BITKIT_16x2_SRAM_2[1]/A_BLT_BOT<0> RM_IHPSG13_1P_BITKIT_16x2_SRAM_2[0]/A_LWL<12>
+ RM_IHPSG13_1P_BITKIT_16x2_SRAM_2[0]/A_LWL<10> RM_IHPSG13_1P_BITKIT_16x2_SRAM_2[0]/A_LWL<9>
+ RM_IHPSG13_1P_BITKIT_16x2_SRAM_2[0]/A_LWL<8> RM_IHPSG13_1P_BITKIT_16x2_SRAM_2[0]/A_LWL<6>
+ RM_IHPSG13_1P_BITKIT_16x2_SRAM_2[0]/A_LWL<5> RM_IHPSG13_1P_BITKIT_16x2_SRAM_2[0]/A_LWL<4>
+ RM_IHPSG13_1P_BITKIT_16x2_SRAM_2[0]/A_LWL<3> RM_IHPSG13_1P_BITKIT_16x2_SRAM_2[0]/A_LWL<1>
+ RM_IHPSG13_1P_BITKIT_16x2_SRAM_2[0]/A_RWL<10> RM_IHPSG13_1P_BITKIT_16x2_SRAM_2[0]/A_RWL<12>
+ RM_IHPSG13_1P_BITKIT_16x2_SRAM_2[0]/A_RWL<15> RM_IHPSG13_1P_BITKIT_16x2_SRAM_2[0]/A_RWL<14>
+ RM_IHPSG13_1P_BITKIT_16x2_SRAM_2[0]/A_RWL<0> RM_IHPSG13_1P_BITKIT_16x2_SRAM_2[0]/A_RWL<8>
+ RM_IHPSG13_1P_BITKIT_16x2_SRAM_2[0]/A_RWL<7> RM_IHPSG13_1P_BITKIT_16x2_SRAM_2[0]/A_RWL<5>
+ RM_IHPSG13_1P_BITKIT_16x2_SRAM_2[0]/A_RWL<1> RM_IHPSG13_1P_BITKIT_16x2_SRAM_2[0]/A_RWL<3>
+ RM_IHPSG13_1P_BITKIT_16x2_SRAM_2[0]/A_LWL<2> RM_IHPSG13_1P_BITKIT_16x2_SRAM_2[0]/A_RWL<6>
+ RM_IHPSG13_1P_BITKIT_16x2_SRAM_2[0]/A_LWL<15> RM_IHPSG13_1P_BITKIT_16x2_SRAM_2[0]/A_RWL<9>
+ RM_IHPSG13_1P_BITKIT_16x2_SRAM_2[0]/A_RWL<2> RM_IHPSG13_1P_BITKIT_16x2_SRAM_2[0]/A_LWL<13>
+ RM_IHPSG13_1P_BITKIT_16x2_SRAM_2[0]/A_LWL<0> RM_IHPSG13_1P_BITKIT_16x2_SRAM_2[0]/A_RWL<4>
+ RM_IHPSG13_1P_BITKIT_16x2_SRAM_2[0]/A_LWL<11> RM_IHPSG13_1P_BITKIT_16x2_SRAM_2[0]/A_RWL<13>
+ RM_IHPSG13_1P_BITKIT_16x2_SRAM_2[0]/A_LWL<7> RM_IHPSG13_1P_BITKIT_16x2_SRAM_2[0]/A_LWL<14>
+ RM_IHPSG13_1P_BITKIT_16x2_SRAM_3[3]/VDD RM_IHPSG13_1P_BITKIT_16x2_SRAM_2[0]/A_RWL<11>
+ RM_IHPSG13_1P_BITKIT_16x2_SRAM_3[3]/VSS RM_IHPSG13_1P_BITKIT_16x2_SRAM
XRM_IHPSG13_1P_BITKIT_16x2_SRAM_2[1] RM_IHPSG13_1P_BITKIT_16x2_SRAM_2[1]/A_BLT_BOT<1>
+ RM_IHPSG13_1P_BITKIT_16x2_SRAM_2[2]/A_BLT_BOT<1> RM_IHPSG13_1P_BITKIT_16x2_SRAM_2[1]/A_BLC_BOT<1>
+ RM_IHPSG13_1P_BITKIT_16x2_SRAM_2[2]/A_BLC_BOT<1> RM_IHPSG13_1P_BITKIT_16x2_SRAM_2[1]/A_BLC_BOT<0>
+ RM_IHPSG13_1P_BITKIT_16x2_SRAM_2[2]/A_BLC_BOT<0> RM_IHPSG13_1P_BITKIT_16x2_SRAM_2[1]/A_BLT_BOT<0>
+ RM_IHPSG13_1P_BITKIT_16x2_SRAM_2[2]/A_BLT_BOT<0> RM_IHPSG13_1P_BITKIT_16x2_SRAM_2[1]/A_LWL<12>
+ RM_IHPSG13_1P_BITKIT_16x2_SRAM_2[1]/A_LWL<10> RM_IHPSG13_1P_BITKIT_16x2_SRAM_2[1]/A_LWL<9>
+ RM_IHPSG13_1P_BITKIT_16x2_SRAM_2[1]/A_LWL<8> RM_IHPSG13_1P_BITKIT_16x2_SRAM_2[1]/A_LWL<6>
+ RM_IHPSG13_1P_BITKIT_16x2_SRAM_2[1]/A_LWL<5> RM_IHPSG13_1P_BITKIT_16x2_SRAM_2[1]/A_LWL<4>
+ RM_IHPSG13_1P_BITKIT_16x2_SRAM_2[1]/A_LWL<3> RM_IHPSG13_1P_BITKIT_16x2_SRAM_2[1]/A_LWL<1>
+ RM_IHPSG13_1P_BITKIT_16x2_SRAM_2[1]/A_RWL<10> RM_IHPSG13_1P_BITKIT_16x2_SRAM_2[1]/A_RWL<12>
+ RM_IHPSG13_1P_BITKIT_16x2_SRAM_2[1]/A_RWL<15> RM_IHPSG13_1P_BITKIT_16x2_SRAM_2[1]/A_RWL<14>
+ RM_IHPSG13_1P_BITKIT_16x2_SRAM_2[1]/A_RWL<0> RM_IHPSG13_1P_BITKIT_16x2_SRAM_2[1]/A_RWL<8>
+ RM_IHPSG13_1P_BITKIT_16x2_SRAM_2[1]/A_RWL<7> RM_IHPSG13_1P_BITKIT_16x2_SRAM_2[1]/A_RWL<5>
+ RM_IHPSG13_1P_BITKIT_16x2_SRAM_2[1]/A_RWL<1> RM_IHPSG13_1P_BITKIT_16x2_SRAM_2[1]/A_RWL<3>
+ RM_IHPSG13_1P_BITKIT_16x2_SRAM_2[1]/A_LWL<2> RM_IHPSG13_1P_BITKIT_16x2_SRAM_2[1]/A_RWL<6>
+ RM_IHPSG13_1P_BITKIT_16x2_SRAM_2[1]/A_LWL<15> RM_IHPSG13_1P_BITKIT_16x2_SRAM_2[1]/A_RWL<9>
+ RM_IHPSG13_1P_BITKIT_16x2_SRAM_2[1]/A_RWL<2> RM_IHPSG13_1P_BITKIT_16x2_SRAM_2[1]/A_LWL<13>
+ RM_IHPSG13_1P_BITKIT_16x2_SRAM_2[1]/A_LWL<0> RM_IHPSG13_1P_BITKIT_16x2_SRAM_2[1]/A_RWL<4>
+ RM_IHPSG13_1P_BITKIT_16x2_SRAM_2[1]/A_LWL<11> RM_IHPSG13_1P_BITKIT_16x2_SRAM_2[1]/A_RWL<13>
+ RM_IHPSG13_1P_BITKIT_16x2_SRAM_2[1]/A_LWL<7> RM_IHPSG13_1P_BITKIT_16x2_SRAM_2[1]/A_LWL<14>
+ RM_IHPSG13_1P_BITKIT_16x2_SRAM_3[3]/VDD RM_IHPSG13_1P_BITKIT_16x2_SRAM_2[1]/A_RWL<11>
+ RM_IHPSG13_1P_BITKIT_16x2_SRAM_3[3]/VSS RM_IHPSG13_1P_BITKIT_16x2_SRAM
XRM_IHPSG13_1P_BITKIT_16x2_SRAM_2[2] RM_IHPSG13_1P_BITKIT_16x2_SRAM_2[2]/A_BLT_BOT<1>
+ RM_IHPSG13_1P_BITKIT_16x2_SRAM_2[3]/A_BLT_BOT<1> RM_IHPSG13_1P_BITKIT_16x2_SRAM_2[2]/A_BLC_BOT<1>
+ RM_IHPSG13_1P_BITKIT_16x2_SRAM_2[3]/A_BLC_BOT<1> RM_IHPSG13_1P_BITKIT_16x2_SRAM_2[2]/A_BLC_BOT<0>
+ RM_IHPSG13_1P_BITKIT_16x2_SRAM_2[3]/A_BLC_BOT<0> RM_IHPSG13_1P_BITKIT_16x2_SRAM_2[2]/A_BLT_BOT<0>
+ RM_IHPSG13_1P_BITKIT_16x2_SRAM_2[3]/A_BLT_BOT<0> RM_IHPSG13_1P_BITKIT_16x2_SRAM_2[2]/A_LWL<12>
+ RM_IHPSG13_1P_BITKIT_16x2_SRAM_2[2]/A_LWL<10> RM_IHPSG13_1P_BITKIT_16x2_SRAM_2[2]/A_LWL<9>
+ RM_IHPSG13_1P_BITKIT_16x2_SRAM_2[2]/A_LWL<8> RM_IHPSG13_1P_BITKIT_16x2_SRAM_2[2]/A_LWL<6>
+ RM_IHPSG13_1P_BITKIT_16x2_SRAM_2[2]/A_LWL<5> RM_IHPSG13_1P_BITKIT_16x2_SRAM_2[2]/A_LWL<4>
+ RM_IHPSG13_1P_BITKIT_16x2_SRAM_2[2]/A_LWL<3> RM_IHPSG13_1P_BITKIT_16x2_SRAM_2[2]/A_LWL<1>
+ RM_IHPSG13_1P_BITKIT_16x2_SRAM_2[2]/A_RWL<10> RM_IHPSG13_1P_BITKIT_16x2_SRAM_2[2]/A_RWL<12>
+ RM_IHPSG13_1P_BITKIT_16x2_SRAM_2[2]/A_RWL<15> RM_IHPSG13_1P_BITKIT_16x2_SRAM_2[2]/A_RWL<14>
+ RM_IHPSG13_1P_BITKIT_16x2_SRAM_2[2]/A_RWL<0> RM_IHPSG13_1P_BITKIT_16x2_SRAM_2[2]/A_RWL<8>
+ RM_IHPSG13_1P_BITKIT_16x2_SRAM_2[2]/A_RWL<7> RM_IHPSG13_1P_BITKIT_16x2_SRAM_2[2]/A_RWL<5>
+ RM_IHPSG13_1P_BITKIT_16x2_SRAM_2[2]/A_RWL<1> RM_IHPSG13_1P_BITKIT_16x2_SRAM_2[2]/A_RWL<3>
+ RM_IHPSG13_1P_BITKIT_16x2_SRAM_2[2]/A_LWL<2> RM_IHPSG13_1P_BITKIT_16x2_SRAM_2[2]/A_RWL<6>
+ RM_IHPSG13_1P_BITKIT_16x2_SRAM_2[2]/A_LWL<15> RM_IHPSG13_1P_BITKIT_16x2_SRAM_2[2]/A_RWL<9>
+ RM_IHPSG13_1P_BITKIT_16x2_SRAM_2[2]/A_RWL<2> RM_IHPSG13_1P_BITKIT_16x2_SRAM_2[2]/A_LWL<13>
+ RM_IHPSG13_1P_BITKIT_16x2_SRAM_2[2]/A_LWL<0> RM_IHPSG13_1P_BITKIT_16x2_SRAM_2[2]/A_RWL<4>
+ RM_IHPSG13_1P_BITKIT_16x2_SRAM_2[2]/A_LWL<11> RM_IHPSG13_1P_BITKIT_16x2_SRAM_2[2]/A_RWL<13>
+ RM_IHPSG13_1P_BITKIT_16x2_SRAM_2[2]/A_LWL<7> RM_IHPSG13_1P_BITKIT_16x2_SRAM_2[2]/A_LWL<14>
+ RM_IHPSG13_1P_BITKIT_16x2_SRAM_3[3]/VDD RM_IHPSG13_1P_BITKIT_16x2_SRAM_2[2]/A_RWL<11>
+ RM_IHPSG13_1P_BITKIT_16x2_SRAM_3[3]/VSS RM_IHPSG13_1P_BITKIT_16x2_SRAM
XRM_IHPSG13_1P_BITKIT_16x2_SRAM_2[3] RM_IHPSG13_1P_BITKIT_16x2_SRAM_2[3]/A_BLT_BOT<1>
+ RM_IHPSG13_1P_BITKIT_16x2_SRAM_3[0]/A_BLT_BOT<1> RM_IHPSG13_1P_BITKIT_16x2_SRAM_2[3]/A_BLC_BOT<1>
+ RM_IHPSG13_1P_BITKIT_16x2_SRAM_3[0]/A_BLC_BOT<1> RM_IHPSG13_1P_BITKIT_16x2_SRAM_2[3]/A_BLC_BOT<0>
+ RM_IHPSG13_1P_BITKIT_16x2_SRAM_3[0]/A_BLC_BOT<0> RM_IHPSG13_1P_BITKIT_16x2_SRAM_2[3]/A_BLT_BOT<0>
+ RM_IHPSG13_1P_BITKIT_16x2_SRAM_3[0]/A_BLT_BOT<0> RM_IHPSG13_1P_BITKIT_16x2_SRAM_2[3]/A_LWL<12>
+ RM_IHPSG13_1P_BITKIT_16x2_SRAM_2[3]/A_LWL<10> RM_IHPSG13_1P_BITKIT_16x2_SRAM_2[3]/A_LWL<9>
+ RM_IHPSG13_1P_BITKIT_16x2_SRAM_2[3]/A_LWL<8> RM_IHPSG13_1P_BITKIT_16x2_SRAM_2[3]/A_LWL<6>
+ RM_IHPSG13_1P_BITKIT_16x2_SRAM_2[3]/A_LWL<5> RM_IHPSG13_1P_BITKIT_16x2_SRAM_2[3]/A_LWL<4>
+ RM_IHPSG13_1P_BITKIT_16x2_SRAM_2[3]/A_LWL<3> RM_IHPSG13_1P_BITKIT_16x2_SRAM_2[3]/A_LWL<1>
+ RM_IHPSG13_1P_BITKIT_16x2_SRAM_2[3]/A_RWL<10> RM_IHPSG13_1P_BITKIT_16x2_SRAM_2[3]/A_RWL<12>
+ RM_IHPSG13_1P_BITKIT_16x2_SRAM_2[3]/A_RWL<15> RM_IHPSG13_1P_BITKIT_16x2_SRAM_2[3]/A_RWL<14>
+ RM_IHPSG13_1P_BITKIT_16x2_SRAM_2[3]/A_RWL<0> RM_IHPSG13_1P_BITKIT_16x2_SRAM_2[3]/A_RWL<8>
+ RM_IHPSG13_1P_BITKIT_16x2_SRAM_2[3]/A_RWL<7> RM_IHPSG13_1P_BITKIT_16x2_SRAM_2[3]/A_RWL<5>
+ RM_IHPSG13_1P_BITKIT_16x2_SRAM_2[3]/A_RWL<1> RM_IHPSG13_1P_BITKIT_16x2_SRAM_2[3]/A_RWL<3>
+ RM_IHPSG13_1P_BITKIT_16x2_SRAM_2[3]/A_LWL<2> RM_IHPSG13_1P_BITKIT_16x2_SRAM_2[3]/A_RWL<6>
+ RM_IHPSG13_1P_BITKIT_16x2_SRAM_2[3]/A_LWL<15> RM_IHPSG13_1P_BITKIT_16x2_SRAM_2[3]/A_RWL<9>
+ RM_IHPSG13_1P_BITKIT_16x2_SRAM_2[3]/A_RWL<2> RM_IHPSG13_1P_BITKIT_16x2_SRAM_2[3]/A_LWL<13>
+ RM_IHPSG13_1P_BITKIT_16x2_SRAM_2[3]/A_LWL<0> RM_IHPSG13_1P_BITKIT_16x2_SRAM_2[3]/A_RWL<4>
+ RM_IHPSG13_1P_BITKIT_16x2_SRAM_2[3]/A_LWL<11> RM_IHPSG13_1P_BITKIT_16x2_SRAM_2[3]/A_RWL<13>
+ RM_IHPSG13_1P_BITKIT_16x2_SRAM_2[3]/A_LWL<7> RM_IHPSG13_1P_BITKIT_16x2_SRAM_2[3]/A_LWL<14>
+ RM_IHPSG13_1P_BITKIT_16x2_SRAM_3[3]/VDD RM_IHPSG13_1P_BITKIT_16x2_SRAM_2[3]/A_RWL<11>
+ RM_IHPSG13_1P_BITKIT_16x2_SRAM_3[3]/VSS RM_IHPSG13_1P_BITKIT_16x2_SRAM
XRM_IHPSG13_1P_BITKIT_16x2_SRAM_3[0] RM_IHPSG13_1P_BITKIT_16x2_SRAM_3[0]/A_BLT_BOT<1>
+ RM_IHPSG13_1P_BITKIT_16x2_SRAM_3[0]/A_BLT_TOP<1> RM_IHPSG13_1P_BITKIT_16x2_SRAM_3[0]/A_BLC_BOT<1>
+ RM_IHPSG13_1P_BITKIT_16x2_SRAM_3[0]/A_BLC_TOP<1> RM_IHPSG13_1P_BITKIT_16x2_SRAM_3[0]/A_BLC_BOT<0>
+ RM_IHPSG13_1P_BITKIT_16x2_SRAM_3[0]/A_BLC_TOP<0> RM_IHPSG13_1P_BITKIT_16x2_SRAM_3[0]/A_BLT_BOT<0>
+ RM_IHPSG13_1P_BITKIT_16x2_SRAM_3[0]/A_BLT_TOP<0> RM_IHPSG13_1P_BITKIT_16x2_SRAM_3[0]/A_LWL<12>
+ RM_IHPSG13_1P_BITKIT_16x2_SRAM_3[0]/A_LWL<10> RM_IHPSG13_1P_BITKIT_16x2_SRAM_3[0]/A_LWL<9>
+ RM_IHPSG13_1P_BITKIT_16x2_SRAM_3[0]/A_LWL<8> RM_IHPSG13_1P_BITKIT_16x2_SRAM_3[0]/A_LWL<6>
+ RM_IHPSG13_1P_BITKIT_16x2_SRAM_3[0]/A_LWL<5> RM_IHPSG13_1P_BITKIT_16x2_SRAM_3[0]/A_LWL<4>
+ RM_IHPSG13_1P_BITKIT_16x2_SRAM_3[0]/A_LWL<3> RM_IHPSG13_1P_BITKIT_16x2_SRAM_3[0]/A_LWL<1>
+ RM_IHPSG13_1P_BITKIT_16x2_SRAM_3[0]/A_RWL<10> RM_IHPSG13_1P_BITKIT_16x2_SRAM_3[0]/A_RWL<12>
+ RM_IHPSG13_1P_BITKIT_16x2_SRAM_3[0]/A_RWL<15> RM_IHPSG13_1P_BITKIT_16x2_SRAM_3[0]/A_RWL<14>
+ RM_IHPSG13_1P_BITKIT_16x2_SRAM_3[0]/A_RWL<0> RM_IHPSG13_1P_BITKIT_16x2_SRAM_3[0]/A_RWL<8>
+ RM_IHPSG13_1P_BITKIT_16x2_SRAM_3[0]/A_RWL<7> RM_IHPSG13_1P_BITKIT_16x2_SRAM_3[0]/A_RWL<5>
+ RM_IHPSG13_1P_BITKIT_16x2_SRAM_3[0]/A_RWL<1> RM_IHPSG13_1P_BITKIT_16x2_SRAM_3[0]/A_RWL<3>
+ RM_IHPSG13_1P_BITKIT_16x2_SRAM_3[0]/A_LWL<2> RM_IHPSG13_1P_BITKIT_16x2_SRAM_3[0]/A_RWL<6>
+ RM_IHPSG13_1P_BITKIT_16x2_SRAM_3[0]/A_LWL<15> RM_IHPSG13_1P_BITKIT_16x2_SRAM_3[0]/A_RWL<9>
+ RM_IHPSG13_1P_BITKIT_16x2_SRAM_3[0]/A_RWL<2> RM_IHPSG13_1P_BITKIT_16x2_SRAM_3[0]/A_LWL<13>
+ RM_IHPSG13_1P_BITKIT_16x2_SRAM_3[0]/A_LWL<0> RM_IHPSG13_1P_BITKIT_16x2_SRAM_3[0]/A_RWL<4>
+ RM_IHPSG13_1P_BITKIT_16x2_SRAM_3[0]/A_LWL<11> RM_IHPSG13_1P_BITKIT_16x2_SRAM_3[0]/A_RWL<13>
+ RM_IHPSG13_1P_BITKIT_16x2_SRAM_3[0]/A_LWL<7> RM_IHPSG13_1P_BITKIT_16x2_SRAM_3[0]/A_LWL<14>
+ RM_IHPSG13_1P_BITKIT_16x2_SRAM_3[3]/VDD RM_IHPSG13_1P_BITKIT_16x2_SRAM_3[0]/A_RWL<11>
+ RM_IHPSG13_1P_BITKIT_16x2_SRAM_3[3]/VSS RM_IHPSG13_1P_BITKIT_16x2_SRAM
XRM_IHPSG13_1P_BITKIT_16x2_SRAM_3[1] RM_IHPSG13_1P_BITKIT_16x2_SRAM_3[1]/A_BLT_BOT<1>
+ RM_IHPSG13_1P_BITKIT_16x2_SRAM_3[1]/A_BLT_TOP<1> RM_IHPSG13_1P_BITKIT_16x2_SRAM_3[1]/A_BLC_BOT<1>
+ RM_IHPSG13_1P_BITKIT_16x2_SRAM_3[1]/A_BLC_TOP<1> RM_IHPSG13_1P_BITKIT_16x2_SRAM_3[1]/A_BLC_BOT<0>
+ RM_IHPSG13_1P_BITKIT_16x2_SRAM_3[1]/A_BLC_TOP<0> RM_IHPSG13_1P_BITKIT_16x2_SRAM_3[1]/A_BLT_BOT<0>
+ RM_IHPSG13_1P_BITKIT_16x2_SRAM_3[1]/A_BLT_TOP<0> RM_IHPSG13_1P_BITKIT_16x2_SRAM_3[1]/A_LWL<12>
+ RM_IHPSG13_1P_BITKIT_16x2_SRAM_3[1]/A_LWL<10> RM_IHPSG13_1P_BITKIT_16x2_SRAM_3[1]/A_LWL<9>
+ RM_IHPSG13_1P_BITKIT_16x2_SRAM_3[1]/A_LWL<8> RM_IHPSG13_1P_BITKIT_16x2_SRAM_3[1]/A_LWL<6>
+ RM_IHPSG13_1P_BITKIT_16x2_SRAM_3[1]/A_LWL<5> RM_IHPSG13_1P_BITKIT_16x2_SRAM_3[1]/A_LWL<4>
+ RM_IHPSG13_1P_BITKIT_16x2_SRAM_3[1]/A_LWL<3> RM_IHPSG13_1P_BITKIT_16x2_SRAM_3[1]/A_LWL<1>
+ RM_IHPSG13_1P_BITKIT_16x2_SRAM_3[1]/A_RWL<10> RM_IHPSG13_1P_BITKIT_16x2_SRAM_3[1]/A_RWL<12>
+ RM_IHPSG13_1P_BITKIT_16x2_SRAM_3[1]/A_RWL<15> RM_IHPSG13_1P_BITKIT_16x2_SRAM_3[1]/A_RWL<14>
+ RM_IHPSG13_1P_BITKIT_16x2_SRAM_3[1]/A_RWL<0> RM_IHPSG13_1P_BITKIT_16x2_SRAM_3[1]/A_RWL<8>
+ RM_IHPSG13_1P_BITKIT_16x2_SRAM_3[1]/A_RWL<7> RM_IHPSG13_1P_BITKIT_16x2_SRAM_3[1]/A_RWL<5>
+ RM_IHPSG13_1P_BITKIT_16x2_SRAM_3[1]/A_RWL<1> RM_IHPSG13_1P_BITKIT_16x2_SRAM_3[1]/A_RWL<3>
+ RM_IHPSG13_1P_BITKIT_16x2_SRAM_3[1]/A_LWL<2> RM_IHPSG13_1P_BITKIT_16x2_SRAM_3[1]/A_RWL<6>
+ RM_IHPSG13_1P_BITKIT_16x2_SRAM_3[1]/A_LWL<15> RM_IHPSG13_1P_BITKIT_16x2_SRAM_3[1]/A_RWL<9>
+ RM_IHPSG13_1P_BITKIT_16x2_SRAM_3[1]/A_RWL<2> RM_IHPSG13_1P_BITKIT_16x2_SRAM_3[1]/A_LWL<13>
+ RM_IHPSG13_1P_BITKIT_16x2_SRAM_3[1]/A_LWL<0> RM_IHPSG13_1P_BITKIT_16x2_SRAM_3[1]/A_RWL<4>
+ RM_IHPSG13_1P_BITKIT_16x2_SRAM_3[1]/A_LWL<11> RM_IHPSG13_1P_BITKIT_16x2_SRAM_3[1]/A_RWL<13>
+ RM_IHPSG13_1P_BITKIT_16x2_SRAM_3[1]/A_LWL<7> RM_IHPSG13_1P_BITKIT_16x2_SRAM_3[1]/A_LWL<14>
+ RM_IHPSG13_1P_BITKIT_16x2_SRAM_3[3]/VDD RM_IHPSG13_1P_BITKIT_16x2_SRAM_3[1]/A_RWL<11>
+ RM_IHPSG13_1P_BITKIT_16x2_SRAM_3[3]/VSS RM_IHPSG13_1P_BITKIT_16x2_SRAM
XRM_IHPSG13_1P_BITKIT_16x2_SRAM_3[2] RM_IHPSG13_1P_BITKIT_16x2_SRAM_3[2]/A_BLT_BOT<1>
+ RM_IHPSG13_1P_BITKIT_16x2_SRAM_3[2]/A_BLT_TOP<1> RM_IHPSG13_1P_BITKIT_16x2_SRAM_3[2]/A_BLC_BOT<1>
+ RM_IHPSG13_1P_BITKIT_16x2_SRAM_3[2]/A_BLC_TOP<1> RM_IHPSG13_1P_BITKIT_16x2_SRAM_3[2]/A_BLC_BOT<0>
+ RM_IHPSG13_1P_BITKIT_16x2_SRAM_3[2]/A_BLC_TOP<0> RM_IHPSG13_1P_BITKIT_16x2_SRAM_3[2]/A_BLT_BOT<0>
+ RM_IHPSG13_1P_BITKIT_16x2_SRAM_3[2]/A_BLT_TOP<0> RM_IHPSG13_1P_BITKIT_16x2_SRAM_3[2]/A_LWL<12>
+ RM_IHPSG13_1P_BITKIT_16x2_SRAM_3[2]/A_LWL<10> RM_IHPSG13_1P_BITKIT_16x2_SRAM_3[2]/A_LWL<9>
+ RM_IHPSG13_1P_BITKIT_16x2_SRAM_3[2]/A_LWL<8> RM_IHPSG13_1P_BITKIT_16x2_SRAM_3[2]/A_LWL<6>
+ RM_IHPSG13_1P_BITKIT_16x2_SRAM_3[2]/A_LWL<5> RM_IHPSG13_1P_BITKIT_16x2_SRAM_3[2]/A_LWL<4>
+ RM_IHPSG13_1P_BITKIT_16x2_SRAM_3[2]/A_LWL<3> RM_IHPSG13_1P_BITKIT_16x2_SRAM_3[2]/A_LWL<1>
+ RM_IHPSG13_1P_BITKIT_16x2_SRAM_3[2]/A_RWL<10> RM_IHPSG13_1P_BITKIT_16x2_SRAM_3[2]/A_RWL<12>
+ RM_IHPSG13_1P_BITKIT_16x2_SRAM_3[2]/A_RWL<15> RM_IHPSG13_1P_BITKIT_16x2_SRAM_3[2]/A_RWL<14>
+ RM_IHPSG13_1P_BITKIT_16x2_SRAM_3[2]/A_RWL<0> RM_IHPSG13_1P_BITKIT_16x2_SRAM_3[2]/A_RWL<8>
+ RM_IHPSG13_1P_BITKIT_16x2_SRAM_3[2]/A_RWL<7> RM_IHPSG13_1P_BITKIT_16x2_SRAM_3[2]/A_RWL<5>
+ RM_IHPSG13_1P_BITKIT_16x2_SRAM_3[2]/A_RWL<1> RM_IHPSG13_1P_BITKIT_16x2_SRAM_3[2]/A_RWL<3>
+ RM_IHPSG13_1P_BITKIT_16x2_SRAM_3[2]/A_LWL<2> RM_IHPSG13_1P_BITKIT_16x2_SRAM_3[2]/A_RWL<6>
+ RM_IHPSG13_1P_BITKIT_16x2_SRAM_3[2]/A_LWL<15> RM_IHPSG13_1P_BITKIT_16x2_SRAM_3[2]/A_RWL<9>
+ RM_IHPSG13_1P_BITKIT_16x2_SRAM_3[2]/A_RWL<2> RM_IHPSG13_1P_BITKIT_16x2_SRAM_3[2]/A_LWL<13>
+ RM_IHPSG13_1P_BITKIT_16x2_SRAM_3[2]/A_LWL<0> RM_IHPSG13_1P_BITKIT_16x2_SRAM_3[2]/A_RWL<4>
+ RM_IHPSG13_1P_BITKIT_16x2_SRAM_3[2]/A_LWL<11> RM_IHPSG13_1P_BITKIT_16x2_SRAM_3[2]/A_RWL<13>
+ RM_IHPSG13_1P_BITKIT_16x2_SRAM_3[2]/A_LWL<7> RM_IHPSG13_1P_BITKIT_16x2_SRAM_3[2]/A_LWL<14>
+ RM_IHPSG13_1P_BITKIT_16x2_SRAM_3[3]/VDD RM_IHPSG13_1P_BITKIT_16x2_SRAM_3[2]/A_RWL<11>
+ RM_IHPSG13_1P_BITKIT_16x2_SRAM_3[3]/VSS RM_IHPSG13_1P_BITKIT_16x2_SRAM
XRM_IHPSG13_1P_BITKIT_16x2_SRAM_3[3] RM_IHPSG13_1P_BITKIT_16x2_SRAM_3[3]/A_BLT_BOT<1>
+ RM_IHPSG13_1P_BITKIT_16x2_SRAM_3[3]/A_BLT_TOP<1> RM_IHPSG13_1P_BITKIT_16x2_SRAM_3[3]/A_BLC_BOT<1>
+ RM_IHPSG13_1P_BITKIT_16x2_SRAM_3[3]/A_BLC_TOP<1> RM_IHPSG13_1P_BITKIT_16x2_SRAM_3[3]/A_BLC_BOT<0>
+ RM_IHPSG13_1P_BITKIT_16x2_SRAM_3[3]/A_BLC_TOP<0> RM_IHPSG13_1P_BITKIT_16x2_SRAM_3[3]/A_BLT_BOT<0>
+ RM_IHPSG13_1P_BITKIT_16x2_SRAM_3[3]/A_BLT_TOP<0> RM_IHPSG13_1P_BITKIT_16x2_SRAM_3[3]/A_LWL<12>
+ RM_IHPSG13_1P_BITKIT_16x2_SRAM_3[3]/A_LWL<10> RM_IHPSG13_1P_BITKIT_16x2_SRAM_3[3]/A_LWL<9>
+ RM_IHPSG13_1P_BITKIT_16x2_SRAM_3[3]/A_LWL<8> RM_IHPSG13_1P_BITKIT_16x2_SRAM_3[3]/A_LWL<6>
+ RM_IHPSG13_1P_BITKIT_16x2_SRAM_3[3]/A_LWL<5> RM_IHPSG13_1P_BITKIT_16x2_SRAM_3[3]/A_LWL<4>
+ RM_IHPSG13_1P_BITKIT_16x2_SRAM_3[3]/A_LWL<3> RM_IHPSG13_1P_BITKIT_16x2_SRAM_3[3]/A_LWL<1>
+ RM_IHPSG13_1P_BITKIT_16x2_SRAM_3[3]/A_RWL<10> RM_IHPSG13_1P_BITKIT_16x2_SRAM_3[3]/A_RWL<12>
+ RM_IHPSG13_1P_BITKIT_16x2_SRAM_3[3]/A_RWL<15> RM_IHPSG13_1P_BITKIT_16x2_SRAM_3[3]/A_RWL<14>
+ RM_IHPSG13_1P_BITKIT_16x2_SRAM_3[3]/A_RWL<0> RM_IHPSG13_1P_BITKIT_16x2_SRAM_3[3]/A_RWL<8>
+ RM_IHPSG13_1P_BITKIT_16x2_SRAM_3[3]/A_RWL<7> RM_IHPSG13_1P_BITKIT_16x2_SRAM_3[3]/A_RWL<5>
+ RM_IHPSG13_1P_BITKIT_16x2_SRAM_3[3]/A_RWL<1> RM_IHPSG13_1P_BITKIT_16x2_SRAM_3[3]/A_RWL<3>
+ RM_IHPSG13_1P_BITKIT_16x2_SRAM_3[3]/A_LWL<2> RM_IHPSG13_1P_BITKIT_16x2_SRAM_3[3]/A_RWL<6>
+ RM_IHPSG13_1P_BITKIT_16x2_SRAM_3[3]/A_LWL<15> RM_IHPSG13_1P_BITKIT_16x2_SRAM_3[3]/A_RWL<9>
+ RM_IHPSG13_1P_BITKIT_16x2_SRAM_3[3]/A_RWL<2> RM_IHPSG13_1P_BITKIT_16x2_SRAM_3[3]/A_LWL<13>
+ RM_IHPSG13_1P_BITKIT_16x2_SRAM_3[3]/A_LWL<0> RM_IHPSG13_1P_BITKIT_16x2_SRAM_3[3]/A_RWL<4>
+ RM_IHPSG13_1P_BITKIT_16x2_SRAM_3[3]/A_LWL<11> RM_IHPSG13_1P_BITKIT_16x2_SRAM_3[3]/A_RWL<13>
+ RM_IHPSG13_1P_BITKIT_16x2_SRAM_3[3]/A_LWL<7> RM_IHPSG13_1P_BITKIT_16x2_SRAM_3[3]/A_LWL<14>
+ RM_IHPSG13_1P_BITKIT_16x2_SRAM_3[3]/VDD RM_IHPSG13_1P_BITKIT_16x2_SRAM_3[3]/A_RWL<11>
+ RM_IHPSG13_1P_BITKIT_16x2_SRAM_3[3]/VSS RM_IHPSG13_1P_BITKIT_16x2_SRAM
.ends

.subckt RM_IHPSG13_1P_MATRIX_256x16 RM_IHPSG13_1P_BITKIT_16x2_EDGE_LR_7[1]/LWL<10>
+ RM_IHPSG13_1P_COLUMN_256_0[4]/RM_IHPSG13_1P_BITKIT_16x2_SRAM_0[0]/A_BLT_BOT<0> RM_IHPSG13_1P_BITKIT_16x2_EDGE_LR_5[1]/LWL<7>
+ RM_IHPSG13_1P_COLUMN_256_0[4]/RM_IHPSG13_1P_BITKIT_16x2_SRAM_0[0]/A_BLT_BOT<1> RM_IHPSG13_1P_COLUMN_256_0[4]/RM_IHPSG13_1P_BITKIT_16x2_SRAM_0[0]/A_BLC_BOT<0>
+ RM_IHPSG13_1P_COLUMN_256_0[4]/RM_IHPSG13_1P_BITKIT_16x2_SRAM_0[0]/A_BLC_BOT<1> RM_IHPSG13_1P_BITKIT_16x2_EDGE_LR_5[2]/LWL<0>
+ RM_IHPSG13_1P_BITKIT_16x2_EDGE_LR_4[3]/LWL<2> RM_IHPSG13_1P_BITKIT_16x2_EDGE_LR_7[1]/LWL<12>
+ RM_IHPSG13_1P_BITKIT_16x2_EDGE_LR_5[2]/LWL<10> RM_IHPSG13_1P_COLUMN_256_0[7]/RM_IHPSG13_1P_BITKIT_16x2_SRAM_0[0]/A_BLT_BOT<0>
+ RM_IHPSG13_1P_BITKIT_16x2_EDGE_LR_7[0]/LWL<4> RM_IHPSG13_1P_BITKIT_16x2_EDGE_LR_6[1]/LWL<4>
+ RM_IHPSG13_1P_COLUMN_256_0[7]/RM_IHPSG13_1P_BITKIT_16x2_SRAM_0[0]/A_BLT_BOT<1> RM_IHPSG13_1P_BITKIT_16x2_EDGE_LR_7[0]/LWL<5>
+ RM_IHPSG13_1P_BITKIT_16x2_EDGE_LR_6[1]/LWL<3> RM_IHPSG13_1P_COLUMN_256_0[7]/RM_IHPSG13_1P_BITKIT_16x2_SRAM_0[0]/A_BLC_BOT<0>
+ RM_IHPSG13_1P_BITKIT_16x2_EDGE_LR_5[2]/LWL<13> RM_IHPSG13_1P_BITKIT_16x2_EDGE_LR_6[2]/LWL<10>
+ RM_IHPSG13_1P_BITKIT_16x2_EDGE_LR_4[2]/LWL<10> RM_IHPSG13_1P_COLUMN_256_0[7]/RM_IHPSG13_1P_BITKIT_16x2_SRAM_0[0]/A_BLC_BOT<1>
+ RM_IHPSG13_1P_BITKIT_16x2_EDGE_LR_7[1]/LWL<15> RM_IHPSG13_1P_BITKIT_16x2_EDGE_LR_4[3]/LWL<5>
+ RM_IHPSG13_1P_COLUMN_256_0[2]/RM_IHPSG13_1P_BITKIT_16x2_SRAM_0[0]/A_BLT_BOT<0> RM_IHPSG13_1P_BITKIT_16x2_EDGE_LR_5[2]/LWL<4>
+ RM_IHPSG13_1P_BITKIT_16x2_EDGE_LR_6[2]/LWL<11> RM_IHPSG13_1P_BITKIT_16x2_EDGE_LR_5[2]/LWL<1>
+ RM_IHPSG13_1P_BITKIT_16x2_EDGE_LR_7[3]/LWL<9> RM_IHPSG13_1P_COLUMN_256_0[2]/RM_IHPSG13_1P_BITKIT_16x2_SRAM_0[0]/A_BLT_BOT<1>
+ RM_IHPSG13_1P_COLUMN_256_0[2]/RM_IHPSG13_1P_BITKIT_16x2_SRAM_0[0]/A_BLC_BOT<0> RM_IHPSG13_1P_BITKIT_16x2_EDGE_LR_5[2]/LWL<7>
+ RM_IHPSG13_1P_BITKIT_16x2_EDGE_LR_4[2]/LWL<13> RM_IHPSG13_1P_BITKIT_16x2_EDGE_LR_7[0]/LWL<0>
+ RM_IHPSG13_1P_COLUMN_256_0[2]/RM_IHPSG13_1P_BITKIT_16x2_SRAM_0[0]/A_BLC_BOT<1> RM_IHPSG13_1P_BITKIT_16x2_EDGE_LR_7[2]/LWL<10>
+ RM_IHPSG13_1P_BITKIT_16x2_EDGE_LR_5[1]/LWL<9> RM_IHPSG13_1P_BITKIT_16x2_EDGE_LR_7[1]/LWL<14>
+ RM_IHPSG13_1P_BITKIT_16x2_EDGE_LR_6[1]/LWL<9> RM_IHPSG13_1P_BITKIT_16x2_EDGE_LR_4[3]/LWL<10>
+ RM_IHPSG13_1P_BITKIT_16x2_EDGE_LR_7[2]/LWL<11> RM_IHPSG13_1P_BITKIT_16x2_EDGE_LR_5[3]/LWL<0>
+ RM_IHPSG13_1P_BITKIT_16x2_EDGE_LR_4[3]/LWL<4> RM_IHPSG13_1P_BITKIT_16x2_EDGE_LR_7[0]/LWL<6>
+ RM_IHPSG13_1P_BITKIT_16x2_EDGE_LR_6[2]/LWL<1> RM_IHPSG13_1P_BITKIT_16x2_EDGE_LR_4[0]/LWL<1>
+ RM_IHPSG13_1P_BITKIT_16x2_EDGE_LR_7[2]/LWL<12> RM_IHPSG13_1P_BITKIT_16x2_EDGE_LR_4[2]/LWL<7>
+ RM_IHPSG13_1P_BITKIT_16x2_EDGE_LR_6[1]/LWL<14> RM_IHPSG13_1P_BITKIT_16x2_EDGE_LR_4[3]/LWL<0>
+ RM_IHPSG13_1P_BITKIT_16x2_EDGE_LR_4[3]/LWL<12> RM_IHPSG13_1P_BITKIT_16x2_EDGE_LR_5[3]/LWL<2>
+ RM_IHPSG13_1P_BITKIT_16x2_EDGE_LR_7[1]/LWL<3> RM_IHPSG13_1P_COLUMN_256_0[5]/RM_IHPSG13_1P_BITKIT_16x2_SRAM_0[0]/A_BLT_BOT<0>
+ RM_IHPSG13_1P_BITKIT_16x2_EDGE_LR_5[2]/LWL<11> RM_IHPSG13_1P_BITKIT_16x2_EDGE_LR_6[2]/LWL<3>
+ RM_IHPSG13_1P_BITKIT_16x2_EDGE_LR_6[2]/LWL<14> RM_IHPSG13_1P_BITKIT_16x2_EDGE_LR_5[3]/LWL<1>
+ RM_IHPSG13_1P_BITKIT_16x2_EDGE_LR_7[2]/LWL<14> RM_IHPSG13_1P_BITKIT_16x2_EDGE_LR_4[0]/LWL<3>
+ RM_IHPSG13_1P_BITKIT_16x2_EDGE_LR_7[1]/LWL<4> RM_IHPSG13_1P_COLUMN_256_0[5]/RM_IHPSG13_1P_BITKIT_16x2_SRAM_0[0]/A_BLT_BOT<1>
+ RM_IHPSG13_1P_BITKIT_16x2_EDGE_LR_6[1]/LWL<15> RM_IHPSG13_1P_BITKIT_16x2_EDGE_LR_5[3]/LWL<10>
+ RM_IHPSG13_1P_COLUMN_256_0[5]/RM_IHPSG13_1P_BITKIT_16x2_SRAM_0[0]/A_BLC_BOT<0> RM_IHPSG13_1P_BITKIT_16x2_EDGE_LR_6[2]/LWL<4>
+ RM_IHPSG13_1P_BITKIT_16x2_EDGE_LR_4[0]/LWL<10> RM_IHPSG13_1P_BITKIT_16x2_EDGE_LR_4[0]/LWL<4>
+ RM_IHPSG13_1P_BITKIT_16x2_EDGE_LR_7[2]/LWL<15> RM_IHPSG13_1P_BITKIT_16x2_EDGE_LR_5[3]/LWL<4>
+ RM_IHPSG13_1P_BITKIT_16x2_EDGE_LR_6[1]/LWL<6> RM_IHPSG13_1P_BITKIT_16x2_EDGE_LR_7[1]/LWL<5>
+ RM_IHPSG13_1P_BITKIT_16x2_EDGE_LR_7[0]/LWL<7> RM_IHPSG13_1P_BITKIT_16x2_EDGE_LR_4[3]/LWL<13>
+ RM_IHPSG13_1P_COLUMN_256_0[5]/RM_IHPSG13_1P_BITKIT_16x2_SRAM_0[0]/A_BLC_BOT<1> RM_IHPSG13_1P_BITKIT_16x2_EDGE_LR_7[1]/LWL<0>
+ RM_IHPSG13_1P_BITKIT_16x2_EDGE_LR_4[0]/LWL<11> RM_IHPSG13_1P_BITKIT_16x2_EDGE_LR_5[2]/LWL<14>
+ RM_IHPSG13_1P_COLUMN_256_0[0]/RM_IHPSG13_1P_BITKIT_16x2_SRAM_0[0]/A_BLT_BOT<0> RM_IHPSG13_1P_BITKIT_16x2_EDGE_LR_4[3]/LWL<15>
+ RM_IHPSG13_1P_BITKIT_16x2_EDGE_LR_5[3]/LWL<5> RM_IHPSG13_1P_BITKIT_16x2_EDGE_LR_7[1]/LWL<6>
+ RM_IHPSG13_1P_BITKIT_16x2_EDGE_LR_5[2]/LWL<9> RM_IHPSG13_1P_BITKIT_16x2_EDGE_LR_7[3]/LWL<6>
+ RM_IHPSG13_1P_BITKIT_16x2_EDGE_LR_6[2]/LWL<6> RM_IHPSG13_1P_COLUMN_256_0[0]/RM_IHPSG13_1P_BITKIT_16x2_SRAM_0[0]/A_BLT_BOT<1>
+ RM_IHPSG13_1P_BITKIT_16x2_EDGE_LR_6[1]/LWL<5> RM_IHPSG13_1P_BITKIT_16x2_EDGE_LR_5[1]/LWL<6>
+ RM_IHPSG13_1P_COLUMN_256_0[0]/RM_IHPSG13_1P_BITKIT_16x2_SRAM_0[0]/A_BLC_BOT<0> RM_IHPSG13_1P_BITKIT_16x2_EDGE_LR_5[3]/LWL<13>
+ RM_IHPSG13_1P_BITKIT_16x2_EDGE_LR_6[2]/LWL<12> RM_IHPSG13_1P_BITKIT_16x2_EDGE_LR_6[3]/LWL<10>
+ RM_IHPSG13_1P_BITKIT_16x2_EDGE_LR_4[0]/LWL<6> RM_IHPSG13_1P_BITKIT_16x2_EDGE_LR_4[0]/LWL<7>
+ RM_IHPSG13_1P_BITKIT_16x2_EDGE_LR_4[2]/LWL<14> RM_IHPSG13_1P_BITKIT_16x2_EDGE_LR_5[0]/LWL<10>
+ RM_IHPSG13_1P_BITKIT_16x2_EDGE_LR_5[3]/LWL<7> RM_IHPSG13_1P_BITKIT_16x2_EDGE_LR_7[0]/LWL<1>
+ RM_IHPSG13_1P_BITKIT_16x2_EDGE_LR_4[3]/LWL<7> RM_IHPSG13_1P_COLUMN_256_0[0]/RM_IHPSG13_1P_BITKIT_16x2_SRAM_0[0]/A_BLC_BOT<1>
+ RM_IHPSG13_1P_BITKIT_16x2_EDGE_LR_5[3]/LWL<14> RM_IHPSG13_1P_BITKIT_16x2_EDGE_LR_7[1]/LWL<13>
+ RM_IHPSG13_1P_BITKIT_16x2_EDGE_LR_6[3]/LWL<11> RM_IHPSG13_1P_BITKIT_16x2_EDGE_LR_4[0]/LWL<14>
+ RM_IHPSG13_1P_BITKIT_16x2_EDGE_LR_5[2]/LWL<6> RM_IHPSG13_1P_BITKIT_16x2_EDGE_LR_5[0]/LWL<11>
+ RM_IHPSG13_1P_BITKIT_16x2_EDGE_LR_5[2]/LWL<3> RM_IHPSG13_1P_BITKIT_16x2_EDGE_LR_5[3]/LWL<11>
+ RM_IHPSG13_1P_BITKIT_16x2_EDGE_LR_4[0]/LWL<12> RM_IHPSG13_1P_BITKIT_16x2_EDGE_LR_4[3]/LWL<14>
+ RM_IHPSG13_1P_BITKIT_16x2_EDGE_LR_6[2]/LWL<9> RM_IHPSG13_1P_BITKIT_16x2_EDGE_LR_4[0]/LWL<9>
+ RM_IHPSG13_1P_BITKIT_16x2_EDGE_LR_6[3]/LWL<0> RM_IHPSG13_1P_BITKIT_16x2_EDGE_LR_4[1]/LWL<0>
+ RM_IHPSG13_1P_BITKIT_16x2_EDGE_LR_5[0]/LWL<12> RM_IHPSG13_1P_BITKIT_16x2_EDGE_LR_6[2]/LWL<15>
+ RM_IHPSG13_1P_BITKIT_16x2_EDGE_LR_4[2]/LWL<11> RM_IHPSG13_1P_BITKIT_16x2_EDGE_LR_5[3]/LWL<6>
+ RM_IHPSG13_1P_BITKIT_16x2_EDGE_LR_6[3]/LWL<13> RM_IHPSG13_1P_BITKIT_16x2_EDGE_LR_4[2]/LWL<6>
+ RM_IHPSG13_1P_BITKIT_16x2_EDGE_LR_7[3]/LWL<10> RM_IHPSG13_1P_BITKIT_16x2_EDGE_LR_6[3]/LWL<1>
+ RM_IHPSG13_1P_BITKIT_16x2_EDGE_LR_4[1]/LWL<1> RM_IHPSG13_1P_BITKIT_16x2_EDGE_LR_4[3]/LWL<1>
+ RM_IHPSG13_1P_BITKIT_16x2_EDGE_LR_7[1]/LWL<7> RM_IHPSG13_1P_BITKIT_16x2_EDGE_LR_6[0]/LWL<10>
+ RM_IHPSG13_1P_BITKIT_16x2_EDGE_LR_7[2]/LWL<0> RM_IHPSG13_1P_COLUMN_256_0[3]/RM_IHPSG13_1P_BITKIT_16x2_SRAM_0[0]/A_BLT_BOT<0>
+ RM_IHPSG13_1P_BITKIT_16x2_EDGE_LR_6[3]/LWL<14> RM_IHPSG13_1P_BITKIT_16x2_EDGE_LR_7[3]/LWL<11>
+ RM_IHPSG13_1P_BITKIT_16x2_EDGE_LR_5[0]/LWL<14> RM_IHPSG13_1P_BITKIT_16x2_EDGE_LR_5[3]/LWL<9>
+ RM_IHPSG13_1P_BITKIT_16x2_EDGE_LR_6[0]/LWL<7> RM_IHPSG13_1P_BITKIT_16x2_EDGE_LR_4[0]/LWL<15>
+ RM_IHPSG13_1P_BITKIT_16x2_EDGE_LR_7[2]/LWL<3> RM_IHPSG13_1P_BITKIT_16x2_EDGE_LR_4[3]/LWL<6>
+ RM_IHPSG13_1P_BITKIT_16x2_EDGE_LR_5[0]/LWL<3> RM_IHPSG13_1P_BITKIT_16x2_EDGE_LR_6[1]/LWL<0>
+ RM_IHPSG13_1P_COLUMN_256_0[3]/RM_IHPSG13_1P_BITKIT_16x2_SRAM_0[0]/A_BLT_BOT<1> RM_IHPSG13_1P_BITKIT_16x2_EDGE_LR_7[0]/LWL<8>
+ RM_IHPSG13_1P_COLUMN_256_0[3]/RM_IHPSG13_1P_BITKIT_16x2_SRAM_0[0]/A_BLC_BOT<0> RM_IHPSG13_1P_BITKIT_16x2_EDGE_LR_7[3]/LWL<12>
+ RM_IHPSG13_1P_BITKIT_16x2_EDGE_LR_6[3]/LWL<3> RM_IHPSG13_1P_BITKIT_16x2_EDGE_LR_4[1]/LWL<3>
+ RM_IHPSG13_1P_BITKIT_16x2_EDGE_LR_5[0]/LWL<15> RM_IHPSG13_1P_BITKIT_16x2_EDGE_LR_6[2]/LWL<5>
+ RM_IHPSG13_1P_BITKIT_16x2_EDGE_LR_4[2]/LWL<9> RM_IHPSG13_1P_BITKIT_16x2_EDGE_LR_6[0]/LWL<12>
+ RM_IHPSG13_1P_BITKIT_16x2_EDGE_LR_6[3]/LWL<12> RM_IHPSG13_1P_BITKIT_16x2_EDGE_LR_7[2]/LWL<4>
+ RM_IHPSG13_1P_BITKIT_16x2_EDGE_LR_5[0]/LWL<4> RM_IHPSG13_1P_BITKIT_16x2_EDGE_LR_5[0]/LWL<0>
+ RM_IHPSG13_1P_COLUMN_256_0[3]/RM_IHPSG13_1P_BITKIT_16x2_SRAM_0[0]/A_BLC_BOT<1> RM_IHPSG13_1P_BITKIT_16x2_EDGE_LR_6[3]/LWL<4>
+ RM_IHPSG13_1P_BITKIT_16x2_EDGE_LR_4[1]/LWL<4> RM_IHPSG13_1P_BITKIT_16x2_EDGE_LR_7[1]/LWL<1>
+ RM_IHPSG13_1P_BITKIT_16x2_EDGE_LR_7[1]/LWL<8> RM_IHPSG13_1P_BITKIT_16x2_EDGE_LR_6[0]/LWL<13>
+ RM_IHPSG13_1P_BITKIT_16x2_EDGE_LR_7[2]/LWL<13> RM_IHPSG13_1P_BITKIT_16x2_EDGE_LR_7[2]/LWL<5>
+ RM_IHPSG13_1P_BITKIT_16x2_EDGE_LR_5[2]/LWL<12> RM_IHPSG13_1P_BITKIT_16x2_EDGE_LR_5[0]/LWL<5>
+ RM_IHPSG13_1P_BITKIT_16x2_EDGE_LR_6[0]/LWL<8> RM_IHPSG13_1P_BITKIT_16x2_EDGE_LR_7[3]/LWL<14>
+ RM_IHPSG13_1P_BITKIT_16x2_EDGE_LR_5[3]/LWL<3> RM_IHPSG13_1P_BITKIT_16x2_EDGE_LR_4[0]/LWL<5>
+ RM_IHPSG13_1P_BITKIT_16x2_EDGE_LR_6[0]/LWL<14> RM_IHPSG13_1P_BITKIT_16x2_EDGE_LR_6[1]/LWL<13>
+ RM_IHPSG13_1P_BITKIT_16x2_EDGE_LR_7[2]/LWL<6> RM_IHPSG13_1P_BITKIT_16x2_EDGE_LR_7[0]/LWL<2>
+ RM_IHPSG13_1P_BITKIT_16x2_EDGE_LR_4[1]/LWL<10> RM_IHPSG13_1P_BITKIT_16x2_EDGE_LR_5[0]/LWL<6>
+ RM_IHPSG13_1P_BITKIT_16x2_EDGE_LR_7[0]/LWL<11> RM_IHPSG13_1P_BITKIT_16x2_EDGE_LR_7[3]/LWL<15>
+ RM_IHPSG13_1P_BITKIT_16x2_EDGE_LR_6[3]/LWL<6> RM_IHPSG13_1P_BITKIT_16x2_EDGE_LR_4[1]/LWL<6>
+ RM_IHPSG13_1P_BITKIT_16x2_EDGE_LR_6[1]/LWL<8> RM_IHPSG13_1P_BITKIT_16x2_EDGE_LR_6[0]/LWL<15>
+ RM_IHPSG13_1P_BITKIT_16x2_EDGE_LR_6[3]/LWL<15> RM_IHPSG13_1P_BITKIT_16x2_EDGE_LR_7[0]/LWL<9>
+ RM_IHPSG13_1P_BITKIT_16x2_EDGE_LR_4[3]/LWL<11> RM_IHPSG13_1P_BITKIT_16x2_EDGE_LR_5[0]/LWL<13>
+ RM_IHPSG13_1P_BITKIT_16x2_EDGE_LR_4[1]/LWL<11> RM_IHPSG13_1P_BITKIT_16x2_EDGE_LR_7[0]/LWL<12>
+ RM_IHPSG13_1P_BITKIT_16x2_EDGE_LR_6[3]/LWL<7> RM_IHPSG13_1P_BITKIT_16x2_EDGE_LR_4[1]/LWL<7>
+ RM_IHPSG13_1P_BITKIT_16x2_EDGE_LR_7[1]/LWL<2> RM_IHPSG13_1P_COLUMN_256_0[6]/RM_IHPSG13_1P_BITKIT_16x2_SRAM_0[0]/A_BLT_BOT<0>
+ RM_IHPSG13_1P_BITKIT_16x2_EDGE_LR_7[2]/LWL<7> RM_IHPSG13_1P_BITKIT_16x2_EDGE_LR_5[2]/LWL<15>
+ RM_IHPSG13_1P_BITKIT_16x2_EDGE_LR_7[2]/LWL<8> RM_IHPSG13_1P_BITKIT_16x2_EDGE_LR_7[3]/LWL<8>
+ RM_IHPSG13_1P_BITKIT_16x2_EDGE_LR_4[1]/LWL<12> RM_IHPSG13_1P_BITKIT_16x2_EDGE_LR_5[0]/LWL<8>
+ RM_IHPSG13_1P_BITKIT_16x2_EDGE_LR_7[0]/LWL<13> RM_IHPSG13_1P_BITKIT_16x2_EDGE_LR_6[2]/LWL<8>
+ RM_IHPSG13_1P_COLUMN_256_0[6]/RM_IHPSG13_1P_BITKIT_16x2_SRAM_0[0]/A_BLT_BOT<1> RM_IHPSG13_1P_BITKIT_16x2_EDGE_LR_6[1]/LWL<7>
+ RM_IHPSG13_1P_BITKIT_16x2_EDGE_LR_5[1]/LWL<8> RM_IHPSG13_1P_BITKIT_16x2_EDGE_LR_6[0]/LWL<0>
+ RM_IHPSG13_1P_COLUMN_256_0[6]/RM_IHPSG13_1P_BITKIT_16x2_SRAM_0[0]/A_BLC_BOT<0> RM_IHPSG13_1P_BITKIT_16x2_EDGE_LR_7[2]/LWL<9>
+ RM_IHPSG13_1P_BITKIT_16x2_EDGE_LR_6[2]/LWL<0> RM_IHPSG13_1P_BITKIT_16x2_EDGE_LR_5[0]/LWL<9>
+ RM_IHPSG13_1P_BITKIT_16x2_EDGE_LR_4[1]/LWL<13> RM_IHPSG13_1P_BITKIT_16x2_EDGE_LR_7[0]/LWL<14>
+ RM_IHPSG13_1P_BITKIT_16x2_EDGE_LR_7[3]/LWL<0> RM_IHPSG13_1P_BITKIT_16x2_EDGE_LR_4[0]/LWL<8>
+ RM_IHPSG13_1P_BITKIT_16x2_EDGE_LR_7[2]/LWL<2> RM_IHPSG13_1P_BITKIT_16x2_EDGE_LR_5[1]/LWL<10>
+ RM_IHPSG13_1P_BITKIT_16x2_EDGE_LR_6[3]/LWL<9> RM_IHPSG13_1P_BITKIT_16x2_EDGE_LR_4[1]/LWL<9>
+ RM_IHPSG13_1P_BITKIT_16x2_EDGE_LR_6[1]/LWL<2> RM_IHPSG13_1P_BITKIT_16x2_EDGE_LR_6[3]/LWL<5>
+ RM_IHPSG13_1P_BITKIT_16x2_EDGE_LR_7[0]/LWL<3> RM_IHPSG13_1P_BITKIT_16x2_EDGE_LR_4[2]/LWL<0>
+ RM_IHPSG13_1P_BITKIT_16x2_EDGE_LR_4[3]/LWL<9> RM_IHPSG13_1P_BITKIT_16x2_EDGE_LR_5[0]/LWL<7>
+ RM_IHPSG13_1P_BITKIT_16x2_EDGE_LR_6[0]/LWL<1> RM_IHPSG13_1P_COLUMN_256_0[6]/RM_IHPSG13_1P_BITKIT_16x2_SRAM_0[0]/A_BLC_BOT<1>
+ RM_IHPSG13_1P_BITKIT_16x2_EDGE_LR_7[1]/LWL<11> RM_IHPSG13_1P_BITKIT_16x2_EDGE_LR_6[3]/LWL<8>
+ RM_IHPSG13_1P_BITKIT_16x2_EDGE_LR_4[1]/LWL<14> RM_IHPSG13_1P_BITKIT_16x2_EDGE_LR_5[0]/LWL<2>
+ RM_IHPSG13_1P_BITKIT_16x2_EDGE_LR_5[1]/LWL<0> RM_IHPSG13_1P_BITKIT_16x2_EDGE_LR_7[0]/LWL<15>
+ RM_IHPSG13_1P_BITKIT_16x2_EDGE_LR_7[3]/LWL<1> RM_IHPSG13_1P_BITKIT_16x2_EDGE_LR_5[1]/LWL<1>
+ RM_IHPSG13_1P_BITKIT_16x2_EDGE_LR_5[1]/LWL<11> RM_IHPSG13_1P_BITKIT_16x2_EDGE_LR_5[2]/LWL<8>
+ RM_IHPSG13_1P_COLUMN_256_0[1]/RM_IHPSG13_1P_BITKIT_16x2_SRAM_0[0]/A_BLT_BOT<0> RM_IHPSG13_1P_BITKIT_16x2_EDGE_LR_7[2]/LWL<1>
+ RM_IHPSG13_1P_BITKIT_16x2_EDGE_LR_5[2]/LWL<5> RM_IHPSG13_1P_BITKIT_16x2_EDGE_LR_4[2]/LWL<1>
+ RM_IHPSG13_1P_BITKIT_16x2_EDGE_LR_6[0]/LWL<2> RM_IHPSG13_1P_BITKIT_16x2_EDGE_LR_4[1]/LWL<8>
+ RM_IHPSG13_1P_BITKIT_16x2_EDGE_LR_7[3]/LWL<13> RM_IHPSG13_1P_BITKIT_16x2_EDGE_LR_5[3]/LWL<12>
+ RM_IHPSG13_1P_BITKIT_16x2_EDGE_LR_6[0]/LWL<11> RM_IHPSG13_1P_BITKIT_16x2_EDGE_LR_4[1]/LWL<15>
+ RM_IHPSG13_1P_BITKIT_16x2_EDGE_LR_4[0]/LWL<0> RM_IHPSG13_1P_BITKIT_16x2_EDGE_LR_7[3]/LWL<2>
+ RM_IHPSG13_1P_BITKIT_16x2_EDGE_LR_6[2]/LWL<2> RM_IHPSG13_1P_BITKIT_16x2_EDGE_LR_5[1]/LWL<12>
+ RM_IHPSG13_1P_COLUMN_256_0[1]/RM_IHPSG13_1P_BITKIT_16x2_SRAM_0[0]/A_BLT_BOT<1> RM_IHPSG13_1P_COLUMN_256_0[1]/RM_IHPSG13_1P_BITKIT_16x2_SRAM_0[0]/A_BLC_BOT<0>
+ RM_IHPSG13_1P_BITKIT_16x2_EDGE_LR_6[1]/LWL<1> RM_IHPSG13_1P_BITKIT_16x2_EDGE_LR_5[1]/LWL<2>
+ RM_IHPSG13_1P_BITKIT_16x2_EDGE_LR_4[2]/LWL<2> RM_IHPSG13_1P_BITKIT_16x2_EDGE_LR_4[1]/LWL<5>
+ RM_IHPSG13_1P_BITKIT_16x2_EDGE_LR_6[0]/LWL<3> RM_IHPSG13_1P_BITKIT_16x2_EDGE_LR_6[2]/LWL<13>
+ RM_IHPSG13_1P_BITKIT_16x2_EDGE_LR_4[2]/LWL<12> RM_IHPSG13_1P_BITKIT_16x2_EDGE_LR_5[3]/LWL<8>
+ RM_IHPSG13_1P_BITKIT_16x2_EDGE_LR_4[0]/LWL<2> RM_IHPSG13_1P_BITKIT_16x2_EDGE_LR_7[3]/LWL<3>
+ RM_IHPSG13_1P_BITKIT_16x2_EDGE_LR_5[1]/LWL<3> RM_IHPSG13_1P_BITKIT_16x2_EDGE_LR_4[2]/LWL<8>
+ RM_IHPSG13_1P_BITKIT_16x2_EDGE_LR_6[1]/LWL<10> RM_IHPSG13_1P_COLUMN_256_0[1]/RM_IHPSG13_1P_BITKIT_16x2_SRAM_0[0]/A_BLC_BOT<1>
+ RM_IHPSG13_1P_BITKIT_16x2_EDGE_LR_4[3]/LWL<3> RM_IHPSG13_1P_BITKIT_16x2_EDGE_LR_5[0]/LWL<1>
+ RM_IHPSG13_1P_BITKIT_16x2_EDGE_LR_4[2]/LWL<3> RM_IHPSG13_1P_BITKIT_16x2_EDGE_LR_6[0]/LWL<4>
+ RM_IHPSG13_1P_BITKIT_16x2_EDGE_LR_7[1]/LWL<9> RM_IHPSG13_1P_BITKIT_16x2_EDGE_LR_6[3]/LWL<2>
+ RM_IHPSG13_1P_BITKIT_16x2_EDGE_LR_5[1]/LWL<13> RM_IHPSG13_1P_BITKIT_16x2_EDGE_LR_7[3]/LWL<4>
+ RM_IHPSG13_1P_BITKIT_16x2_EDGE_LR_5[1]/LWL<4> RM_IHPSG13_1P_BITKIT_16x2_EDGE_LR_5[2]/LWL<2>
+ RM_IHPSG13_1P_BITKIT_16x2_EDGE_LR_5[1]/LWL<14> RM_IHPSG13_1P_BITKIT_16x2_EDGE_LR_6[1]/LWL<11>
+ RM_IHPSG13_1P_BITKIT_16x2_EDGE_LR_4[1]/LWL<2> RM_IHPSG13_1P_BITKIT_16x2_EDGE_LR_4[2]/LWL<4>
+ RM_IHPSG13_1P_BITKIT_16x2_EDGE_LR_7[3]/LWL<7> RM_IHPSG13_1P_BITKIT_16x2_EDGE_LR_6[0]/LWL<5>
+ RM_IHPSG13_1P_BITKIT_16x2_EDGE_LR_5[3]/LWL<15> RM_IHPSG13_1P_BITKIT_16x2_EDGE_LR_6[0]/LWL<9>
+ RM_IHPSG13_1P_BITKIT_16x2_EDGE_LR_4[0]/LWL<13> RM_IHPSG13_1P_BITKIT_16x2_EDGE_LR_4[3]/LWL<8>
+ RM_IHPSG13_1P_BITKIT_16x2_EDGE_LR_7[3]/LWL<5> RM_IHPSG13_1P_BITKIT_16x2_EDGE_LR_7[0]/LWL<10>
+ RM_IHPSG13_1P_BITKIT_16x2_EDGE_LR_5[1]/LWL<5> RM_IHPSG13_1P_BITKIT_16x2_EDGE_LR_5[1]/LWL<15>
+ RM_IHPSG13_1P_BITKIT_16x2_EDGE_LR_6[1]/LWL<12> RM_IHPSG13_1P_BITKIT_16x2_EDGE_LR_4[2]/LWL<5>
+ RM_IHPSG13_1P_BITKIT_16x2_EDGE_LR_6[2]/LWL<7> RM_IHPSG13_1P_BITKIT_16x2_EDGE_LR_6[0]/LWL<6>
+ RM_IHPSG13_1P_COLUMN_256_0[7]/RM_IHPSG13_1P_BITKIT_16x2_SRAM_3[3]/VSS RM_IHPSG13_1P_COLUMN_256_0[7]/RM_IHPSG13_1P_BITKIT_16x2_SRAM_3[3]/VDD
+ RM_IHPSG13_1P_BITKIT_16x2_EDGE_LR_4[2]/LWL<15>
XRM_IHPSG13_1P_BITKIT_16x2_EDGE_LR_0[0] RM_IHPSG13_1P_BITKIT_16x2_EDGE_LR_0[0]/LWL<1>
+ RM_IHPSG13_1P_BITKIT_16x2_EDGE_LR_0[0]/LWL<2> RM_IHPSG13_1P_BITKIT_16x2_EDGE_LR_0[0]/LWL<3>
+ RM_IHPSG13_1P_BITKIT_16x2_EDGE_LR_0[0]/LWL<4> RM_IHPSG13_1P_BITKIT_16x2_EDGE_LR_0[0]/LWL<5>
+ RM_IHPSG13_1P_BITKIT_16x2_EDGE_LR_0[0]/LWL<7> RM_IHPSG13_1P_BITKIT_16x2_EDGE_LR_0[0]/LWL<8>
+ RM_IHPSG13_1P_BITKIT_16x2_EDGE_LR_0[0]/LWL<9> RM_IHPSG13_1P_BITKIT_16x2_EDGE_LR_0[0]/LWL<10>
+ RM_IHPSG13_1P_BITKIT_16x2_EDGE_LR_0[0]/LWL<11> RM_IHPSG13_1P_BITKIT_16x2_EDGE_LR_0[0]/LWL<12>
+ RM_IHPSG13_1P_BITKIT_16x2_EDGE_LR_0[0]/LWL<14> RM_IHPSG13_1P_BITKIT_16x2_EDGE_LR_0[0]/LWL<15>
+ RM_IHPSG13_1P_BITKIT_16x2_EDGE_LR_0[0]/LWL<0> RM_IHPSG13_1P_BITKIT_16x2_EDGE_LR_0[0]/LWL<6>
+ RM_IHPSG13_1P_BITKIT_16x2_EDGE_LR_0[0]/LWL<13> RM_IHPSG13_1P_COLUMN_256_0[7]/RM_IHPSG13_1P_BITKIT_16x2_SRAM_3[3]/VSS
+ RM_IHPSG13_1P_COLUMN_256_0[7]/RM_IHPSG13_1P_BITKIT_16x2_SRAM_3[3]/VDD RM_IHPSG13_1P_BITKIT_16x2_EDGE_LR
XRM_IHPSG13_1P_BITKIT_16x2_EDGE_LR_0[1] RM_IHPSG13_1P_BITKIT_16x2_EDGE_LR_0[1]/LWL<1>
+ RM_IHPSG13_1P_BITKIT_16x2_EDGE_LR_0[1]/LWL<2> RM_IHPSG13_1P_BITKIT_16x2_EDGE_LR_0[1]/LWL<3>
+ RM_IHPSG13_1P_BITKIT_16x2_EDGE_LR_0[1]/LWL<4> RM_IHPSG13_1P_BITKIT_16x2_EDGE_LR_0[1]/LWL<5>
+ RM_IHPSG13_1P_BITKIT_16x2_EDGE_LR_0[1]/LWL<7> RM_IHPSG13_1P_BITKIT_16x2_EDGE_LR_0[1]/LWL<8>
+ RM_IHPSG13_1P_BITKIT_16x2_EDGE_LR_0[1]/LWL<9> RM_IHPSG13_1P_BITKIT_16x2_EDGE_LR_0[1]/LWL<10>
+ RM_IHPSG13_1P_BITKIT_16x2_EDGE_LR_0[1]/LWL<11> RM_IHPSG13_1P_BITKIT_16x2_EDGE_LR_0[1]/LWL<12>
+ RM_IHPSG13_1P_BITKIT_16x2_EDGE_LR_0[1]/LWL<14> RM_IHPSG13_1P_BITKIT_16x2_EDGE_LR_0[1]/LWL<15>
+ RM_IHPSG13_1P_BITKIT_16x2_EDGE_LR_0[1]/LWL<0> RM_IHPSG13_1P_BITKIT_16x2_EDGE_LR_0[1]/LWL<6>
+ RM_IHPSG13_1P_BITKIT_16x2_EDGE_LR_0[1]/LWL<13> RM_IHPSG13_1P_COLUMN_256_0[7]/RM_IHPSG13_1P_BITKIT_16x2_SRAM_3[3]/VSS
+ RM_IHPSG13_1P_COLUMN_256_0[7]/RM_IHPSG13_1P_BITKIT_16x2_SRAM_3[3]/VDD RM_IHPSG13_1P_BITKIT_16x2_EDGE_LR
XRM_IHPSG13_1P_BITKIT_16x2_EDGE_LR_0[2] RM_IHPSG13_1P_BITKIT_16x2_EDGE_LR_0[2]/LWL<1>
+ RM_IHPSG13_1P_BITKIT_16x2_EDGE_LR_0[2]/LWL<2> RM_IHPSG13_1P_BITKIT_16x2_EDGE_LR_0[2]/LWL<3>
+ RM_IHPSG13_1P_BITKIT_16x2_EDGE_LR_0[2]/LWL<4> RM_IHPSG13_1P_BITKIT_16x2_EDGE_LR_0[2]/LWL<5>
+ RM_IHPSG13_1P_BITKIT_16x2_EDGE_LR_0[2]/LWL<7> RM_IHPSG13_1P_BITKIT_16x2_EDGE_LR_0[2]/LWL<8>
+ RM_IHPSG13_1P_BITKIT_16x2_EDGE_LR_0[2]/LWL<9> RM_IHPSG13_1P_BITKIT_16x2_EDGE_LR_0[2]/LWL<10>
+ RM_IHPSG13_1P_BITKIT_16x2_EDGE_LR_0[2]/LWL<11> RM_IHPSG13_1P_BITKIT_16x2_EDGE_LR_0[2]/LWL<12>
+ RM_IHPSG13_1P_BITKIT_16x2_EDGE_LR_0[2]/LWL<14> RM_IHPSG13_1P_BITKIT_16x2_EDGE_LR_0[2]/LWL<15>
+ RM_IHPSG13_1P_BITKIT_16x2_EDGE_LR_0[2]/LWL<0> RM_IHPSG13_1P_BITKIT_16x2_EDGE_LR_0[2]/LWL<6>
+ RM_IHPSG13_1P_BITKIT_16x2_EDGE_LR_0[2]/LWL<13> RM_IHPSG13_1P_COLUMN_256_0[7]/RM_IHPSG13_1P_BITKIT_16x2_SRAM_3[3]/VSS
+ RM_IHPSG13_1P_COLUMN_256_0[7]/RM_IHPSG13_1P_BITKIT_16x2_SRAM_3[3]/VDD RM_IHPSG13_1P_BITKIT_16x2_EDGE_LR
XRM_IHPSG13_1P_BITKIT_16x2_EDGE_LR_0[3] RM_IHPSG13_1P_BITKIT_16x2_EDGE_LR_0[3]/LWL<1>
+ RM_IHPSG13_1P_BITKIT_16x2_EDGE_LR_0[3]/LWL<2> RM_IHPSG13_1P_BITKIT_16x2_EDGE_LR_0[3]/LWL<3>
+ RM_IHPSG13_1P_BITKIT_16x2_EDGE_LR_0[3]/LWL<4> RM_IHPSG13_1P_BITKIT_16x2_EDGE_LR_0[3]/LWL<5>
+ RM_IHPSG13_1P_BITKIT_16x2_EDGE_LR_0[3]/LWL<7> RM_IHPSG13_1P_BITKIT_16x2_EDGE_LR_0[3]/LWL<8>
+ RM_IHPSG13_1P_BITKIT_16x2_EDGE_LR_0[3]/LWL<9> RM_IHPSG13_1P_BITKIT_16x2_EDGE_LR_0[3]/LWL<10>
+ RM_IHPSG13_1P_BITKIT_16x2_EDGE_LR_0[3]/LWL<11> RM_IHPSG13_1P_BITKIT_16x2_EDGE_LR_0[3]/LWL<12>
+ RM_IHPSG13_1P_BITKIT_16x2_EDGE_LR_0[3]/LWL<14> RM_IHPSG13_1P_BITKIT_16x2_EDGE_LR_0[3]/LWL<15>
+ RM_IHPSG13_1P_BITKIT_16x2_EDGE_LR_0[3]/LWL<0> RM_IHPSG13_1P_BITKIT_16x2_EDGE_LR_0[3]/LWL<6>
+ RM_IHPSG13_1P_BITKIT_16x2_EDGE_LR_0[3]/LWL<13> RM_IHPSG13_1P_COLUMN_256_0[7]/RM_IHPSG13_1P_BITKIT_16x2_SRAM_3[3]/VSS
+ RM_IHPSG13_1P_COLUMN_256_0[7]/RM_IHPSG13_1P_BITKIT_16x2_SRAM_3[3]/VDD RM_IHPSG13_1P_BITKIT_16x2_EDGE_LR
XRM_IHPSG13_1P_BITKIT_16x2_EDGE_LR_1[0] RM_IHPSG13_1P_BITKIT_16x2_EDGE_LR_1[0]/LWL<1>
+ RM_IHPSG13_1P_BITKIT_16x2_EDGE_LR_1[0]/LWL<2> RM_IHPSG13_1P_BITKIT_16x2_EDGE_LR_1[0]/LWL<3>
+ RM_IHPSG13_1P_BITKIT_16x2_EDGE_LR_1[0]/LWL<4> RM_IHPSG13_1P_BITKIT_16x2_EDGE_LR_1[0]/LWL<5>
+ RM_IHPSG13_1P_BITKIT_16x2_EDGE_LR_1[0]/LWL<7> RM_IHPSG13_1P_BITKIT_16x2_EDGE_LR_1[0]/LWL<8>
+ RM_IHPSG13_1P_BITKIT_16x2_EDGE_LR_1[0]/LWL<9> RM_IHPSG13_1P_BITKIT_16x2_EDGE_LR_1[0]/LWL<10>
+ RM_IHPSG13_1P_BITKIT_16x2_EDGE_LR_1[0]/LWL<11> RM_IHPSG13_1P_BITKIT_16x2_EDGE_LR_1[0]/LWL<12>
+ RM_IHPSG13_1P_BITKIT_16x2_EDGE_LR_1[0]/LWL<14> RM_IHPSG13_1P_BITKIT_16x2_EDGE_LR_1[0]/LWL<15>
+ RM_IHPSG13_1P_BITKIT_16x2_EDGE_LR_1[0]/LWL<0> RM_IHPSG13_1P_BITKIT_16x2_EDGE_LR_1[0]/LWL<6>
+ RM_IHPSG13_1P_BITKIT_16x2_EDGE_LR_1[0]/LWL<13> RM_IHPSG13_1P_COLUMN_256_0[7]/RM_IHPSG13_1P_BITKIT_16x2_SRAM_3[3]/VSS
+ RM_IHPSG13_1P_COLUMN_256_0[7]/RM_IHPSG13_1P_BITKIT_16x2_SRAM_3[3]/VDD RM_IHPSG13_1P_BITKIT_16x2_EDGE_LR
XRM_IHPSG13_1P_BITKIT_16x2_EDGE_LR_1[1] RM_IHPSG13_1P_BITKIT_16x2_EDGE_LR_1[1]/LWL<1>
+ RM_IHPSG13_1P_BITKIT_16x2_EDGE_LR_1[1]/LWL<2> RM_IHPSG13_1P_BITKIT_16x2_EDGE_LR_1[1]/LWL<3>
+ RM_IHPSG13_1P_BITKIT_16x2_EDGE_LR_1[1]/LWL<4> RM_IHPSG13_1P_BITKIT_16x2_EDGE_LR_1[1]/LWL<5>
+ RM_IHPSG13_1P_BITKIT_16x2_EDGE_LR_1[1]/LWL<7> RM_IHPSG13_1P_BITKIT_16x2_EDGE_LR_1[1]/LWL<8>
+ RM_IHPSG13_1P_BITKIT_16x2_EDGE_LR_1[1]/LWL<9> RM_IHPSG13_1P_BITKIT_16x2_EDGE_LR_1[1]/LWL<10>
+ RM_IHPSG13_1P_BITKIT_16x2_EDGE_LR_1[1]/LWL<11> RM_IHPSG13_1P_BITKIT_16x2_EDGE_LR_1[1]/LWL<12>
+ RM_IHPSG13_1P_BITKIT_16x2_EDGE_LR_1[1]/LWL<14> RM_IHPSG13_1P_BITKIT_16x2_EDGE_LR_1[1]/LWL<15>
+ RM_IHPSG13_1P_BITKIT_16x2_EDGE_LR_1[1]/LWL<0> RM_IHPSG13_1P_BITKIT_16x2_EDGE_LR_1[1]/LWL<6>
+ RM_IHPSG13_1P_BITKIT_16x2_EDGE_LR_1[1]/LWL<13> RM_IHPSG13_1P_COLUMN_256_0[7]/RM_IHPSG13_1P_BITKIT_16x2_SRAM_3[3]/VSS
+ RM_IHPSG13_1P_COLUMN_256_0[7]/RM_IHPSG13_1P_BITKIT_16x2_SRAM_3[3]/VDD RM_IHPSG13_1P_BITKIT_16x2_EDGE_LR
XRM_IHPSG13_1P_BITKIT_16x2_EDGE_LR_1[2] RM_IHPSG13_1P_BITKIT_16x2_EDGE_LR_1[2]/LWL<1>
+ RM_IHPSG13_1P_BITKIT_16x2_EDGE_LR_1[2]/LWL<2> RM_IHPSG13_1P_BITKIT_16x2_EDGE_LR_1[2]/LWL<3>
+ RM_IHPSG13_1P_BITKIT_16x2_EDGE_LR_1[2]/LWL<4> RM_IHPSG13_1P_BITKIT_16x2_EDGE_LR_1[2]/LWL<5>
+ RM_IHPSG13_1P_BITKIT_16x2_EDGE_LR_1[2]/LWL<7> RM_IHPSG13_1P_BITKIT_16x2_EDGE_LR_1[2]/LWL<8>
+ RM_IHPSG13_1P_BITKIT_16x2_EDGE_LR_1[2]/LWL<9> RM_IHPSG13_1P_BITKIT_16x2_EDGE_LR_1[2]/LWL<10>
+ RM_IHPSG13_1P_BITKIT_16x2_EDGE_LR_1[2]/LWL<11> RM_IHPSG13_1P_BITKIT_16x2_EDGE_LR_1[2]/LWL<12>
+ RM_IHPSG13_1P_BITKIT_16x2_EDGE_LR_1[2]/LWL<14> RM_IHPSG13_1P_BITKIT_16x2_EDGE_LR_1[2]/LWL<15>
+ RM_IHPSG13_1P_BITKIT_16x2_EDGE_LR_1[2]/LWL<0> RM_IHPSG13_1P_BITKIT_16x2_EDGE_LR_1[2]/LWL<6>
+ RM_IHPSG13_1P_BITKIT_16x2_EDGE_LR_1[2]/LWL<13> RM_IHPSG13_1P_COLUMN_256_0[7]/RM_IHPSG13_1P_BITKIT_16x2_SRAM_3[3]/VSS
+ RM_IHPSG13_1P_COLUMN_256_0[7]/RM_IHPSG13_1P_BITKIT_16x2_SRAM_3[3]/VDD RM_IHPSG13_1P_BITKIT_16x2_EDGE_LR
XRM_IHPSG13_1P_BITKIT_16x2_EDGE_LR_1[3] RM_IHPSG13_1P_BITKIT_16x2_EDGE_LR_1[3]/LWL<1>
+ RM_IHPSG13_1P_BITKIT_16x2_EDGE_LR_1[3]/LWL<2> RM_IHPSG13_1P_BITKIT_16x2_EDGE_LR_1[3]/LWL<3>
+ RM_IHPSG13_1P_BITKIT_16x2_EDGE_LR_1[3]/LWL<4> RM_IHPSG13_1P_BITKIT_16x2_EDGE_LR_1[3]/LWL<5>
+ RM_IHPSG13_1P_BITKIT_16x2_EDGE_LR_1[3]/LWL<7> RM_IHPSG13_1P_BITKIT_16x2_EDGE_LR_1[3]/LWL<8>
+ RM_IHPSG13_1P_BITKIT_16x2_EDGE_LR_1[3]/LWL<9> RM_IHPSG13_1P_BITKIT_16x2_EDGE_LR_1[3]/LWL<10>
+ RM_IHPSG13_1P_BITKIT_16x2_EDGE_LR_1[3]/LWL<11> RM_IHPSG13_1P_BITKIT_16x2_EDGE_LR_1[3]/LWL<12>
+ RM_IHPSG13_1P_BITKIT_16x2_EDGE_LR_1[3]/LWL<14> RM_IHPSG13_1P_BITKIT_16x2_EDGE_LR_1[3]/LWL<15>
+ RM_IHPSG13_1P_BITKIT_16x2_EDGE_LR_1[3]/LWL<0> RM_IHPSG13_1P_BITKIT_16x2_EDGE_LR_1[3]/LWL<6>
+ RM_IHPSG13_1P_BITKIT_16x2_EDGE_LR_1[3]/LWL<13> RM_IHPSG13_1P_COLUMN_256_0[7]/RM_IHPSG13_1P_BITKIT_16x2_SRAM_3[3]/VSS
+ RM_IHPSG13_1P_COLUMN_256_0[7]/RM_IHPSG13_1P_BITKIT_16x2_SRAM_3[3]/VDD RM_IHPSG13_1P_BITKIT_16x2_EDGE_LR
XRM_IHPSG13_1P_BITKIT_16x2_EDGE_LR_2[0] RM_IHPSG13_1P_BITKIT_16x2_EDGE_LR_2[0]/LWL<1>
+ RM_IHPSG13_1P_BITKIT_16x2_EDGE_LR_2[0]/LWL<2> RM_IHPSG13_1P_BITKIT_16x2_EDGE_LR_2[0]/LWL<3>
+ RM_IHPSG13_1P_BITKIT_16x2_EDGE_LR_2[0]/LWL<4> RM_IHPSG13_1P_BITKIT_16x2_EDGE_LR_2[0]/LWL<5>
+ RM_IHPSG13_1P_BITKIT_16x2_EDGE_LR_2[0]/LWL<7> RM_IHPSG13_1P_BITKIT_16x2_EDGE_LR_2[0]/LWL<8>
+ RM_IHPSG13_1P_BITKIT_16x2_EDGE_LR_2[0]/LWL<9> RM_IHPSG13_1P_BITKIT_16x2_EDGE_LR_2[0]/LWL<10>
+ RM_IHPSG13_1P_BITKIT_16x2_EDGE_LR_2[0]/LWL<11> RM_IHPSG13_1P_BITKIT_16x2_EDGE_LR_2[0]/LWL<12>
+ RM_IHPSG13_1P_BITKIT_16x2_EDGE_LR_2[0]/LWL<14> RM_IHPSG13_1P_BITKIT_16x2_EDGE_LR_2[0]/LWL<15>
+ RM_IHPSG13_1P_BITKIT_16x2_EDGE_LR_2[0]/LWL<0> RM_IHPSG13_1P_BITKIT_16x2_EDGE_LR_2[0]/LWL<6>
+ RM_IHPSG13_1P_BITKIT_16x2_EDGE_LR_2[0]/LWL<13> RM_IHPSG13_1P_COLUMN_256_0[7]/RM_IHPSG13_1P_BITKIT_16x2_SRAM_3[3]/VSS
+ RM_IHPSG13_1P_COLUMN_256_0[7]/RM_IHPSG13_1P_BITKIT_16x2_SRAM_3[3]/VDD RM_IHPSG13_1P_BITKIT_16x2_EDGE_LR
XRM_IHPSG13_1P_BITKIT_16x2_EDGE_LR_2[1] RM_IHPSG13_1P_BITKIT_16x2_EDGE_LR_2[1]/LWL<1>
+ RM_IHPSG13_1P_BITKIT_16x2_EDGE_LR_2[1]/LWL<2> RM_IHPSG13_1P_BITKIT_16x2_EDGE_LR_2[1]/LWL<3>
+ RM_IHPSG13_1P_BITKIT_16x2_EDGE_LR_2[1]/LWL<4> RM_IHPSG13_1P_BITKIT_16x2_EDGE_LR_2[1]/LWL<5>
+ RM_IHPSG13_1P_BITKIT_16x2_EDGE_LR_2[1]/LWL<7> RM_IHPSG13_1P_BITKIT_16x2_EDGE_LR_2[1]/LWL<8>
+ RM_IHPSG13_1P_BITKIT_16x2_EDGE_LR_2[1]/LWL<9> RM_IHPSG13_1P_BITKIT_16x2_EDGE_LR_2[1]/LWL<10>
+ RM_IHPSG13_1P_BITKIT_16x2_EDGE_LR_2[1]/LWL<11> RM_IHPSG13_1P_BITKIT_16x2_EDGE_LR_2[1]/LWL<12>
+ RM_IHPSG13_1P_BITKIT_16x2_EDGE_LR_2[1]/LWL<14> RM_IHPSG13_1P_BITKIT_16x2_EDGE_LR_2[1]/LWL<15>
+ RM_IHPSG13_1P_BITKIT_16x2_EDGE_LR_2[1]/LWL<0> RM_IHPSG13_1P_BITKIT_16x2_EDGE_LR_2[1]/LWL<6>
+ RM_IHPSG13_1P_BITKIT_16x2_EDGE_LR_2[1]/LWL<13> RM_IHPSG13_1P_COLUMN_256_0[7]/RM_IHPSG13_1P_BITKIT_16x2_SRAM_3[3]/VSS
+ RM_IHPSG13_1P_COLUMN_256_0[7]/RM_IHPSG13_1P_BITKIT_16x2_SRAM_3[3]/VDD RM_IHPSG13_1P_BITKIT_16x2_EDGE_LR
XRM_IHPSG13_1P_BITKIT_16x2_EDGE_LR_2[2] RM_IHPSG13_1P_BITKIT_16x2_EDGE_LR_2[2]/LWL<1>
+ RM_IHPSG13_1P_BITKIT_16x2_EDGE_LR_2[2]/LWL<2> RM_IHPSG13_1P_BITKIT_16x2_EDGE_LR_2[2]/LWL<3>
+ RM_IHPSG13_1P_BITKIT_16x2_EDGE_LR_2[2]/LWL<4> RM_IHPSG13_1P_BITKIT_16x2_EDGE_LR_2[2]/LWL<5>
+ RM_IHPSG13_1P_BITKIT_16x2_EDGE_LR_2[2]/LWL<7> RM_IHPSG13_1P_BITKIT_16x2_EDGE_LR_2[2]/LWL<8>
+ RM_IHPSG13_1P_BITKIT_16x2_EDGE_LR_2[2]/LWL<9> RM_IHPSG13_1P_BITKIT_16x2_EDGE_LR_2[2]/LWL<10>
+ RM_IHPSG13_1P_BITKIT_16x2_EDGE_LR_2[2]/LWL<11> RM_IHPSG13_1P_BITKIT_16x2_EDGE_LR_2[2]/LWL<12>
+ RM_IHPSG13_1P_BITKIT_16x2_EDGE_LR_2[2]/LWL<14> RM_IHPSG13_1P_BITKIT_16x2_EDGE_LR_2[2]/LWL<15>
+ RM_IHPSG13_1P_BITKIT_16x2_EDGE_LR_2[2]/LWL<0> RM_IHPSG13_1P_BITKIT_16x2_EDGE_LR_2[2]/LWL<6>
+ RM_IHPSG13_1P_BITKIT_16x2_EDGE_LR_2[2]/LWL<13> RM_IHPSG13_1P_COLUMN_256_0[7]/RM_IHPSG13_1P_BITKIT_16x2_SRAM_3[3]/VSS
+ RM_IHPSG13_1P_COLUMN_256_0[7]/RM_IHPSG13_1P_BITKIT_16x2_SRAM_3[3]/VDD RM_IHPSG13_1P_BITKIT_16x2_EDGE_LR
XRM_IHPSG13_1P_BITKIT_16x2_EDGE_LR_2[3] RM_IHPSG13_1P_BITKIT_16x2_EDGE_LR_2[3]/LWL<1>
+ RM_IHPSG13_1P_BITKIT_16x2_EDGE_LR_2[3]/LWL<2> RM_IHPSG13_1P_BITKIT_16x2_EDGE_LR_2[3]/LWL<3>
+ RM_IHPSG13_1P_BITKIT_16x2_EDGE_LR_2[3]/LWL<4> RM_IHPSG13_1P_BITKIT_16x2_EDGE_LR_2[3]/LWL<5>
+ RM_IHPSG13_1P_BITKIT_16x2_EDGE_LR_2[3]/LWL<7> RM_IHPSG13_1P_BITKIT_16x2_EDGE_LR_2[3]/LWL<8>
+ RM_IHPSG13_1P_BITKIT_16x2_EDGE_LR_2[3]/LWL<9> RM_IHPSG13_1P_BITKIT_16x2_EDGE_LR_2[3]/LWL<10>
+ RM_IHPSG13_1P_BITKIT_16x2_EDGE_LR_2[3]/LWL<11> RM_IHPSG13_1P_BITKIT_16x2_EDGE_LR_2[3]/LWL<12>
+ RM_IHPSG13_1P_BITKIT_16x2_EDGE_LR_2[3]/LWL<14> RM_IHPSG13_1P_BITKIT_16x2_EDGE_LR_2[3]/LWL<15>
+ RM_IHPSG13_1P_BITKIT_16x2_EDGE_LR_2[3]/LWL<0> RM_IHPSG13_1P_BITKIT_16x2_EDGE_LR_2[3]/LWL<6>
+ RM_IHPSG13_1P_BITKIT_16x2_EDGE_LR_2[3]/LWL<13> RM_IHPSG13_1P_COLUMN_256_0[7]/RM_IHPSG13_1P_BITKIT_16x2_SRAM_3[3]/VSS
+ RM_IHPSG13_1P_COLUMN_256_0[7]/RM_IHPSG13_1P_BITKIT_16x2_SRAM_3[3]/VDD RM_IHPSG13_1P_BITKIT_16x2_EDGE_LR
XRM_IHPSG13_1P_BITKIT_16x2_EDGE_LR_3[0] RM_IHPSG13_1P_BITKIT_16x2_EDGE_LR_3[0]/LWL<1>
+ RM_IHPSG13_1P_BITKIT_16x2_EDGE_LR_3[0]/LWL<2> RM_IHPSG13_1P_BITKIT_16x2_EDGE_LR_3[0]/LWL<3>
+ RM_IHPSG13_1P_BITKIT_16x2_EDGE_LR_3[0]/LWL<4> RM_IHPSG13_1P_BITKIT_16x2_EDGE_LR_3[0]/LWL<5>
+ RM_IHPSG13_1P_BITKIT_16x2_EDGE_LR_3[0]/LWL<7> RM_IHPSG13_1P_BITKIT_16x2_EDGE_LR_3[0]/LWL<8>
+ RM_IHPSG13_1P_BITKIT_16x2_EDGE_LR_3[0]/LWL<9> RM_IHPSG13_1P_BITKIT_16x2_EDGE_LR_3[0]/LWL<10>
+ RM_IHPSG13_1P_BITKIT_16x2_EDGE_LR_3[0]/LWL<11> RM_IHPSG13_1P_BITKIT_16x2_EDGE_LR_3[0]/LWL<12>
+ RM_IHPSG13_1P_BITKIT_16x2_EDGE_LR_3[0]/LWL<14> RM_IHPSG13_1P_BITKIT_16x2_EDGE_LR_3[0]/LWL<15>
+ RM_IHPSG13_1P_BITKIT_16x2_EDGE_LR_3[0]/LWL<0> RM_IHPSG13_1P_BITKIT_16x2_EDGE_LR_3[0]/LWL<6>
+ RM_IHPSG13_1P_BITKIT_16x2_EDGE_LR_3[0]/LWL<13> RM_IHPSG13_1P_COLUMN_256_0[7]/RM_IHPSG13_1P_BITKIT_16x2_SRAM_3[3]/VSS
+ RM_IHPSG13_1P_COLUMN_256_0[7]/RM_IHPSG13_1P_BITKIT_16x2_SRAM_3[3]/VDD RM_IHPSG13_1P_BITKIT_16x2_EDGE_LR
XRM_IHPSG13_1P_BITKIT_16x2_EDGE_LR_3[1] RM_IHPSG13_1P_BITKIT_16x2_EDGE_LR_3[1]/LWL<1>
+ RM_IHPSG13_1P_BITKIT_16x2_EDGE_LR_3[1]/LWL<2> RM_IHPSG13_1P_BITKIT_16x2_EDGE_LR_3[1]/LWL<3>
+ RM_IHPSG13_1P_BITKIT_16x2_EDGE_LR_3[1]/LWL<4> RM_IHPSG13_1P_BITKIT_16x2_EDGE_LR_3[1]/LWL<5>
+ RM_IHPSG13_1P_BITKIT_16x2_EDGE_LR_3[1]/LWL<7> RM_IHPSG13_1P_BITKIT_16x2_EDGE_LR_3[1]/LWL<8>
+ RM_IHPSG13_1P_BITKIT_16x2_EDGE_LR_3[1]/LWL<9> RM_IHPSG13_1P_BITKIT_16x2_EDGE_LR_3[1]/LWL<10>
+ RM_IHPSG13_1P_BITKIT_16x2_EDGE_LR_3[1]/LWL<11> RM_IHPSG13_1P_BITKIT_16x2_EDGE_LR_3[1]/LWL<12>
+ RM_IHPSG13_1P_BITKIT_16x2_EDGE_LR_3[1]/LWL<14> RM_IHPSG13_1P_BITKIT_16x2_EDGE_LR_3[1]/LWL<15>
+ RM_IHPSG13_1P_BITKIT_16x2_EDGE_LR_3[1]/LWL<0> RM_IHPSG13_1P_BITKIT_16x2_EDGE_LR_3[1]/LWL<6>
+ RM_IHPSG13_1P_BITKIT_16x2_EDGE_LR_3[1]/LWL<13> RM_IHPSG13_1P_COLUMN_256_0[7]/RM_IHPSG13_1P_BITKIT_16x2_SRAM_3[3]/VSS
+ RM_IHPSG13_1P_COLUMN_256_0[7]/RM_IHPSG13_1P_BITKIT_16x2_SRAM_3[3]/VDD RM_IHPSG13_1P_BITKIT_16x2_EDGE_LR
XRM_IHPSG13_1P_BITKIT_16x2_EDGE_LR_3[2] RM_IHPSG13_1P_BITKIT_16x2_EDGE_LR_3[2]/LWL<1>
+ RM_IHPSG13_1P_BITKIT_16x2_EDGE_LR_3[2]/LWL<2> RM_IHPSG13_1P_BITKIT_16x2_EDGE_LR_3[2]/LWL<3>
+ RM_IHPSG13_1P_BITKIT_16x2_EDGE_LR_3[2]/LWL<4> RM_IHPSG13_1P_BITKIT_16x2_EDGE_LR_3[2]/LWL<5>
+ RM_IHPSG13_1P_BITKIT_16x2_EDGE_LR_3[2]/LWL<7> RM_IHPSG13_1P_BITKIT_16x2_EDGE_LR_3[2]/LWL<8>
+ RM_IHPSG13_1P_BITKIT_16x2_EDGE_LR_3[2]/LWL<9> RM_IHPSG13_1P_BITKIT_16x2_EDGE_LR_3[2]/LWL<10>
+ RM_IHPSG13_1P_BITKIT_16x2_EDGE_LR_3[2]/LWL<11> RM_IHPSG13_1P_BITKIT_16x2_EDGE_LR_3[2]/LWL<12>
+ RM_IHPSG13_1P_BITKIT_16x2_EDGE_LR_3[2]/LWL<14> RM_IHPSG13_1P_BITKIT_16x2_EDGE_LR_3[2]/LWL<15>
+ RM_IHPSG13_1P_BITKIT_16x2_EDGE_LR_3[2]/LWL<0> RM_IHPSG13_1P_BITKIT_16x2_EDGE_LR_3[2]/LWL<6>
+ RM_IHPSG13_1P_BITKIT_16x2_EDGE_LR_3[2]/LWL<13> RM_IHPSG13_1P_COLUMN_256_0[7]/RM_IHPSG13_1P_BITKIT_16x2_SRAM_3[3]/VSS
+ RM_IHPSG13_1P_COLUMN_256_0[7]/RM_IHPSG13_1P_BITKIT_16x2_SRAM_3[3]/VDD RM_IHPSG13_1P_BITKIT_16x2_EDGE_LR
XRM_IHPSG13_1P_BITKIT_16x2_EDGE_LR_3[3] RM_IHPSG13_1P_BITKIT_16x2_EDGE_LR_3[3]/LWL<1>
+ RM_IHPSG13_1P_BITKIT_16x2_EDGE_LR_3[3]/LWL<2> RM_IHPSG13_1P_BITKIT_16x2_EDGE_LR_3[3]/LWL<3>
+ RM_IHPSG13_1P_BITKIT_16x2_EDGE_LR_3[3]/LWL<4> RM_IHPSG13_1P_BITKIT_16x2_EDGE_LR_3[3]/LWL<5>
+ RM_IHPSG13_1P_BITKIT_16x2_EDGE_LR_3[3]/LWL<7> RM_IHPSG13_1P_BITKIT_16x2_EDGE_LR_3[3]/LWL<8>
+ RM_IHPSG13_1P_BITKIT_16x2_EDGE_LR_3[3]/LWL<9> RM_IHPSG13_1P_BITKIT_16x2_EDGE_LR_3[3]/LWL<10>
+ RM_IHPSG13_1P_BITKIT_16x2_EDGE_LR_3[3]/LWL<11> RM_IHPSG13_1P_BITKIT_16x2_EDGE_LR_3[3]/LWL<12>
+ RM_IHPSG13_1P_BITKIT_16x2_EDGE_LR_3[3]/LWL<14> RM_IHPSG13_1P_BITKIT_16x2_EDGE_LR_3[3]/LWL<15>
+ RM_IHPSG13_1P_BITKIT_16x2_EDGE_LR_3[3]/LWL<0> RM_IHPSG13_1P_BITKIT_16x2_EDGE_LR_3[3]/LWL<6>
+ RM_IHPSG13_1P_BITKIT_16x2_EDGE_LR_3[3]/LWL<13> RM_IHPSG13_1P_COLUMN_256_0[7]/RM_IHPSG13_1P_BITKIT_16x2_SRAM_3[3]/VSS
+ RM_IHPSG13_1P_COLUMN_256_0[7]/RM_IHPSG13_1P_BITKIT_16x2_SRAM_3[3]/VDD RM_IHPSG13_1P_BITKIT_16x2_EDGE_LR
XRM_IHPSG13_1P_BITKIT_16x2_EDGE_LR_4[0] RM_IHPSG13_1P_BITKIT_16x2_EDGE_LR_4[0]/LWL<1>
+ RM_IHPSG13_1P_BITKIT_16x2_EDGE_LR_4[0]/LWL<2> RM_IHPSG13_1P_BITKIT_16x2_EDGE_LR_4[0]/LWL<3>
+ RM_IHPSG13_1P_BITKIT_16x2_EDGE_LR_4[0]/LWL<4> RM_IHPSG13_1P_BITKIT_16x2_EDGE_LR_4[0]/LWL<5>
+ RM_IHPSG13_1P_BITKIT_16x2_EDGE_LR_4[0]/LWL<7> RM_IHPSG13_1P_BITKIT_16x2_EDGE_LR_4[0]/LWL<8>
+ RM_IHPSG13_1P_BITKIT_16x2_EDGE_LR_4[0]/LWL<9> RM_IHPSG13_1P_BITKIT_16x2_EDGE_LR_4[0]/LWL<10>
+ RM_IHPSG13_1P_BITKIT_16x2_EDGE_LR_4[0]/LWL<11> RM_IHPSG13_1P_BITKIT_16x2_EDGE_LR_4[0]/LWL<12>
+ RM_IHPSG13_1P_BITKIT_16x2_EDGE_LR_4[0]/LWL<14> RM_IHPSG13_1P_BITKIT_16x2_EDGE_LR_4[0]/LWL<15>
+ RM_IHPSG13_1P_BITKIT_16x2_EDGE_LR_4[0]/LWL<0> RM_IHPSG13_1P_BITKIT_16x2_EDGE_LR_4[0]/LWL<6>
+ RM_IHPSG13_1P_BITKIT_16x2_EDGE_LR_4[0]/LWL<13> RM_IHPSG13_1P_COLUMN_256_0[7]/RM_IHPSG13_1P_BITKIT_16x2_SRAM_3[3]/VSS
+ RM_IHPSG13_1P_COLUMN_256_0[7]/RM_IHPSG13_1P_BITKIT_16x2_SRAM_3[3]/VDD RM_IHPSG13_1P_BITKIT_16x2_EDGE_LR
XRM_IHPSG13_1P_BITKIT_16x2_EDGE_LR_4[1] RM_IHPSG13_1P_BITKIT_16x2_EDGE_LR_4[1]/LWL<1>
+ RM_IHPSG13_1P_BITKIT_16x2_EDGE_LR_4[1]/LWL<2> RM_IHPSG13_1P_BITKIT_16x2_EDGE_LR_4[1]/LWL<3>
+ RM_IHPSG13_1P_BITKIT_16x2_EDGE_LR_4[1]/LWL<4> RM_IHPSG13_1P_BITKIT_16x2_EDGE_LR_4[1]/LWL<5>
+ RM_IHPSG13_1P_BITKIT_16x2_EDGE_LR_4[1]/LWL<7> RM_IHPSG13_1P_BITKIT_16x2_EDGE_LR_4[1]/LWL<8>
+ RM_IHPSG13_1P_BITKIT_16x2_EDGE_LR_4[1]/LWL<9> RM_IHPSG13_1P_BITKIT_16x2_EDGE_LR_4[1]/LWL<10>
+ RM_IHPSG13_1P_BITKIT_16x2_EDGE_LR_4[1]/LWL<11> RM_IHPSG13_1P_BITKIT_16x2_EDGE_LR_4[1]/LWL<12>
+ RM_IHPSG13_1P_BITKIT_16x2_EDGE_LR_4[1]/LWL<14> RM_IHPSG13_1P_BITKIT_16x2_EDGE_LR_4[1]/LWL<15>
+ RM_IHPSG13_1P_BITKIT_16x2_EDGE_LR_4[1]/LWL<0> RM_IHPSG13_1P_BITKIT_16x2_EDGE_LR_4[1]/LWL<6>
+ RM_IHPSG13_1P_BITKIT_16x2_EDGE_LR_4[1]/LWL<13> RM_IHPSG13_1P_COLUMN_256_0[7]/RM_IHPSG13_1P_BITKIT_16x2_SRAM_3[3]/VSS
+ RM_IHPSG13_1P_COLUMN_256_0[7]/RM_IHPSG13_1P_BITKIT_16x2_SRAM_3[3]/VDD RM_IHPSG13_1P_BITKIT_16x2_EDGE_LR
XRM_IHPSG13_1P_BITKIT_16x2_EDGE_LR_4[2] RM_IHPSG13_1P_BITKIT_16x2_EDGE_LR_4[2]/LWL<1>
+ RM_IHPSG13_1P_BITKIT_16x2_EDGE_LR_4[2]/LWL<2> RM_IHPSG13_1P_BITKIT_16x2_EDGE_LR_4[2]/LWL<3>
+ RM_IHPSG13_1P_BITKIT_16x2_EDGE_LR_4[2]/LWL<4> RM_IHPSG13_1P_BITKIT_16x2_EDGE_LR_4[2]/LWL<5>
+ RM_IHPSG13_1P_BITKIT_16x2_EDGE_LR_4[2]/LWL<7> RM_IHPSG13_1P_BITKIT_16x2_EDGE_LR_4[2]/LWL<8>
+ RM_IHPSG13_1P_BITKIT_16x2_EDGE_LR_4[2]/LWL<9> RM_IHPSG13_1P_BITKIT_16x2_EDGE_LR_4[2]/LWL<10>
+ RM_IHPSG13_1P_BITKIT_16x2_EDGE_LR_4[2]/LWL<11> RM_IHPSG13_1P_BITKIT_16x2_EDGE_LR_4[2]/LWL<12>
+ RM_IHPSG13_1P_BITKIT_16x2_EDGE_LR_4[2]/LWL<14> RM_IHPSG13_1P_BITKIT_16x2_EDGE_LR_4[2]/LWL<15>
+ RM_IHPSG13_1P_BITKIT_16x2_EDGE_LR_4[2]/LWL<0> RM_IHPSG13_1P_BITKIT_16x2_EDGE_LR_4[2]/LWL<6>
+ RM_IHPSG13_1P_BITKIT_16x2_EDGE_LR_4[2]/LWL<13> RM_IHPSG13_1P_COLUMN_256_0[7]/RM_IHPSG13_1P_BITKIT_16x2_SRAM_3[3]/VSS
+ RM_IHPSG13_1P_COLUMN_256_0[7]/RM_IHPSG13_1P_BITKIT_16x2_SRAM_3[3]/VDD RM_IHPSG13_1P_BITKIT_16x2_EDGE_LR
XRM_IHPSG13_1P_BITKIT_16x2_EDGE_LR_4[3] RM_IHPSG13_1P_BITKIT_16x2_EDGE_LR_4[3]/LWL<1>
+ RM_IHPSG13_1P_BITKIT_16x2_EDGE_LR_4[3]/LWL<2> RM_IHPSG13_1P_BITKIT_16x2_EDGE_LR_4[3]/LWL<3>
+ RM_IHPSG13_1P_BITKIT_16x2_EDGE_LR_4[3]/LWL<4> RM_IHPSG13_1P_BITKIT_16x2_EDGE_LR_4[3]/LWL<5>
+ RM_IHPSG13_1P_BITKIT_16x2_EDGE_LR_4[3]/LWL<7> RM_IHPSG13_1P_BITKIT_16x2_EDGE_LR_4[3]/LWL<8>
+ RM_IHPSG13_1P_BITKIT_16x2_EDGE_LR_4[3]/LWL<9> RM_IHPSG13_1P_BITKIT_16x2_EDGE_LR_4[3]/LWL<10>
+ RM_IHPSG13_1P_BITKIT_16x2_EDGE_LR_4[3]/LWL<11> RM_IHPSG13_1P_BITKIT_16x2_EDGE_LR_4[3]/LWL<12>
+ RM_IHPSG13_1P_BITKIT_16x2_EDGE_LR_4[3]/LWL<14> RM_IHPSG13_1P_BITKIT_16x2_EDGE_LR_4[3]/LWL<15>
+ RM_IHPSG13_1P_BITKIT_16x2_EDGE_LR_4[3]/LWL<0> RM_IHPSG13_1P_BITKIT_16x2_EDGE_LR_4[3]/LWL<6>
+ RM_IHPSG13_1P_BITKIT_16x2_EDGE_LR_4[3]/LWL<13> RM_IHPSG13_1P_COLUMN_256_0[7]/RM_IHPSG13_1P_BITKIT_16x2_SRAM_3[3]/VSS
+ RM_IHPSG13_1P_COLUMN_256_0[7]/RM_IHPSG13_1P_BITKIT_16x2_SRAM_3[3]/VDD RM_IHPSG13_1P_BITKIT_16x2_EDGE_LR
XRM_IHPSG13_1P_BITKIT_16x2_EDGE_LR_5[0] RM_IHPSG13_1P_BITKIT_16x2_EDGE_LR_5[0]/LWL<1>
+ RM_IHPSG13_1P_BITKIT_16x2_EDGE_LR_5[0]/LWL<2> RM_IHPSG13_1P_BITKIT_16x2_EDGE_LR_5[0]/LWL<3>
+ RM_IHPSG13_1P_BITKIT_16x2_EDGE_LR_5[0]/LWL<4> RM_IHPSG13_1P_BITKIT_16x2_EDGE_LR_5[0]/LWL<5>
+ RM_IHPSG13_1P_BITKIT_16x2_EDGE_LR_5[0]/LWL<7> RM_IHPSG13_1P_BITKIT_16x2_EDGE_LR_5[0]/LWL<8>
+ RM_IHPSG13_1P_BITKIT_16x2_EDGE_LR_5[0]/LWL<9> RM_IHPSG13_1P_BITKIT_16x2_EDGE_LR_5[0]/LWL<10>
+ RM_IHPSG13_1P_BITKIT_16x2_EDGE_LR_5[0]/LWL<11> RM_IHPSG13_1P_BITKIT_16x2_EDGE_LR_5[0]/LWL<12>
+ RM_IHPSG13_1P_BITKIT_16x2_EDGE_LR_5[0]/LWL<14> RM_IHPSG13_1P_BITKIT_16x2_EDGE_LR_5[0]/LWL<15>
+ RM_IHPSG13_1P_BITKIT_16x2_EDGE_LR_5[0]/LWL<0> RM_IHPSG13_1P_BITKIT_16x2_EDGE_LR_5[0]/LWL<6>
+ RM_IHPSG13_1P_BITKIT_16x2_EDGE_LR_5[0]/LWL<13> RM_IHPSG13_1P_COLUMN_256_0[7]/RM_IHPSG13_1P_BITKIT_16x2_SRAM_3[3]/VSS
+ RM_IHPSG13_1P_COLUMN_256_0[7]/RM_IHPSG13_1P_BITKIT_16x2_SRAM_3[3]/VDD RM_IHPSG13_1P_BITKIT_16x2_EDGE_LR
XRM_IHPSG13_1P_BITKIT_16x2_EDGE_LR_5[1] RM_IHPSG13_1P_BITKIT_16x2_EDGE_LR_5[1]/LWL<1>
+ RM_IHPSG13_1P_BITKIT_16x2_EDGE_LR_5[1]/LWL<2> RM_IHPSG13_1P_BITKIT_16x2_EDGE_LR_5[1]/LWL<3>
+ RM_IHPSG13_1P_BITKIT_16x2_EDGE_LR_5[1]/LWL<4> RM_IHPSG13_1P_BITKIT_16x2_EDGE_LR_5[1]/LWL<5>
+ RM_IHPSG13_1P_BITKIT_16x2_EDGE_LR_5[1]/LWL<7> RM_IHPSG13_1P_BITKIT_16x2_EDGE_LR_5[1]/LWL<8>
+ RM_IHPSG13_1P_BITKIT_16x2_EDGE_LR_5[1]/LWL<9> RM_IHPSG13_1P_BITKIT_16x2_EDGE_LR_5[1]/LWL<10>
+ RM_IHPSG13_1P_BITKIT_16x2_EDGE_LR_5[1]/LWL<11> RM_IHPSG13_1P_BITKIT_16x2_EDGE_LR_5[1]/LWL<12>
+ RM_IHPSG13_1P_BITKIT_16x2_EDGE_LR_5[1]/LWL<14> RM_IHPSG13_1P_BITKIT_16x2_EDGE_LR_5[1]/LWL<15>
+ RM_IHPSG13_1P_BITKIT_16x2_EDGE_LR_5[1]/LWL<0> RM_IHPSG13_1P_BITKIT_16x2_EDGE_LR_5[1]/LWL<6>
+ RM_IHPSG13_1P_BITKIT_16x2_EDGE_LR_5[1]/LWL<13> RM_IHPSG13_1P_COLUMN_256_0[7]/RM_IHPSG13_1P_BITKIT_16x2_SRAM_3[3]/VSS
+ RM_IHPSG13_1P_COLUMN_256_0[7]/RM_IHPSG13_1P_BITKIT_16x2_SRAM_3[3]/VDD RM_IHPSG13_1P_BITKIT_16x2_EDGE_LR
XRM_IHPSG13_1P_BITKIT_16x2_EDGE_LR_5[2] RM_IHPSG13_1P_BITKIT_16x2_EDGE_LR_5[2]/LWL<1>
+ RM_IHPSG13_1P_BITKIT_16x2_EDGE_LR_5[2]/LWL<2> RM_IHPSG13_1P_BITKIT_16x2_EDGE_LR_5[2]/LWL<3>
+ RM_IHPSG13_1P_BITKIT_16x2_EDGE_LR_5[2]/LWL<4> RM_IHPSG13_1P_BITKIT_16x2_EDGE_LR_5[2]/LWL<5>
+ RM_IHPSG13_1P_BITKIT_16x2_EDGE_LR_5[2]/LWL<7> RM_IHPSG13_1P_BITKIT_16x2_EDGE_LR_5[2]/LWL<8>
+ RM_IHPSG13_1P_BITKIT_16x2_EDGE_LR_5[2]/LWL<9> RM_IHPSG13_1P_BITKIT_16x2_EDGE_LR_5[2]/LWL<10>
+ RM_IHPSG13_1P_BITKIT_16x2_EDGE_LR_5[2]/LWL<11> RM_IHPSG13_1P_BITKIT_16x2_EDGE_LR_5[2]/LWL<12>
+ RM_IHPSG13_1P_BITKIT_16x2_EDGE_LR_5[2]/LWL<14> RM_IHPSG13_1P_BITKIT_16x2_EDGE_LR_5[2]/LWL<15>
+ RM_IHPSG13_1P_BITKIT_16x2_EDGE_LR_5[2]/LWL<0> RM_IHPSG13_1P_BITKIT_16x2_EDGE_LR_5[2]/LWL<6>
+ RM_IHPSG13_1P_BITKIT_16x2_EDGE_LR_5[2]/LWL<13> RM_IHPSG13_1P_COLUMN_256_0[7]/RM_IHPSG13_1P_BITKIT_16x2_SRAM_3[3]/VSS
+ RM_IHPSG13_1P_COLUMN_256_0[7]/RM_IHPSG13_1P_BITKIT_16x2_SRAM_3[3]/VDD RM_IHPSG13_1P_BITKIT_16x2_EDGE_LR
XRM_IHPSG13_1P_BITKIT_16x2_EDGE_LR_5[3] RM_IHPSG13_1P_BITKIT_16x2_EDGE_LR_5[3]/LWL<1>
+ RM_IHPSG13_1P_BITKIT_16x2_EDGE_LR_5[3]/LWL<2> RM_IHPSG13_1P_BITKIT_16x2_EDGE_LR_5[3]/LWL<3>
+ RM_IHPSG13_1P_BITKIT_16x2_EDGE_LR_5[3]/LWL<4> RM_IHPSG13_1P_BITKIT_16x2_EDGE_LR_5[3]/LWL<5>
+ RM_IHPSG13_1P_BITKIT_16x2_EDGE_LR_5[3]/LWL<7> RM_IHPSG13_1P_BITKIT_16x2_EDGE_LR_5[3]/LWL<8>
+ RM_IHPSG13_1P_BITKIT_16x2_EDGE_LR_5[3]/LWL<9> RM_IHPSG13_1P_BITKIT_16x2_EDGE_LR_5[3]/LWL<10>
+ RM_IHPSG13_1P_BITKIT_16x2_EDGE_LR_5[3]/LWL<11> RM_IHPSG13_1P_BITKIT_16x2_EDGE_LR_5[3]/LWL<12>
+ RM_IHPSG13_1P_BITKIT_16x2_EDGE_LR_5[3]/LWL<14> RM_IHPSG13_1P_BITKIT_16x2_EDGE_LR_5[3]/LWL<15>
+ RM_IHPSG13_1P_BITKIT_16x2_EDGE_LR_5[3]/LWL<0> RM_IHPSG13_1P_BITKIT_16x2_EDGE_LR_5[3]/LWL<6>
+ RM_IHPSG13_1P_BITKIT_16x2_EDGE_LR_5[3]/LWL<13> RM_IHPSG13_1P_COLUMN_256_0[7]/RM_IHPSG13_1P_BITKIT_16x2_SRAM_3[3]/VSS
+ RM_IHPSG13_1P_COLUMN_256_0[7]/RM_IHPSG13_1P_BITKIT_16x2_SRAM_3[3]/VDD RM_IHPSG13_1P_BITKIT_16x2_EDGE_LR
XRM_IHPSG13_1P_COLUMN_256_0[0] RM_IHPSG13_1P_COLUMN_256_0[0]/RM_IHPSG13_1P_BITKIT_16x2_SRAM_0[0]/A_BLT_BOT<0>
+ RM_IHPSG13_1P_COLUMN_256_0[0]/RM_IHPSG13_1P_BITKIT_16x2_SRAM_0[0]/A_BLT_BOT<1> RM_IHPSG13_1P_COLUMN_256_0[0]/RM_IHPSG13_1P_BITKIT_16x2_SRAM_0[0]/A_BLC_BOT<0>
+ RM_IHPSG13_1P_COLUMN_256_0[0]/RM_IHPSG13_1P_BITKIT_16x2_SRAM_1[3]/A_RWL<6> RM_IHPSG13_1P_COLUMN_256_0[0]/RM_IHPSG13_1P_BITKIT_16x2_SRAM_0[3]/A_RWL<11>
+ RM_IHPSG13_1P_COLUMN_256_0[0]/RM_IHPSG13_1P_BITKIT_16x2_SRAM_0[0]/A_BLC_BOT<1> RM_IHPSG13_1P_BITKIT_16x2_EDGE_LR_5[1]/LWL<12>
+ RM_IHPSG13_1P_COLUMN_256_0[0]/RM_IHPSG13_1P_BITKIT_16x2_SRAM_1[3]/A_RWL<8> RM_IHPSG13_1P_COLUMN_256_0[0]/RM_IHPSG13_1P_BITKIT_16x2_SRAM_0[3]/A_RWL<9>
+ RM_IHPSG13_1P_BITKIT_16x2_EDGE_LR_7[3]/LWL<4> RM_IHPSG13_1P_BITKIT_16x2_EDGE_LR_5[2]/LWL<9>
+ RM_IHPSG13_1P_BITKIT_16x2_EDGE_LR_4[3]/LWL<1> RM_IHPSG13_1P_COLUMN_256_0[0]/RM_IHPSG13_1P_BITKIT_16x2_SRAM_0[3]/A_RWL<14>
+ RM_IHPSG13_1P_COLUMN_256_0[0]/RM_IHPSG13_1P_BITKIT_16x2_SRAM_0[2]/A_RWL<14> RM_IHPSG13_1P_BITKIT_16x2_EDGE_LR_4[0]/LWL<11>
+ RM_IHPSG13_1P_BITKIT_16x2_EDGE_LR_4[3]/LWL<4> RM_IHPSG13_1P_BITKIT_16x2_EDGE_LR_5[2]/LWL<12>
+ RM_IHPSG13_1P_BITKIT_16x2_EDGE_LR_6[2]/LWL<9> RM_IHPSG13_1P_COLUMN_256_0[0]/RM_IHPSG13_1P_BITKIT_16x2_SRAM_3[3]/A_RWL<9>
+ RM_IHPSG13_1P_BITKIT_16x2_EDGE_LR_6[3]/LWL<2> RM_IHPSG13_1P_BITKIT_16x2_EDGE_LR_7[3]/LWL<1>
+ RM_IHPSG13_1P_COLUMN_256_0[0]/RM_IHPSG13_1P_BITKIT_16x2_SRAM_2[3]/A_RWL<7> RM_IHPSG13_1P_COLUMN_256_0[0]/RM_IHPSG13_1P_BITKIT_16x2_SRAM_0[0]/A_RWL<0>
+ RM_IHPSG13_1P_COLUMN_256_0[0]/RM_IHPSG13_1P_BITKIT_16x2_SRAM_2[0]/A_RWL<1> RM_IHPSG13_1P_COLUMN_256_0[0]/RM_IHPSG13_1P_BITKIT_16x2_SRAM_0[2]/A_RWL<13>
+ RM_IHPSG13_1P_COLUMN_256_0[0]/RM_IHPSG13_1P_BITKIT_16x2_SRAM_2[3]/A_RWL<5> RM_IHPSG13_1P_BITKIT_16x2_EDGE_LR_4[3]/LWL<3>
+ RM_IHPSG13_1P_COLUMN_256_0[0]/RM_IHPSG13_1P_BITKIT_16x2_SRAM_3[0]/A_RWL<13> RM_IHPSG13_1P_COLUMN_256_0[0]/RM_IHPSG13_1P_BITKIT_16x2_SRAM_1[0]/A_RWL<3>
+ RM_IHPSG13_1P_BITKIT_16x2_EDGE_LR_5[1]/LWL<15> RM_IHPSG13_1P_BITKIT_16x2_EDGE_LR_4[0]/LWL<14>
+ RM_IHPSG13_1P_COLUMN_256_0[0]/RM_IHPSG13_1P_BITKIT_16x2_SRAM_0[3]/A_RWL<7> RM_IHPSG13_1P_COLUMN_256_0[0]/RM_IHPSG13_1P_BITKIT_16x2_SRAM_3[0]/A_RWL<0>
+ RM_IHPSG13_1P_BITKIT_16x2_EDGE_LR_5[2]/LWL<15> RM_IHPSG13_1P_COLUMN_256_0[0]/RM_IHPSG13_1P_BITKIT_16x2_SRAM_3[3]/A_RWL<4>
+ RM_IHPSG13_1P_BITKIT_16x2_EDGE_LR_5[2]/LWL<7> RM_IHPSG13_1P_BITKIT_16x2_EDGE_LR_7[0]/LWL<0>
+ RM_IHPSG13_1P_BITKIT_16x2_EDGE_LR_6[3]/LWL<9> RM_IHPSG13_1P_COLUMN_256_0[0]/RM_IHPSG13_1P_BITKIT_16x2_SRAM_3[0]/A_RWL<3>
+ RM_IHPSG13_1P_COLUMN_256_0[0]/RM_IHPSG13_1P_BITKIT_16x2_SRAM_0[0]/A_RWL<5> RM_IHPSG13_1P_COLUMN_256_0[0]/RM_IHPSG13_1P_BITKIT_16x2_SRAM_0[3]/A_RWL<13>
+ RM_IHPSG13_1P_BITKIT_16x2_EDGE_LR_4[3]/LWL<8> RM_IHPSG13_1P_BITKIT_16x2_EDGE_LR_7[3]/LWL<7>
+ RM_IHPSG13_1P_BITKIT_16x2_EDGE_LR_5[0]/LWL<15> RM_IHPSG13_1P_BITKIT_16x2_EDGE_LR_5[3]/LWL<13>
+ RM_IHPSG13_1P_BITKIT_16x2_EDGE_LR_4[3]/LWL<6> RM_IHPSG13_1P_BITKIT_16x2_EDGE_LR_4[1]/LWL<10>
+ RM_IHPSG13_1P_BITKIT_16x2_EDGE_LR_5[3]/LWL<0> RM_IHPSG13_1P_COLUMN_256_0[0]/RM_IHPSG13_1P_BITKIT_16x2_SRAM_3[0]/A_RWL<4>
+ RM_IHPSG13_1P_BITKIT_16x2_EDGE_LR_4[2]/LWL<10> RM_IHPSG13_1P_COLUMN_256_0[0]/RM_IHPSG13_1P_BITKIT_16x2_SRAM_3[1]/A_RWL<13>
+ RM_IHPSG13_1P_COLUMN_256_0[0]/RM_IHPSG13_1P_BITKIT_16x2_SRAM_1[0]/A_RWL<6> RM_IHPSG13_1P_BITKIT_16x2_EDGE_LR_5[3]/LWL<9>
+ RM_IHPSG13_1P_COLUMN_256_0[0]/RM_IHPSG13_1P_BITKIT_16x2_SRAM_1[0]/A_RWL<4> RM_IHPSG13_1P_COLUMN_256_0[0]/RM_IHPSG13_1P_BITKIT_16x2_SRAM_0[3]/A_RWL<10>
+ RM_IHPSG13_1P_BITKIT_16x2_EDGE_LR_4[1]/LWL<14> RM_IHPSG13_1P_COLUMN_256_0[0]/RM_IHPSG13_1P_BITKIT_16x2_SRAM_3[0]/A_RWL<5>
+ RM_IHPSG13_1P_BITKIT_16x2_EDGE_LR_7[3]/LWL<8> RM_IHPSG13_1P_BITKIT_16x2_EDGE_LR_5[3]/LWL<7>
+ RM_IHPSG13_1P_BITKIT_16x2_EDGE_LR_4[2]/LWL<8> RM_IHPSG13_1P_BITKIT_16x2_EDGE_LR_5[3]/LWL<15>
+ RM_IHPSG13_1P_BITKIT_16x2_EDGE_LR_5[2]/LWL<13> RM_IHPSG13_1P_BITKIT_16x2_EDGE_LR_4[0]/LWL<1>
+ RM_IHPSG13_1P_BITKIT_16x2_EDGE_LR_7[0]/LWL<1> RM_IHPSG13_1P_BITKIT_16x2_EDGE_LR_6[3]/LWL<0>
+ RM_IHPSG13_1P_BITKIT_16x2_EDGE_LR_4[0]/LWL<10> RM_IHPSG13_1P_BITKIT_16x2_EDGE_LR_5[3]/LWL<11>
+ RM_IHPSG13_1P_BITKIT_16x2_EDGE_LR_7[0]/LWL<3> RM_IHPSG13_1P_COLUMN_256_0[0]/RM_IHPSG13_1P_BITKIT_16x2_SRAM_3[0]/A_RWL<6>
+ RM_IHPSG13_1P_BITKIT_16x2_EDGE_LR_4[3]/LWL<5> RM_IHPSG13_1P_COLUMN_256_0[0]/RM_IHPSG13_1P_BITKIT_16x2_SRAM_2[0]/A_RWL<7>
+ RM_IHPSG13_1P_COLUMN_256_0[0]/RM_IHPSG13_1P_BITKIT_16x2_SRAM_3[1]/A_RWL<15> RM_IHPSG13_1P_COLUMN_256_0[0]/RM_IHPSG13_1P_BITKIT_16x2_SRAM_0[1]/A_RWL<0>
+ RM_IHPSG13_1P_COLUMN_256_0[0]/RM_IHPSG13_1P_BITKIT_16x2_SRAM_3[0]/A_RWL<2> RM_IHPSG13_1P_COLUMN_256_0[0]/RM_IHPSG13_1P_BITKIT_16x2_SRAM_2[0]/A_RWL<11>
+ RM_IHPSG13_1P_BITKIT_16x2_EDGE_LR_4[0]/LWL<2> RM_IHPSG13_1P_COLUMN_256_0[0]/RM_IHPSG13_1P_BITKIT_16x2_SRAM_3[0]/A_RWL<15>
+ RM_IHPSG13_1P_BITKIT_16x2_EDGE_LR_7[0]/LWL<4> RM_IHPSG13_1P_BITKIT_16x2_EDGE_LR_6[0]/LWL<12>
+ RM_IHPSG13_1P_COLUMN_256_0[0]/RM_IHPSG13_1P_BITKIT_16x2_SRAM_2[0]/A_RWL<8> RM_IHPSG13_1P_COLUMN_256_0[0]/RM_IHPSG13_1P_BITKIT_16x2_SRAM_1[0]/A_RWL<9>
+ RM_IHPSG13_1P_BITKIT_16x2_EDGE_LR_5[1]/LWL<13> RM_IHPSG13_1P_COLUMN_256_0[0]/RM_IHPSG13_1P_BITKIT_16x2_SRAM_1[3]/A_RWL<9>
+ RM_IHPSG13_1P_BITKIT_16x2_EDGE_LR_4[3]/LWL<10> RM_IHPSG13_1P_COLUMN_256_0[0]/RM_IHPSG13_1P_BITKIT_16x2_SRAM_3[2]/A_RWL<13>
+ RM_IHPSG13_1P_BITKIT_16x2_EDGE_LR_5[2]/LWL<11> RM_IHPSG13_1P_COLUMN_256_0[0]/RM_IHPSG13_1P_BITKIT_16x2_SRAM_0[0]/A_RWL<7>
+ RM_IHPSG13_1P_BITKIT_16x2_EDGE_LR_7[3]/LWL<5> RM_IHPSG13_1P_COLUMN_256_0[0]/RM_IHPSG13_1P_BITKIT_16x2_SRAM_1[0]/A_RWL<2>
+ RM_IHPSG13_1P_BITKIT_16x2_EDGE_LR_4[2]/LWL<14> RM_IHPSG13_1P_BITKIT_16x2_EDGE_LR_5[0]/LWL<3>
+ RM_IHPSG13_1P_BITKIT_16x2_EDGE_LR_4[0]/LWL<4> RM_IHPSG13_1P_BITKIT_16x2_EDGE_LR_5[3]/LWL<14>
+ RM_IHPSG13_1P_COLUMN_256_0[0]/RM_IHPSG13_1P_BITKIT_16x2_SRAM_2[1]/A_RWL<10> RM_IHPSG13_1P_BITKIT_16x2_EDGE_LR_6[0]/LWL<5>
+ RM_IHPSG13_1P_COLUMN_256_0[0]/RM_IHPSG13_1P_BITKIT_16x2_SRAM_3[1]/A_RWL<0> RM_IHPSG13_1P_COLUMN_256_0[0]/RM_IHPSG13_1P_BITKIT_16x2_SRAM_2[0]/A_RWL<10>
+ RM_IHPSG13_1P_COLUMN_256_0[0]/RM_IHPSG13_1P_BITKIT_16x2_SRAM_2[0]/A_RWL<12> RM_IHPSG13_1P_COLUMN_256_0[0]/RM_IHPSG13_1P_BITKIT_16x2_SRAM_3[3]/A_RWL<11>
+ RM_IHPSG13_1P_BITKIT_16x2_EDGE_LR_7[0]/LWL<6> RM_IHPSG13_1P_COLUMN_256_0[0]/RM_IHPSG13_1P_BITKIT_16x2_SRAM_2[1]/A_RWL<1>
+ RM_IHPSG13_1P_COLUMN_256_0[0]/RM_IHPSG13_1P_BITKIT_16x2_SRAM_2[3]/A_RWL<8> RM_IHPSG13_1P_COLUMN_256_0[0]/RM_IHPSG13_1P_BITKIT_16x2_SRAM_1[1]/A_RWL<2>
+ RM_IHPSG13_1P_COLUMN_256_0[0]/RM_IHPSG13_1P_BITKIT_16x2_SRAM_2[0]/A_RWL<14> RM_IHPSG13_1P_BITKIT_16x2_EDGE_LR_5[0]/LWL<13>
+ RM_IHPSG13_1P_COLUMN_256_0[0]/RM_IHPSG13_1P_BITKIT_16x2_SRAM_3[2]/A_RWL<15> RM_IHPSG13_1P_COLUMN_256_0[0]/RM_IHPSG13_1P_BITKIT_16x2_SRAM_2[1]/A_RWL<11>
+ RM_IHPSG13_1P_BITKIT_16x2_EDGE_LR_5[1]/LWL<11> RM_IHPSG13_1P_BITKIT_16x2_EDGE_LR_5[0]/LWL<0>
+ RM_IHPSG13_1P_COLUMN_256_0[0]/RM_IHPSG13_1P_BITKIT_16x2_SRAM_3[3]/A_RWL<12> RM_IHPSG13_1P_BITKIT_16x2_EDGE_LR_7[0]/LWL<7>
+ RM_IHPSG13_1P_BITKIT_16x2_EDGE_LR_6[0]/LWL<15> RM_IHPSG13_1P_COLUMN_256_0[0]/RM_IHPSG13_1P_BITKIT_16x2_SRAM_1[1]/A_RWL<3>
+ RM_IHPSG13_1P_BITKIT_16x2_EDGE_LR_6[1]/LWL<12> RM_IHPSG13_1P_COLUMN_256_0[0]/RM_IHPSG13_1P_BITKIT_16x2_SRAM_0[1]/A_RWL<4>
+ RM_IHPSG13_1P_BITKIT_16x2_EDGE_LR_5[0]/LWL<5> RM_IHPSG13_1P_BITKIT_16x2_EDGE_LR_4[0]/LWL<6>
+ RM_IHPSG13_1P_BITKIT_16x2_EDGE_LR_5[2]/LWL<14> RM_IHPSG13_1P_BITKIT_16x2_EDGE_LR_6[0]/LWL<7>
+ RM_IHPSG13_1P_COLUMN_256_0[0]/RM_IHPSG13_1P_BITKIT_16x2_SRAM_3[1]/A_RWL<2> RM_IHPSG13_1P_COLUMN_256_0[0]/RM_IHPSG13_1P_BITKIT_16x2_SRAM_3[2]/A_RWL<11>
+ RM_IHPSG13_1P_COLUMN_256_0[0]/RM_IHPSG13_1P_BITKIT_16x2_SRAM_3[3]/A_RWL<13> RM_IHPSG13_1P_BITKIT_16x2_EDGE_LR_7[0]/LWL<8>
+ RM_IHPSG13_1P_COLUMN_256_0[0]/RM_IHPSG13_1P_BITKIT_16x2_SRAM_2[3]/A_RWL<6> RM_IHPSG13_1P_COLUMN_256_0[0]/RM_IHPSG13_1P_BITKIT_16x2_SRAM_1[1]/A_RWL<4>
+ RM_IHPSG13_1P_COLUMN_256_0[0]/RM_IHPSG13_1P_BITKIT_16x2_SRAM_0[0]/A_RWL<1> RM_IHPSG13_1P_BITKIT_16x2_EDGE_LR_6[1]/LWL<13>
+ RM_IHPSG13_1P_BITKIT_16x2_EDGE_LR_6[0]/LWL<13> RM_IHPSG13_1P_COLUMN_256_0[0]/RM_IHPSG13_1P_BITKIT_16x2_SRAM_0[1]/A_RWL<5>
+ RM_IHPSG13_1P_BITKIT_16x2_EDGE_LR_5[0]/LWL<6> RM_IHPSG13_1P_BITKIT_16x2_EDGE_LR_4[3]/LWL<12>
+ RM_IHPSG13_1P_BITKIT_16x2_EDGE_LR_6[1]/LWL<11> RM_IHPSG13_1P_COLUMN_256_0[0]/RM_IHPSG13_1P_BITKIT_16x2_SRAM_0[0]/A_RWL<8>
+ RM_IHPSG13_1P_BITKIT_16x2_EDGE_LR_6[0]/LWL<0> RM_IHPSG13_1P_BITKIT_16x2_EDGE_LR_7[3]/LWL<3>
+ RM_IHPSG13_1P_COLUMN_256_0[0]/RM_IHPSG13_1P_BITKIT_16x2_SRAM_2[1]/A_RWL<12> RM_IHPSG13_1P_COLUMN_256_0[0]/RM_IHPSG13_1P_BITKIT_16x2_SRAM_2[0]/A_RWL<9>
+ RM_IHPSG13_1P_COLUMN_256_0[0]/RM_IHPSG13_1P_BITKIT_16x2_SRAM_3[1]/A_RWL<3> RM_IHPSG13_1P_BITKIT_16x2_EDGE_LR_4[3]/LWL<2>
+ RM_IHPSG13_1P_COLUMN_256_0[0]/RM_IHPSG13_1P_BITKIT_16x2_SRAM_3[3]/A_RWL<14> RM_IHPSG13_1P_COLUMN_256_0[0]/RM_IHPSG13_1P_BITKIT_16x2_SRAM_2[2]/A_RWL<10>
+ RM_IHPSG13_1P_BITKIT_16x2_EDGE_LR_4[0]/LWL<5> RM_IHPSG13_1P_BITKIT_16x2_EDGE_LR_5[3]/LWL<4>
+ RM_IHPSG13_1P_COLUMN_256_0[0]/RM_IHPSG13_1P_BITKIT_16x2_SRAM_2[1]/A_RWL<3> RM_IHPSG13_1P_BITKIT_16x2_EDGE_LR_5[0]/LWL<7>
+ RM_IHPSG13_1P_BITKIT_16x2_EDGE_LR_7[0]/LWL<10> RM_IHPSG13_1P_BITKIT_16x2_EDGE_LR_6[1]/LWL<0>
+ RM_IHPSG13_1P_BITKIT_16x2_EDGE_LR_4[0]/LWL<8> RM_IHPSG13_1P_BITKIT_16x2_EDGE_LR_5[1]/LWL<14>
+ RM_IHPSG13_1P_BITKIT_16x2_EDGE_LR_6[2]/LWL<11> RM_IHPSG13_1P_COLUMN_256_0[0]/RM_IHPSG13_1P_BITKIT_16x2_SRAM_2[1]/A_RWL<14>
+ RM_IHPSG13_1P_BITKIT_16x2_EDGE_LR_7[1]/LWL<1> RM_IHPSG13_1P_BITKIT_16x2_EDGE_LR_6[0]/LWL<9>
+ RM_IHPSG13_1P_COLUMN_256_0[0]/RM_IHPSG13_1P_BITKIT_16x2_SRAM_3[1]/A_RWL<4> RM_IHPSG13_1P_COLUMN_256_0[0]/RM_IHPSG13_1P_BITKIT_16x2_SRAM_1[0]/A_RWL<0>
+ RM_IHPSG13_1P_COLUMN_256_0[0]/RM_IHPSG13_1P_BITKIT_16x2_SRAM_3[1]/A_RWL<11> RM_IHPSG13_1P_COLUMN_256_0[0]/RM_IHPSG13_1P_BITKIT_16x2_SRAM_3[3]/A_RWL<15>
+ RM_IHPSG13_1P_COLUMN_256_0[0]/RM_IHPSG13_1P_BITKIT_16x2_SRAM_0[3]/A_RWL<6> RM_IHPSG13_1P_COLUMN_256_0[0]/RM_IHPSG13_1P_BITKIT_16x2_SRAM_2[1]/A_RWL<5>
+ RM_IHPSG13_1P_COLUMN_256_0[0]/RM_IHPSG13_1P_BITKIT_16x2_SRAM_2[2]/A_RWL<11> RM_IHPSG13_1P_COLUMN_256_0[0]/RM_IHPSG13_1P_BITKIT_16x2_SRAM_3[0]/A_RWL<1>
+ RM_IHPSG13_1P_COLUMN_256_0[0]/RM_IHPSG13_1P_BITKIT_16x2_SRAM_3[3]/A_RWL<5> RM_IHPSG13_1P_COLUMN_256_0[0]/RM_IHPSG13_1P_BITKIT_16x2_SRAM_1[1]/A_RWL<6>
+ RM_IHPSG13_1P_COLUMN_256_0[0]/RM_IHPSG13_1P_BITKIT_16x2_SRAM_3[0]/A_RWL<8> RM_IHPSG13_1P_BITKIT_16x2_EDGE_LR_6[1]/LWL<15>
+ RM_IHPSG13_1P_COLUMN_256_0[0]/RM_IHPSG13_1P_BITKIT_16x2_SRAM_0[1]/A_RWL<7> RM_IHPSG13_1P_BITKIT_16x2_EDGE_LR_5[3]/LWL<3>
+ RM_IHPSG13_1P_BITKIT_16x2_EDGE_LR_7[0]/LWL<11> RM_IHPSG13_1P_BITKIT_16x2_EDGE_LR_4[2]/LWL<12>
+ RM_IHPSG13_1P_BITKIT_16x2_EDGE_LR_6[0]/LWL<11> RM_IHPSG13_1P_BITKIT_16x2_EDGE_LR_6[2]/LWL<12>
+ RM_IHPSG13_1P_COLUMN_256_0[0]/RM_IHPSG13_1P_BITKIT_16x2_SRAM_3[2]/A_RWL<14> RM_IHPSG13_1P_COLUMN_256_0[0]/RM_IHPSG13_1P_BITKIT_16x2_SRAM_3[1]/A_RWL<5>
+ RM_IHPSG13_1P_BITKIT_16x2_EDGE_LR_7[0]/LWL<5> RM_IHPSG13_1P_BITKIT_16x2_EDGE_LR_6[3]/LWL<4>
+ RM_IHPSG13_1P_COLUMN_256_0[0]/RM_IHPSG13_1P_BITKIT_16x2_SRAM_0[1]/A_RWL<1> RM_IHPSG13_1P_COLUMN_256_0[0]/RM_IHPSG13_1P_BITKIT_16x2_SRAM_0[1]/A_RWL<3>
+ RM_IHPSG13_1P_BITKIT_16x2_EDGE_LR_5[1]/LWL<0> RM_IHPSG13_1P_COLUMN_256_0[0]/RM_IHPSG13_1P_BITKIT_16x2_SRAM_2[0]/A_RWL<3>
+ RM_IHPSG13_1P_BITKIT_16x2_EDGE_LR_4[3]/LWL<9> RM_IHPSG13_1P_BITKIT_16x2_EDGE_LR_4[1]/LWL<1>
+ RM_IHPSG13_1P_BITKIT_16x2_EDGE_LR_5[0]/LWL<9> RM_IHPSG13_1P_COLUMN_256_0[0]/RM_IHPSG13_1P_BITKIT_16x2_SRAM_0[1]/A_RWL<8>
+ RM_IHPSG13_1P_BITKIT_16x2_EDGE_LR_6[1]/LWL<14> RM_IHPSG13_1P_BITKIT_16x2_EDGE_LR_7[0]/LWL<2>
+ RM_IHPSG13_1P_COLUMN_256_0[0]/RM_IHPSG13_1P_BITKIT_16x2_SRAM_2[2]/A_RWL<12> RM_IHPSG13_1P_BITKIT_16x2_EDGE_LR_6[1]/LWL<2>
+ RM_IHPSG13_1P_BITKIT_16x2_EDGE_LR_7[3]/LWL<6> RM_IHPSG13_1P_BITKIT_16x2_EDGE_LR_5[0]/LWL<14>
+ RM_IHPSG13_1P_BITKIT_16x2_EDGE_LR_6[2]/LWL<13> RM_IHPSG13_1P_BITKIT_16x2_EDGE_LR_7[1]/LWL<3>
+ RM_IHPSG13_1P_COLUMN_256_0[0]/RM_IHPSG13_1P_BITKIT_16x2_SRAM_1[0]/A_RWL<12> RM_IHPSG13_1P_COLUMN_256_0[0]/RM_IHPSG13_1P_BITKIT_16x2_SRAM_3[1]/A_RWL<6>
+ RM_IHPSG13_1P_COLUMN_256_0[0]/RM_IHPSG13_1P_BITKIT_16x2_SRAM_3[0]/A_RWL<11> RM_IHPSG13_1P_BITKIT_16x2_EDGE_LR_5[3]/LWL<1>
+ RM_IHPSG13_1P_COLUMN_256_0[0]/RM_IHPSG13_1P_BITKIT_16x2_SRAM_2[1]/A_RWL<7> RM_IHPSG13_1P_COLUMN_256_0[0]/RM_IHPSG13_1P_BITKIT_16x2_SRAM_2[1]/A_RWL<6>
+ RM_IHPSG13_1P_COLUMN_256_0[0]/RM_IHPSG13_1P_BITKIT_16x2_SRAM_0[2]/A_RWL<0> RM_IHPSG13_1P_COLUMN_256_0[0]/RM_IHPSG13_1P_BITKIT_16x2_SRAM_2[3]/A_RWL<10>
+ RM_IHPSG13_1P_BITKIT_16x2_EDGE_LR_4[1]/LWL<2> RM_IHPSG13_1P_BITKIT_16x2_EDGE_LR_7[0]/LWL<13>
+ RM_IHPSG13_1P_BITKIT_16x2_EDGE_LR_4[1]/LWL<12> RM_IHPSG13_1P_COLUMN_256_0[0]/RM_IHPSG13_1P_BITKIT_16x2_SRAM_1[1]/A_RWL<0>
+ RM_IHPSG13_1P_BITKIT_16x2_EDGE_LR_6[2]/LWL<14> RM_IHPSG13_1P_COLUMN_256_0[0]/RM_IHPSG13_1P_BITKIT_16x2_SRAM_1[0]/A_RWL<5>
+ RM_IHPSG13_1P_BITKIT_16x2_EDGE_LR_7[1]/LWL<10> RM_IHPSG13_1P_BITKIT_16x2_EDGE_LR_7[1]/LWL<4>
+ RM_IHPSG13_1P_COLUMN_256_0[0]/RM_IHPSG13_1P_BITKIT_16x2_SRAM_3[1]/A_RWL<14> RM_IHPSG13_1P_COLUMN_256_0[0]/RM_IHPSG13_1P_BITKIT_16x2_SRAM_3[1]/A_RWL<1>
+ RM_IHPSG13_1P_COLUMN_256_0[0]/RM_IHPSG13_1P_BITKIT_16x2_SRAM_1[0]/A_RWL<13> RM_IHPSG13_1P_BITKIT_16x2_EDGE_LR_6[3]/LWL<11>
+ RM_IHPSG13_1P_COLUMN_256_0[0]/RM_IHPSG13_1P_BITKIT_16x2_SRAM_2[1]/A_RWL<8> RM_IHPSG13_1P_BITKIT_16x2_EDGE_LR_6[0]/LWL<3>
+ RM_IHPSG13_1P_COLUMN_256_0[0]/RM_IHPSG13_1P_BITKIT_16x2_SRAM_2[2]/A_RWL<14> RM_IHPSG13_1P_BITKIT_16x2_EDGE_LR_6[3]/LWL<7>
+ RM_IHPSG13_1P_COLUMN_256_0[0]/RM_IHPSG13_1P_BITKIT_16x2_SRAM_0[0]/A_RWL<3> RM_IHPSG13_1P_BITKIT_16x2_EDGE_LR_7[3]/LWL<9>
+ RM_IHPSG13_1P_BITKIT_16x2_EDGE_LR_5[0]/LWL<2> RM_IHPSG13_1P_COLUMN_256_0[0]/RM_IHPSG13_1P_BITKIT_16x2_SRAM_1[1]/A_RWL<9>
+ RM_IHPSG13_1P_BITKIT_16x2_EDGE_LR_5[3]/LWL<6> RM_IHPSG13_1P_BITKIT_16x2_EDGE_LR_4[2]/LWL<9>
+ RM_IHPSG13_1P_BITKIT_16x2_EDGE_LR_4[1]/LWL<3> RM_IHPSG13_1P_BITKIT_16x2_EDGE_LR_7[0]/LWL<14>
+ RM_IHPSG13_1P_BITKIT_16x2_EDGE_LR_6[0]/LWL<14> RM_IHPSG13_1P_BITKIT_16x2_EDGE_LR_4[3]/LWL<15>
+ RM_IHPSG13_1P_BITKIT_16x2_EDGE_LR_6[2]/LWL<15> RM_IHPSG13_1P_BITKIT_16x2_EDGE_LR_7[1]/LWL<11>
+ RM_IHPSG13_1P_BITKIT_16x2_EDGE_LR_7[1]/LWL<5> RM_IHPSG13_1P_COLUMN_256_0[0]/RM_IHPSG13_1P_BITKIT_16x2_SRAM_1[0]/A_RWL<11>
+ RM_IHPSG13_1P_COLUMN_256_0[0]/RM_IHPSG13_1P_BITKIT_16x2_SRAM_2[2]/A_RWL<0> RM_IHPSG13_1P_BITKIT_16x2_EDGE_LR_6[3]/LWL<1>
+ RM_IHPSG13_1P_COLUMN_256_0[0]/RM_IHPSG13_1P_BITKIT_16x2_SRAM_3[1]/A_RWL<8> RM_IHPSG13_1P_COLUMN_256_0[0]/RM_IHPSG13_1P_BITKIT_16x2_SRAM_0[2]/A_RWL<1>
+ RM_IHPSG13_1P_BITKIT_16x2_EDGE_LR_5[3]/LWL<10> RM_IHPSG13_1P_BITKIT_16x2_EDGE_LR_6[3]/LWL<12>
+ RM_IHPSG13_1P_COLUMN_256_0[0]/RM_IHPSG13_1P_BITKIT_16x2_SRAM_1[2]/A_RWL<1> RM_IHPSG13_1P_COLUMN_256_0[0]/RM_IHPSG13_1P_BITKIT_16x2_SRAM_0[1]/A_RWL<6>
+ RM_IHPSG13_1P_COLUMN_256_0[0]/RM_IHPSG13_1P_BITKIT_16x2_SRAM_2[1]/A_RWL<9> RM_IHPSG13_1P_COLUMN_256_0[0]/RM_IHPSG13_1P_BITKIT_16x2_SRAM_1[1]/A_RWL<11>
+ RM_IHPSG13_1P_COLUMN_256_0[0]/RM_IHPSG13_1P_BITKIT_16x2_SRAM_2[0]/A_RWL<6> RM_IHPSG13_1P_BITKIT_16x2_EDGE_LR_5[1]/LWL<3>
+ RM_IHPSG13_1P_COLUMN_256_0[0]/RM_IHPSG13_1P_BITKIT_16x2_SRAM_2[0]/A_RWL<4> RM_IHPSG13_1P_COLUMN_256_0[0]/RM_IHPSG13_1P_BITKIT_16x2_SRAM_3[3]/A_RWL<7>
+ RM_IHPSG13_1P_BITKIT_16x2_EDGE_LR_7[1]/LWL<2> RM_IHPSG13_1P_COLUMN_256_0[0]/RM_IHPSG13_1P_BITKIT_16x2_SRAM_2[3]/A_RWL<12>
+ RM_IHPSG13_1P_BITKIT_16x2_EDGE_LR_4[1]/LWL<4> RM_IHPSG13_1P_BITKIT_16x2_EDGE_LR_4[0]/LWL<12>
+ RM_IHPSG13_1P_BITKIT_16x2_EDGE_LR_6[1]/LWL<5> RM_IHPSG13_1P_COLUMN_256_0[0]/RM_IHPSG13_1P_BITKIT_16x2_SRAM_3[2]/A_RWL<0>
+ RM_IHPSG13_1P_BITKIT_16x2_EDGE_LR_7[1]/LWL<12> RM_IHPSG13_1P_BITKIT_16x2_EDGE_LR_7[1]/LWL<6>
+ RM_IHPSG13_1P_COLUMN_256_0[0]/RM_IHPSG13_1P_BITKIT_16x2_SRAM_2[2]/A_RWL<1> RM_IHPSG13_1P_COLUMN_256_0[0]/RM_IHPSG13_1P_BITKIT_16x2_SRAM_3[0]/A_RWL<14>
+ RM_IHPSG13_1P_COLUMN_256_0[0]/RM_IHPSG13_1P_BITKIT_16x2_SRAM_1[0]/A_RWL<15> RM_IHPSG13_1P_BITKIT_16x2_EDGE_LR_6[1]/LWL<4>
+ RM_IHPSG13_1P_BITKIT_16x2_EDGE_LR_6[3]/LWL<13> RM_IHPSG13_1P_COLUMN_256_0[0]/RM_IHPSG13_1P_BITKIT_16x2_SRAM_1[2]/A_RWL<2>
+ RM_IHPSG13_1P_COLUMN_256_0[0]/RM_IHPSG13_1P_BITKIT_16x2_SRAM_1[1]/A_RWL<12> RM_IHPSG13_1P_BITKIT_16x2_EDGE_LR_5[0]/LWL<4>
+ RM_IHPSG13_1P_BITKIT_16x2_EDGE_LR_7[2]/LWL<9> RM_IHPSG13_1P_COLUMN_256_0[0]/RM_IHPSG13_1P_BITKIT_16x2_SRAM_0[2]/A_RWL<3>
+ RM_IHPSG13_1P_BITKIT_16x2_EDGE_LR_5[1]/LWL<4> RM_IHPSG13_1P_BITKIT_16x2_EDGE_LR_4[1]/LWL<5>
+ RM_IHPSG13_1P_COLUMN_256_0[0]/RM_IHPSG13_1P_BITKIT_16x2_SRAM_1[2]/A_RWL<0> RM_IHPSG13_1P_COLUMN_256_0[0]/RM_IHPSG13_1P_BITKIT_16x2_SRAM_1[1]/A_RWL<5>
+ RM_IHPSG13_1P_BITKIT_16x2_EDGE_LR_4[2]/LWL<15> RM_IHPSG13_1P_COLUMN_256_0[0]/RM_IHPSG13_1P_BITKIT_16x2_SRAM_3[2]/A_RWL<1>
+ RM_IHPSG13_1P_BITKIT_16x2_EDGE_LR_6[3]/LWL<10> RM_IHPSG13_1P_BITKIT_16x2_EDGE_LR_7[1]/LWL<7>
+ RM_IHPSG13_1P_BITKIT_16x2_EDGE_LR_6[1]/LWL<3> RM_IHPSG13_1P_BITKIT_16x2_EDGE_LR_6[0]/LWL<6>
+ RM_IHPSG13_1P_BITKIT_16x2_EDGE_LR_5[2]/LWL<10> RM_IHPSG13_1P_BITKIT_16x2_EDGE_LR_6[3]/LWL<14>
+ RM_IHPSG13_1P_BITKIT_16x2_EDGE_LR_5[1]/LWL<1> RM_IHPSG13_1P_BITKIT_16x2_EDGE_LR_5[1]/LWL<2>
+ RM_IHPSG13_1P_COLUMN_256_0[0]/RM_IHPSG13_1P_BITKIT_16x2_SRAM_0[0]/A_RWL<6> RM_IHPSG13_1P_COLUMN_256_0[0]/RM_IHPSG13_1P_BITKIT_16x2_SRAM_1[2]/A_RWL<3>
+ RM_IHPSG13_1P_BITKIT_16x2_EDGE_LR_7[2]/LWL<10> RM_IHPSG13_1P_COLUMN_256_0[0]/RM_IHPSG13_1P_BITKIT_16x2_SRAM_1[3]/A_RWL<7>
+ RM_IHPSG13_1P_COLUMN_256_0[0]/RM_IHPSG13_1P_BITKIT_16x2_SRAM_1[1]/A_RWL<13> RM_IHPSG13_1P_COLUMN_256_0[0]/RM_IHPSG13_1P_BITKIT_16x2_SRAM_0[2]/A_RWL<4>
+ RM_IHPSG13_1P_BITKIT_16x2_EDGE_LR_7[0]/LWL<12> RM_IHPSG13_1P_COLUMN_256_0[0]/RM_IHPSG13_1P_BITKIT_16x2_SRAM_2[3]/A_RWL<14>
+ RM_IHPSG13_1P_BITKIT_16x2_EDGE_LR_4[1]/LWL<6> RM_IHPSG13_1P_BITKIT_16x2_EDGE_LR_6[1]/LWL<7>
+ RM_IHPSG13_1P_COLUMN_256_0[0]/RM_IHPSG13_1P_BITKIT_16x2_SRAM_3[2]/A_RWL<2> RM_IHPSG13_1P_COLUMN_256_0[0]/RM_IHPSG13_1P_BITKIT_16x2_SRAM_1[0]/A_RWL<14>
+ RM_IHPSG13_1P_BITKIT_16x2_EDGE_LR_7[1]/LWL<14> RM_IHPSG13_1P_BITKIT_16x2_EDGE_LR_7[1]/LWL<8>
+ RM_IHPSG13_1P_COLUMN_256_0[0]/RM_IHPSG13_1P_BITKIT_16x2_SRAM_2[2]/A_RWL<3> RM_IHPSG13_1P_BITKIT_16x2_EDGE_LR_6[3]/LWL<15>
+ RM_IHPSG13_1P_BITKIT_16x2_EDGE_LR_6[0]/LWL<4> RM_IHPSG13_1P_COLUMN_256_0[0]/RM_IHPSG13_1P_BITKIT_16x2_SRAM_1[2]/A_RWL<4>
+ RM_IHPSG13_1P_COLUMN_256_0[0]/RM_IHPSG13_1P_BITKIT_16x2_SRAM_0[3]/A_RWL<8> RM_IHPSG13_1P_COLUMN_256_0[0]/RM_IHPSG13_1P_BITKIT_16x2_SRAM_2[1]/A_RWL<4>
+ RM_IHPSG13_1P_COLUMN_256_0[0]/RM_IHPSG13_1P_BITKIT_16x2_SRAM_2[0]/A_RWL<13> RM_IHPSG13_1P_COLUMN_256_0[0]/RM_IHPSG13_1P_BITKIT_16x2_SRAM_3[3]/A_RWL<10>
+ RM_IHPSG13_1P_COLUMN_256_0[0]/RM_IHPSG13_1P_BITKIT_16x2_SRAM_1[1]/A_RWL<14> RM_IHPSG13_1P_COLUMN_256_0[0]/RM_IHPSG13_1P_BITKIT_16x2_SRAM_0[2]/A_RWL<5>
+ RM_IHPSG13_1P_COLUMN_256_0[0]/RM_IHPSG13_1P_BITKIT_16x2_SRAM_0[0]/A_RWL<10> RM_IHPSG13_1P_COLUMN_256_0[0]/RM_IHPSG13_1P_BITKIT_16x2_SRAM_2[3]/A_RWL<9>
+ RM_IHPSG13_1P_BITKIT_16x2_EDGE_LR_5[1]/LWL<6> RM_IHPSG13_1P_BITKIT_16x2_EDGE_LR_4[0]/LWL<9>
+ RM_IHPSG13_1P_COLUMN_256_0[0]/RM_IHPSG13_1P_BITKIT_16x2_SRAM_2[3]/A_RWL<15> RM_IHPSG13_1P_COLUMN_256_0[0]/RM_IHPSG13_1P_BITKIT_16x2_SRAM_1[2]/A_RWL<11>
+ RM_IHPSG13_1P_BITKIT_16x2_EDGE_LR_4[0]/LWL<7> RM_IHPSG13_1P_BITKIT_16x2_EDGE_LR_5[3]/LWL<8>
+ RM_IHPSG13_1P_BITKIT_16x2_EDGE_LR_4[1]/LWL<15> RM_IHPSG13_1P_BITKIT_16x2_EDGE_LR_6[2]/LWL<10>
+ RM_IHPSG13_1P_BITKIT_16x2_EDGE_LR_7[1]/LWL<9> RM_IHPSG13_1P_BITKIT_16x2_EDGE_LR_6[1]/LWL<1>
+ RM_IHPSG13_1P_BITKIT_16x2_EDGE_LR_5[1]/LWL<10> RM_IHPSG13_1P_BITKIT_16x2_EDGE_LR_5[0]/LWL<1>
+ RM_IHPSG13_1P_BITKIT_16x2_EDGE_LR_7[2]/LWL<12> RM_IHPSG13_1P_COLUMN_256_0[0]/RM_IHPSG13_1P_BITKIT_16x2_SRAM_1[1]/A_RWL<15>
+ RM_IHPSG13_1P_COLUMN_256_0[0]/RM_IHPSG13_1P_BITKIT_16x2_SRAM_0[2]/A_RWL<6> RM_IHPSG13_1P_COLUMN_256_0[0]/RM_IHPSG13_1P_BITKIT_16x2_SRAM_0[0]/A_RWL<11>
+ RM_IHPSG13_1P_BITKIT_16x2_EDGE_LR_5[1]/LWL<7> RM_IHPSG13_1P_COLUMN_256_0[0]/RM_IHPSG13_1P_BITKIT_16x2_SRAM_3[1]/A_RWL<7>
+ RM_IHPSG13_1P_COLUMN_256_0[0]/RM_IHPSG13_1P_BITKIT_16x2_SRAM_1[2]/A_RWL<5> RM_IHPSG13_1P_BITKIT_16x2_EDGE_LR_6[2]/LWL<0>
+ RM_IHPSG13_1P_COLUMN_256_0[0]/RM_IHPSG13_1P_BITKIT_16x2_SRAM_1[2]/A_RWL<12> RM_IHPSG13_1P_BITKIT_16x2_EDGE_LR_4[1]/LWL<8>
+ RM_IHPSG13_1P_COLUMN_256_0[0]/RM_IHPSG13_1P_BITKIT_16x2_SRAM_2[2]/A_RWL<2> RM_IHPSG13_1P_BITKIT_16x2_EDGE_LR_7[2]/LWL<1>
+ RM_IHPSG13_1P_COLUMN_256_0[0]/RM_IHPSG13_1P_BITKIT_16x2_SRAM_0[3]/A_RWL<15> RM_IHPSG13_1P_BITKIT_16x2_EDGE_LR_6[1]/LWL<9>
+ RM_IHPSG13_1P_COLUMN_256_0[0]/RM_IHPSG13_1P_BITKIT_16x2_SRAM_3[2]/A_RWL<4> RM_IHPSG13_1P_COLUMN_256_0[0]/RM_IHPSG13_1P_BITKIT_16x2_SRAM_3[0]/A_RWL<12>
+ RM_IHPSG13_1P_BITKIT_16x2_EDGE_LR_6[1]/LWL<6> RM_IHPSG13_1P_COLUMN_256_0[0]/RM_IHPSG13_1P_BITKIT_16x2_SRAM_3[3]/A_RWL<8>
+ RM_IHPSG13_1P_COLUMN_256_0[0]/RM_IHPSG13_1P_BITKIT_16x2_SRAM_2[2]/A_RWL<15> RM_IHPSG13_1P_COLUMN_256_0[0]/RM_IHPSG13_1P_BITKIT_16x2_SRAM_2[2]/A_RWL<5>
+ RM_IHPSG13_1P_COLUMN_256_0[0]/RM_IHPSG13_1P_BITKIT_16x2_SRAM_1[2]/A_RWL<6> RM_IHPSG13_1P_COLUMN_256_0[0]/RM_IHPSG13_1P_BITKIT_16x2_SRAM_3[2]/A_RWL<10>
+ RM_IHPSG13_1P_BITKIT_16x2_EDGE_LR_7[0]/LWL<9> RM_IHPSG13_1P_COLUMN_256_0[0]/RM_IHPSG13_1P_BITKIT_16x2_SRAM_0[0]/A_RWL<12>
+ RM_IHPSG13_1P_COLUMN_256_0[0]/RM_IHPSG13_1P_BITKIT_16x2_SRAM_0[2]/A_RWL<7> RM_IHPSG13_1P_BITKIT_16x2_EDGE_LR_6[3]/LWL<8>
+ RM_IHPSG13_1P_BITKIT_16x2_EDGE_LR_7[3]/LWL<10> RM_IHPSG13_1P_BITKIT_16x2_EDGE_LR_6[2]/LWL<1>
+ RM_IHPSG13_1P_BITKIT_16x2_EDGE_LR_4[1]/LWL<9> RM_IHPSG13_1P_COLUMN_256_0[0]/RM_IHPSG13_1P_BITKIT_16x2_SRAM_1[2]/A_RWL<13>
+ RM_IHPSG13_1P_BITKIT_16x2_EDGE_LR_7[1]/LWL<15> RM_IHPSG13_1P_BITKIT_16x2_EDGE_LR_5[2]/LWL<8>
+ RM_IHPSG13_1P_BITKIT_16x2_EDGE_LR_7[2]/LWL<2> RM_IHPSG13_1P_BITKIT_16x2_EDGE_LR_4[0]/LWL<15>
+ RM_IHPSG13_1P_BITKIT_16x2_EDGE_LR_4[3]/LWL<13> RM_IHPSG13_1P_COLUMN_256_0[0]/RM_IHPSG13_1P_BITKIT_16x2_SRAM_3[2]/A_RWL<5>
+ RM_IHPSG13_1P_COLUMN_256_0[0]/RM_IHPSG13_1P_BITKIT_16x2_SRAM_1[3]/A_RWL<10> RM_IHPSG13_1P_BITKIT_16x2_EDGE_LR_6[1]/LWL<10>
+ RM_IHPSG13_1P_COLUMN_256_0[0]/RM_IHPSG13_1P_BITKIT_16x2_SRAM_0[0]/A_RWL<9> RM_IHPSG13_1P_BITKIT_16x2_EDGE_LR_6[0]/LWL<1>
+ RM_IHPSG13_1P_COLUMN_256_0[0]/RM_IHPSG13_1P_BITKIT_16x2_SRAM_2[2]/A_RWL<6> RM_IHPSG13_1P_COLUMN_256_0[0]/RM_IHPSG13_1P_BITKIT_16x2_SRAM_2[2]/A_RWL<4>
+ RM_IHPSG13_1P_COLUMN_256_0[0]/RM_IHPSG13_1P_BITKIT_16x2_SRAM_2[1]/A_RWL<13> RM_IHPSG13_1P_BITKIT_16x2_EDGE_LR_7[3]/LWL<2>
+ RM_IHPSG13_1P_BITKIT_16x2_EDGE_LR_4[3]/LWL<0> RM_IHPSG13_1P_BITKIT_16x2_EDGE_LR_5[2]/LWL<0>
+ RM_IHPSG13_1P_COLUMN_256_0[0]/RM_IHPSG13_1P_BITKIT_16x2_SRAM_1[2]/A_RWL<7> RM_IHPSG13_1P_BITKIT_16x2_EDGE_LR_7[2]/LWL<14>
+ RM_IHPSG13_1P_COLUMN_256_0[0]/RM_IHPSG13_1P_BITKIT_16x2_SRAM_1[1]/A_RWL<7> RM_IHPSG13_1P_BITKIT_16x2_EDGE_LR_4[2]/LWL<1>
+ RM_IHPSG13_1P_COLUMN_256_0[0]/RM_IHPSG13_1P_BITKIT_16x2_SRAM_0[0]/A_RWL<13> RM_IHPSG13_1P_BITKIT_16x2_EDGE_LR_4[1]/LWL<7>
+ RM_IHPSG13_1P_COLUMN_256_0[0]/RM_IHPSG13_1P_BITKIT_16x2_SRAM_0[2]/A_RWL<8> RM_IHPSG13_1P_COLUMN_256_0[0]/RM_IHPSG13_1P_BITKIT_16x2_SRAM_3[0]/A_RWL<7>
+ RM_IHPSG13_1P_BITKIT_16x2_EDGE_LR_5[1]/LWL<9> RM_IHPSG13_1P_BITKIT_16x2_EDGE_LR_5[3]/LWL<5>
+ RM_IHPSG13_1P_COLUMN_256_0[0]/RM_IHPSG13_1P_BITKIT_16x2_SRAM_0[2]/A_RWL<2> RM_IHPSG13_1P_BITKIT_16x2_EDGE_LR_6[2]/LWL<2>
+ RM_IHPSG13_1P_COLUMN_256_0[0]/RM_IHPSG13_1P_BITKIT_16x2_SRAM_1[2]/A_RWL<14> RM_IHPSG13_1P_COLUMN_256_0[0]/RM_IHPSG13_1P_BITKIT_16x2_SRAM_2[1]/A_RWL<2>
+ RM_IHPSG13_1P_COLUMN_256_0[0]/RM_IHPSG13_1P_BITKIT_16x2_SRAM_0[1]/A_RWL<10> RM_IHPSG13_1P_BITKIT_16x2_EDGE_LR_7[2]/LWL<3>
+ RM_IHPSG13_1P_COLUMN_256_0[0]/RM_IHPSG13_1P_BITKIT_16x2_SRAM_0[2]/A_RWL<15> RM_IHPSG13_1P_COLUMN_256_0[0]/RM_IHPSG13_1P_BITKIT_16x2_SRAM_3[2]/A_RWL<6>
+ RM_IHPSG13_1P_COLUMN_256_0[0]/RM_IHPSG13_1P_BITKIT_16x2_SRAM_1[3]/A_RWL<11> RM_IHPSG13_1P_COLUMN_256_0[0]/RM_IHPSG13_1P_BITKIT_16x2_SRAM_2[1]/A_RWL<15>
+ RM_IHPSG13_1P_COLUMN_256_0[0]/RM_IHPSG13_1P_BITKIT_16x2_SRAM_2[2]/A_RWL<7> RM_IHPSG13_1P_COLUMN_256_0[0]/RM_IHPSG13_1P_BITKIT_16x2_SRAM_1[2]/A_RWL<10>
+ RM_IHPSG13_1P_COLUMN_256_0[0]/RM_IHPSG13_1P_BITKIT_16x2_SRAM_0[3]/A_RWL<0> RM_IHPSG13_1P_COLUMN_256_0[0]/RM_IHPSG13_1P_BITKIT_16x2_SRAM_1[0]/A_RWL<1>
+ RM_IHPSG13_1P_BITKIT_16x2_EDGE_LR_5[2]/LWL<1> RM_IHPSG13_1P_COLUMN_256_0[0]/RM_IHPSG13_1P_BITKIT_16x2_SRAM_1[2]/A_RWL<8>
+ RM_IHPSG13_1P_BITKIT_16x2_EDGE_LR_7[2]/LWL<15> RM_IHPSG13_1P_COLUMN_256_0[0]/RM_IHPSG13_1P_BITKIT_16x2_SRAM_1[3]/A_RWL<5>
+ RM_IHPSG13_1P_COLUMN_256_0[0]/RM_IHPSG13_1P_BITKIT_16x2_SRAM_3[1]/A_RWL<10> RM_IHPSG13_1P_COLUMN_256_0[0]/RM_IHPSG13_1P_BITKIT_16x2_SRAM_0[0]/A_RWL<14>
+ RM_IHPSG13_1P_BITKIT_16x2_EDGE_LR_4[2]/LWL<2> RM_IHPSG13_1P_BITKIT_16x2_EDGE_LR_6[2]/LWL<8>
+ RM_IHPSG13_1P_COLUMN_256_0[0]/RM_IHPSG13_1P_BITKIT_16x2_SRAM_1[0]/A_RWL<8> RM_IHPSG13_1P_BITKIT_16x2_EDGE_LR_7[3]/LWL<12>
+ RM_IHPSG13_1P_BITKIT_16x2_EDGE_LR_6[2]/LWL<3> RM_IHPSG13_1P_BITKIT_16x2_EDGE_LR_5[1]/LWL<8>
+ RM_IHPSG13_1P_COLUMN_256_0[0]/RM_IHPSG13_1P_BITKIT_16x2_SRAM_3[1]/A_RWL<12> RM_IHPSG13_1P_BITKIT_16x2_EDGE_LR_6[3]/LWL<3>
+ RM_IHPSG13_1P_COLUMN_256_0[0]/RM_IHPSG13_1P_BITKIT_16x2_SRAM_1[2]/A_RWL<15> RM_IHPSG13_1P_BITKIT_16x2_EDGE_LR_7[0]/LWL<15>
+ RM_IHPSG13_1P_COLUMN_256_0[0]/RM_IHPSG13_1P_BITKIT_16x2_SRAM_3[0]/A_RWL<9> RM_IHPSG13_1P_COLUMN_256_0[0]/RM_IHPSG13_1P_BITKIT_16x2_SRAM_0[1]/A_RWL<11>
+ RM_IHPSG13_1P_BITKIT_16x2_EDGE_LR_5[3]/LWL<2> RM_IHPSG13_1P_BITKIT_16x2_EDGE_LR_7[2]/LWL<4>
+ RM_IHPSG13_1P_BITKIT_16x2_EDGE_LR_4[2]/LWL<13> RM_IHPSG13_1P_COLUMN_256_0[0]/RM_IHPSG13_1P_BITKIT_16x2_SRAM_3[2]/A_RWL<7>
+ RM_IHPSG13_1P_COLUMN_256_0[0]/RM_IHPSG13_1P_BITKIT_16x2_SRAM_1[3]/A_RWL<12> RM_IHPSG13_1P_BITKIT_16x2_EDGE_LR_7[3]/LWL<0>
+ RM_IHPSG13_1P_BITKIT_16x2_EDGE_LR_6[0]/LWL<10> RM_IHPSG13_1P_COLUMN_256_0[0]/RM_IHPSG13_1P_BITKIT_16x2_SRAM_1[3]/A_RWL<0>
+ RM_IHPSG13_1P_COLUMN_256_0[0]/RM_IHPSG13_1P_BITKIT_16x2_SRAM_2[2]/A_RWL<8> RM_IHPSG13_1P_BITKIT_16x2_EDGE_LR_4[3]/LWL<11>
+ RM_IHPSG13_1P_BITKIT_16x2_EDGE_LR_4[2]/LWL<0> RM_IHPSG13_1P_COLUMN_256_0[0]/RM_IHPSG13_1P_BITKIT_16x2_SRAM_0[3]/A_RWL<1>
+ RM_IHPSG13_1P_BITKIT_16x2_EDGE_LR_5[2]/LWL<2> RM_IHPSG13_1P_COLUMN_256_0[0]/RM_IHPSG13_1P_BITKIT_16x2_SRAM_1[2]/A_RWL<9>
+ RM_IHPSG13_1P_COLUMN_256_0[0]/RM_IHPSG13_1P_BITKIT_16x2_SRAM_1[0]/A_RWL<7> RM_IHPSG13_1P_BITKIT_16x2_EDGE_LR_6[3]/LWL<5>
+ RM_IHPSG13_1P_BITKIT_16x2_EDGE_LR_4[2]/LWL<3> RM_IHPSG13_1P_COLUMN_256_0[0]/RM_IHPSG13_1P_BITKIT_16x2_SRAM_0[1]/A_RWL<2>
+ RM_IHPSG13_1P_BITKIT_16x2_EDGE_LR_7[3]/LWL<13> RM_IHPSG13_1P_BITKIT_16x2_EDGE_LR_6[2]/LWL<4>
+ RM_IHPSG13_1P_COLUMN_256_0[0]/RM_IHPSG13_1P_BITKIT_16x2_SRAM_2[0]/A_RWL<2> RM_IHPSG13_1P_COLUMN_256_0[0]/RM_IHPSG13_1P_BITKIT_16x2_SRAM_0[1]/A_RWL<12>
+ RM_IHPSG13_1P_COLUMN_256_0[0]/RM_IHPSG13_1P_BITKIT_16x2_SRAM_2[0]/A_RWL<0> RM_IHPSG13_1P_COLUMN_256_0[0]/RM_IHPSG13_1P_BITKIT_16x2_SRAM_3[3]/A_RWL<3>
+ RM_IHPSG13_1P_COLUMN_256_0[0]/RM_IHPSG13_1P_BITKIT_16x2_SRAM_0[1]/A_RWL<9> RM_IHPSG13_1P_BITKIT_16x2_EDGE_LR_7[2]/LWL<5>
+ RM_IHPSG13_1P_COLUMN_256_0[0]/RM_IHPSG13_1P_BITKIT_16x2_SRAM_2[3]/A_RWL<4> RM_IHPSG13_1P_COLUMN_256_0[0]/RM_IHPSG13_1P_BITKIT_16x2_SRAM_2[3]/A_RWL<0>
+ RM_IHPSG13_1P_COLUMN_256_0[0]/RM_IHPSG13_1P_BITKIT_16x2_SRAM_3[2]/A_RWL<8> RM_IHPSG13_1P_COLUMN_256_0[0]/RM_IHPSG13_1P_BITKIT_16x2_SRAM_2[2]/A_RWL<13>
+ RM_IHPSG13_1P_COLUMN_256_0[0]/RM_IHPSG13_1P_BITKIT_16x2_SRAM_1[3]/A_RWL<13> RM_IHPSG13_1P_COLUMN_256_0[0]/RM_IHPSG13_1P_BITKIT_16x2_SRAM_2[0]/A_RWL<15>
+ RM_IHPSG13_1P_COLUMN_256_0[0]/RM_IHPSG13_1P_BITKIT_16x2_SRAM_1[3]/A_RWL<1> RM_IHPSG13_1P_COLUMN_256_0[0]/RM_IHPSG13_1P_BITKIT_16x2_SRAM_2[2]/A_RWL<9>
+ RM_IHPSG13_1P_COLUMN_256_0[0]/RM_IHPSG13_1P_BITKIT_16x2_SRAM_1[1]/A_RWL<10> RM_IHPSG13_1P_BITKIT_16x2_EDGE_LR_4[2]/LWL<7>
+ RM_IHPSG13_1P_COLUMN_256_0[0]/RM_IHPSG13_1P_BITKIT_16x2_SRAM_0[3]/A_RWL<2> RM_IHPSG13_1P_BITKIT_16x2_EDGE_LR_5[2]/LWL<3>
+ RM_IHPSG13_1P_COLUMN_256_0[0]/RM_IHPSG13_1P_BITKIT_16x2_SRAM_3[0]/A_RWL<10> RM_IHPSG13_1P_BITKIT_16x2_EDGE_LR_4[2]/LWL<4>
+ RM_IHPSG13_1P_BITKIT_16x2_EDGE_LR_6[1]/LWL<8> RM_IHPSG13_1P_BITKIT_16x2_EDGE_LR_7[3]/LWL<14>
+ RM_IHPSG13_1P_BITKIT_16x2_EDGE_LR_5[0]/LWL<8> RM_IHPSG13_1P_COLUMN_256_0[0]/RM_IHPSG13_1P_BITKIT_16x2_SRAM_3[3]/A_RWL<0>
+ RM_IHPSG13_1P_BITKIT_16x2_EDGE_LR_7[2]/LWL<13> RM_IHPSG13_1P_COLUMN_256_0[0]/RM_IHPSG13_1P_BITKIT_16x2_SRAM_0[1]/A_RWL<13>
+ RM_IHPSG13_1P_BITKIT_16x2_EDGE_LR_5[0]/LWL<10> RM_IHPSG13_1P_BITKIT_16x2_EDGE_LR_4[1]/LWL<13>
+ RM_IHPSG13_1P_BITKIT_16x2_EDGE_LR_7[2]/LWL<6> RM_IHPSG13_1P_COLUMN_256_0[0]/RM_IHPSG13_1P_BITKIT_16x2_SRAM_2[3]/A_RWL<1>
+ RM_IHPSG13_1P_COLUMN_256_0[0]/RM_IHPSG13_1P_BITKIT_16x2_SRAM_3[2]/A_RWL<9> RM_IHPSG13_1P_BITKIT_16x2_EDGE_LR_7[3]/LWL<11>
+ RM_IHPSG13_1P_COLUMN_256_0[0]/RM_IHPSG13_1P_BITKIT_16x2_SRAM_1[3]/A_RWL<14> RM_IHPSG13_1P_BITKIT_16x2_EDGE_LR_7[2]/LWL<0>
+ RM_IHPSG13_1P_COLUMN_256_0[0]/RM_IHPSG13_1P_BITKIT_16x2_SRAM_1[1]/A_RWL<1> RM_IHPSG13_1P_COLUMN_256_0[0]/RM_IHPSG13_1P_BITKIT_16x2_SRAM_0[2]/A_RWL<10>
+ RM_IHPSG13_1P_COLUMN_256_0[0]/RM_IHPSG13_1P_BITKIT_16x2_SRAM_1[3]/A_RWL<2> RM_IHPSG13_1P_BITKIT_16x2_EDGE_LR_4[2]/LWL<11>
+ RM_IHPSG13_1P_BITKIT_16x2_EDGE_LR_4[1]/LWL<0> RM_IHPSG13_1P_COLUMN_256_0[0]/RM_IHPSG13_1P_BITKIT_16x2_SRAM_0[3]/A_RWL<3>
+ RM_IHPSG13_1P_BITKIT_16x2_EDGE_LR_5[2]/LWL<4> RM_IHPSG13_1P_COLUMN_256_0[0]/RM_IHPSG13_1P_BITKIT_16x2_SRAM_1[1]/A_RWL<8>
+ RM_IHPSG13_1P_BITKIT_16x2_EDGE_LR_6[2]/LWL<5> RM_IHPSG13_1P_BITKIT_16x2_EDGE_LR_6[0]/LWL<2>
+ RM_IHPSG13_1P_COLUMN_256_0[0]/RM_IHPSG13_1P_BITKIT_16x2_SRAM_3[2]/A_RWL<12> RM_IHPSG13_1P_BITKIT_16x2_EDGE_LR_4[2]/LWL<5>
+ RM_IHPSG13_1P_BITKIT_16x2_EDGE_LR_6[3]/LWL<6> RM_IHPSG13_1P_COLUMN_256_0[0]/RM_IHPSG13_1P_BITKIT_16x2_SRAM_3[1]/A_RWL<9>
+ RM_IHPSG13_1P_BITKIT_16x2_EDGE_LR_5[1]/LWL<5> RM_IHPSG13_1P_COLUMN_256_0[0]/RM_IHPSG13_1P_BITKIT_16x2_SRAM_0[0]/A_RWL<2>
+ RM_IHPSG13_1P_BITKIT_16x2_EDGE_LR_7[3]/LWL<15> RM_IHPSG13_1P_BITKIT_16x2_EDGE_LR_6[2]/LWL<6>
+ RM_IHPSG13_1P_COLUMN_256_0[0]/RM_IHPSG13_1P_BITKIT_16x2_SRAM_3[3]/A_RWL<1> RM_IHPSG13_1P_COLUMN_256_0[0]/RM_IHPSG13_1P_BITKIT_16x2_SRAM_0[1]/A_RWL<14>
+ RM_IHPSG13_1P_COLUMN_256_0[0]/RM_IHPSG13_1P_BITKIT_16x2_SRAM_3[2]/A_RWL<3> RM_IHPSG13_1P_BITKIT_16x2_EDGE_LR_5[0]/LWL<11>
+ RM_IHPSG13_1P_BITKIT_16x2_EDGE_LR_7[2]/LWL<7> RM_IHPSG13_1P_COLUMN_256_0[0]/RM_IHPSG13_1P_BITKIT_16x2_SRAM_0[0]/A_RWL<15>
+ RM_IHPSG13_1P_COLUMN_256_0[0]/RM_IHPSG13_1P_BITKIT_16x2_SRAM_2[3]/A_RWL<2> RM_IHPSG13_1P_BITKIT_16x2_EDGE_LR_4[3]/LWL<14>
+ RM_IHPSG13_1P_COLUMN_256_0[0]/RM_IHPSG13_1P_BITKIT_16x2_SRAM_1[3]/A_RWL<15> RM_IHPSG13_1P_COLUMN_256_0[0]/RM_IHPSG13_1P_BITKIT_16x2_SRAM_0[2]/A_RWL<11>
+ RM_IHPSG13_1P_COLUMN_256_0[0]/RM_IHPSG13_1P_BITKIT_16x2_SRAM_1[3]/A_RWL<3> RM_IHPSG13_1P_COLUMN_256_0[0]/RM_IHPSG13_1P_BITKIT_16x2_SRAM_1[0]/A_RWL<10>
+ RM_IHPSG13_1P_COLUMN_256_0[0]/RM_IHPSG13_1P_BITKIT_16x2_SRAM_0[3]/A_RWL<4> RM_IHPSG13_1P_COLUMN_256_0[0]/RM_IHPSG13_1P_BITKIT_16x2_SRAM_2[3]/A_RWL<11>
+ RM_IHPSG13_1P_BITKIT_16x2_EDGE_LR_5[2]/LWL<5> RM_IHPSG13_1P_COLUMN_256_0[0]/RM_IHPSG13_1P_BITKIT_16x2_SRAM_0[0]/A_RWL<4>
+ RM_IHPSG13_1P_BITKIT_16x2_EDGE_LR_4[2]/LWL<6> RM_IHPSG13_1P_BITKIT_16x2_EDGE_LR_6[0]/LWL<8>
+ RM_IHPSG13_1P_COLUMN_256_0[0]/RM_IHPSG13_1P_BITKIT_16x2_SRAM_0[3]/A_RWL<12> RM_IHPSG13_1P_COLUMN_256_0[0]/RM_IHPSG13_1P_BITKIT_16x2_SRAM_2[1]/A_RWL<0>
+ RM_IHPSG13_1P_COLUMN_256_0[0]/RM_IHPSG13_1P_BITKIT_16x2_SRAM_3[3]/A_RWL<6> RM_IHPSG13_1P_COLUMN_256_0[0]/RM_IHPSG13_1P_BITKIT_16x2_SRAM_2[0]/A_RWL<5>
+ RM_IHPSG13_1P_COLUMN_256_0[0]/RM_IHPSG13_1P_BITKIT_16x2_SRAM_0[2]/A_RWL<9> RM_IHPSG13_1P_BITKIT_16x2_EDGE_LR_6[2]/LWL<7>
+ RM_IHPSG13_1P_BITKIT_16x2_EDGE_LR_7[1]/LWL<13> RM_IHPSG13_1P_COLUMN_256_0[0]/RM_IHPSG13_1P_BITKIT_16x2_SRAM_3[3]/A_RWL<2>
+ RM_IHPSG13_1P_COLUMN_256_0[0]/RM_IHPSG13_1P_BITKIT_16x2_SRAM_2[3]/A_RWL<13> RM_IHPSG13_1P_COLUMN_256_0[0]/RM_IHPSG13_1P_BITKIT_16x2_SRAM_0[1]/A_RWL<15>
+ RM_IHPSG13_1P_BITKIT_16x2_EDGE_LR_5[0]/LWL<12> RM_IHPSG13_1P_BITKIT_16x2_EDGE_LR_7[2]/LWL<8>
+ RM_IHPSG13_1P_BITKIT_16x2_EDGE_LR_4[0]/LWL<13> RM_IHPSG13_1P_COLUMN_256_0[0]/RM_IHPSG13_1P_BITKIT_16x2_SRAM_2[3]/A_RWL<3>
+ RM_IHPSG13_1P_BITKIT_16x2_EDGE_LR_7[2]/LWL<11> RM_IHPSG13_1P_BITKIT_16x2_EDGE_LR_5[3]/LWL<12>
+ RM_IHPSG13_1P_BITKIT_16x2_EDGE_LR_4[0]/LWL<3> RM_IHPSG13_1P_BITKIT_16x2_EDGE_LR_7[1]/LWL<0>
+ RM_IHPSG13_1P_BITKIT_16x2_EDGE_LR_4[3]/LWL<7> RM_IHPSG13_1P_COLUMN_256_0[0]/RM_IHPSG13_1P_BITKIT_16x2_SRAM_0[2]/A_RWL<12>
+ RM_IHPSG13_1P_COLUMN_256_0[0]/RM_IHPSG13_1P_BITKIT_16x2_SRAM_1[3]/A_RWL<4> RM_IHPSG13_1P_BITKIT_16x2_EDGE_LR_4[1]/LWL<11>
+ RM_IHPSG13_1P_BITKIT_16x2_EDGE_LR_4[0]/LWL<0> RM_IHPSG13_1P_COLUMN_256_0[7]/RM_IHPSG13_1P_BITKIT_16x2_SRAM_3[3]/VSS
+ RM_IHPSG13_1P_COLUMN_256_0[0]/RM_IHPSG13_1P_BITKIT_16x2_SRAM_0[3]/A_RWL<5> RM_IHPSG13_1P_COLUMN_256_0[7]/RM_IHPSG13_1P_BITKIT_16x2_SRAM_3[3]/VDD
+ RM_IHPSG13_1P_BITKIT_16x2_EDGE_LR_5[2]/LWL<6> RM_IHPSG13_1P_COLUMN_256
XRM_IHPSG13_1P_COLUMN_256_0[1] RM_IHPSG13_1P_COLUMN_256_0[1]/RM_IHPSG13_1P_BITKIT_16x2_SRAM_0[0]/A_BLT_BOT<0>
+ RM_IHPSG13_1P_COLUMN_256_0[1]/RM_IHPSG13_1P_BITKIT_16x2_SRAM_0[0]/A_BLT_BOT<1> RM_IHPSG13_1P_COLUMN_256_0[1]/RM_IHPSG13_1P_BITKIT_16x2_SRAM_0[0]/A_BLC_BOT<0>
+ RM_IHPSG13_1P_COLUMN_256_0[1]/RM_IHPSG13_1P_BITKIT_16x2_SRAM_1[3]/A_RWL<6> RM_IHPSG13_1P_COLUMN_256_0[1]/RM_IHPSG13_1P_BITKIT_16x2_SRAM_0[3]/A_RWL<11>
+ RM_IHPSG13_1P_COLUMN_256_0[1]/RM_IHPSG13_1P_BITKIT_16x2_SRAM_0[0]/A_BLC_BOT<1> RM_IHPSG13_1P_COLUMN_256_0[1]/RM_IHPSG13_1P_BITKIT_16x2_SRAM_3[1]/A_LWL<12>
+ RM_IHPSG13_1P_COLUMN_256_0[1]/RM_IHPSG13_1P_BITKIT_16x2_SRAM_1[3]/A_RWL<8> RM_IHPSG13_1P_COLUMN_256_0[1]/RM_IHPSG13_1P_BITKIT_16x2_SRAM_0[3]/A_RWL<9>
+ RM_IHPSG13_1P_COLUMN_256_0[1]/RM_IHPSG13_1P_BITKIT_16x2_SRAM_0[3]/A_LWL<4> RM_IHPSG13_1P_COLUMN_256_0[1]/RM_IHPSG13_1P_BITKIT_16x2_SRAM_3[2]/A_LWL<9>
+ RM_IHPSG13_1P_COLUMN_256_0[1]/RM_IHPSG13_1P_BITKIT_16x2_SRAM_2[3]/A_LWL<1> RM_IHPSG13_1P_COLUMN_256_0[1]/RM_IHPSG13_1P_BITKIT_16x2_SRAM_0[3]/A_RWL<14>
+ RM_IHPSG13_1P_COLUMN_256_0[1]/RM_IHPSG13_1P_BITKIT_16x2_SRAM_0[2]/A_RWL<14> RM_IHPSG13_1P_COLUMN_256_0[1]/RM_IHPSG13_1P_BITKIT_16x2_SRAM_2[0]/A_LWL<11>
+ RM_IHPSG13_1P_COLUMN_256_0[1]/RM_IHPSG13_1P_BITKIT_16x2_SRAM_2[3]/A_LWL<4> RM_IHPSG13_1P_COLUMN_256_0[1]/RM_IHPSG13_1P_BITKIT_16x2_SRAM_3[2]/A_LWL<12>
+ RM_IHPSG13_1P_COLUMN_256_0[1]/RM_IHPSG13_1P_BITKIT_16x2_SRAM_1[2]/A_LWL<9> RM_IHPSG13_1P_COLUMN_256_0[1]/RM_IHPSG13_1P_BITKIT_16x2_SRAM_3[3]/A_RWL<9>
+ RM_IHPSG13_1P_COLUMN_256_0[1]/RM_IHPSG13_1P_BITKIT_16x2_SRAM_1[3]/A_LWL<2> RM_IHPSG13_1P_COLUMN_256_0[1]/RM_IHPSG13_1P_BITKIT_16x2_SRAM_0[3]/A_LWL<1>
+ RM_IHPSG13_1P_COLUMN_256_0[1]/RM_IHPSG13_1P_BITKIT_16x2_SRAM_2[3]/A_RWL<7> RM_IHPSG13_1P_COLUMN_256_0[1]/RM_IHPSG13_1P_BITKIT_16x2_SRAM_0[0]/A_RWL<0>
+ RM_IHPSG13_1P_COLUMN_256_0[1]/RM_IHPSG13_1P_BITKIT_16x2_SRAM_2[0]/A_RWL<1> RM_IHPSG13_1P_COLUMN_256_0[1]/RM_IHPSG13_1P_BITKIT_16x2_SRAM_0[2]/A_RWL<13>
+ RM_IHPSG13_1P_COLUMN_256_0[1]/RM_IHPSG13_1P_BITKIT_16x2_SRAM_2[3]/A_RWL<5> RM_IHPSG13_1P_COLUMN_256_0[1]/RM_IHPSG13_1P_BITKIT_16x2_SRAM_2[3]/A_LWL<3>
+ RM_IHPSG13_1P_COLUMN_256_0[1]/RM_IHPSG13_1P_BITKIT_16x2_SRAM_3[0]/A_RWL<13> RM_IHPSG13_1P_COLUMN_256_0[1]/RM_IHPSG13_1P_BITKIT_16x2_SRAM_1[0]/A_RWL<3>
+ RM_IHPSG13_1P_COLUMN_256_0[1]/RM_IHPSG13_1P_BITKIT_16x2_SRAM_3[1]/A_LWL<15> RM_IHPSG13_1P_COLUMN_256_0[1]/RM_IHPSG13_1P_BITKIT_16x2_SRAM_2[0]/A_LWL<14>
+ RM_IHPSG13_1P_COLUMN_256_0[1]/RM_IHPSG13_1P_BITKIT_16x2_SRAM_0[3]/A_RWL<7> RM_IHPSG13_1P_COLUMN_256_0[1]/RM_IHPSG13_1P_BITKIT_16x2_SRAM_3[0]/A_RWL<0>
+ RM_IHPSG13_1P_COLUMN_256_0[1]/RM_IHPSG13_1P_BITKIT_16x2_SRAM_3[2]/A_LWL<15> RM_IHPSG13_1P_COLUMN_256_0[1]/RM_IHPSG13_1P_BITKIT_16x2_SRAM_3[3]/A_RWL<4>
+ RM_IHPSG13_1P_COLUMN_256_0[1]/RM_IHPSG13_1P_BITKIT_16x2_SRAM_3[2]/A_LWL<7> RM_IHPSG13_1P_COLUMN_256_0[1]/RM_IHPSG13_1P_BITKIT_16x2_SRAM_0[0]/A_LWL<0>
+ RM_IHPSG13_1P_COLUMN_256_0[1]/RM_IHPSG13_1P_BITKIT_16x2_SRAM_1[3]/A_LWL<9> RM_IHPSG13_1P_COLUMN_256_0[1]/RM_IHPSG13_1P_BITKIT_16x2_SRAM_3[0]/A_RWL<3>
+ RM_IHPSG13_1P_COLUMN_256_0[1]/RM_IHPSG13_1P_BITKIT_16x2_SRAM_0[0]/A_RWL<5> RM_IHPSG13_1P_COLUMN_256_0[1]/RM_IHPSG13_1P_BITKIT_16x2_SRAM_0[3]/A_RWL<13>
+ RM_IHPSG13_1P_COLUMN_256_0[1]/RM_IHPSG13_1P_BITKIT_16x2_SRAM_2[3]/A_LWL<8> RM_IHPSG13_1P_COLUMN_256_0[1]/RM_IHPSG13_1P_BITKIT_16x2_SRAM_0[3]/A_LWL<7>
+ RM_IHPSG13_1P_COLUMN_256_0[1]/RM_IHPSG13_1P_BITKIT_16x2_SRAM_3[0]/A_LWL<15> RM_IHPSG13_1P_COLUMN_256_0[1]/RM_IHPSG13_1P_BITKIT_16x2_SRAM_3[3]/A_LWL<13>
+ RM_IHPSG13_1P_COLUMN_256_0[1]/RM_IHPSG13_1P_BITKIT_16x2_SRAM_2[3]/A_LWL<6> RM_IHPSG13_1P_COLUMN_256_0[1]/RM_IHPSG13_1P_BITKIT_16x2_SRAM_2[1]/A_LWL<10>
+ RM_IHPSG13_1P_COLUMN_256_0[1]/RM_IHPSG13_1P_BITKIT_16x2_SRAM_3[3]/A_LWL<0> RM_IHPSG13_1P_COLUMN_256_0[1]/RM_IHPSG13_1P_BITKIT_16x2_SRAM_3[0]/A_RWL<4>
+ RM_IHPSG13_1P_COLUMN_256_0[1]/RM_IHPSG13_1P_BITKIT_16x2_SRAM_2[2]/A_LWL<10> RM_IHPSG13_1P_COLUMN_256_0[1]/RM_IHPSG13_1P_BITKIT_16x2_SRAM_3[1]/A_RWL<13>
+ RM_IHPSG13_1P_COLUMN_256_0[1]/RM_IHPSG13_1P_BITKIT_16x2_SRAM_1[0]/A_RWL<6> RM_IHPSG13_1P_COLUMN_256_0[1]/RM_IHPSG13_1P_BITKIT_16x2_SRAM_3[3]/A_LWL<9>
+ RM_IHPSG13_1P_COLUMN_256_0[1]/RM_IHPSG13_1P_BITKIT_16x2_SRAM_1[0]/A_RWL<4> RM_IHPSG13_1P_COLUMN_256_0[1]/RM_IHPSG13_1P_BITKIT_16x2_SRAM_0[3]/A_RWL<10>
+ RM_IHPSG13_1P_COLUMN_256_0[1]/RM_IHPSG13_1P_BITKIT_16x2_SRAM_2[1]/A_LWL<14> RM_IHPSG13_1P_COLUMN_256_0[1]/RM_IHPSG13_1P_BITKIT_16x2_SRAM_3[0]/A_RWL<5>
+ RM_IHPSG13_1P_COLUMN_256_0[1]/RM_IHPSG13_1P_BITKIT_16x2_SRAM_0[3]/A_LWL<8> RM_IHPSG13_1P_COLUMN_256_0[1]/RM_IHPSG13_1P_BITKIT_16x2_SRAM_3[3]/A_LWL<7>
+ RM_IHPSG13_1P_COLUMN_256_0[1]/RM_IHPSG13_1P_BITKIT_16x2_SRAM_2[2]/A_LWL<8> RM_IHPSG13_1P_COLUMN_256_0[1]/RM_IHPSG13_1P_BITKIT_16x2_SRAM_3[3]/A_LWL<15>
+ RM_IHPSG13_1P_COLUMN_256_0[1]/RM_IHPSG13_1P_BITKIT_16x2_SRAM_3[2]/A_LWL<13> RM_IHPSG13_1P_COLUMN_256_0[1]/RM_IHPSG13_1P_BITKIT_16x2_SRAM_2[0]/A_LWL<1>
+ RM_IHPSG13_1P_COLUMN_256_0[1]/RM_IHPSG13_1P_BITKIT_16x2_SRAM_0[0]/A_LWL<1> RM_IHPSG13_1P_COLUMN_256_0[1]/RM_IHPSG13_1P_BITKIT_16x2_SRAM_1[3]/A_LWL<0>
+ RM_IHPSG13_1P_COLUMN_256_0[1]/RM_IHPSG13_1P_BITKIT_16x2_SRAM_2[0]/A_LWL<10> RM_IHPSG13_1P_COLUMN_256_0[1]/RM_IHPSG13_1P_BITKIT_16x2_SRAM_3[3]/A_LWL<11>
+ RM_IHPSG13_1P_COLUMN_256_0[1]/RM_IHPSG13_1P_BITKIT_16x2_SRAM_0[0]/A_LWL<3> RM_IHPSG13_1P_COLUMN_256_0[1]/RM_IHPSG13_1P_BITKIT_16x2_SRAM_3[0]/A_RWL<6>
+ RM_IHPSG13_1P_COLUMN_256_0[1]/RM_IHPSG13_1P_BITKIT_16x2_SRAM_2[3]/A_LWL<5> RM_IHPSG13_1P_COLUMN_256_0[1]/RM_IHPSG13_1P_BITKIT_16x2_SRAM_2[0]/A_RWL<7>
+ RM_IHPSG13_1P_COLUMN_256_0[1]/RM_IHPSG13_1P_BITKIT_16x2_SRAM_3[1]/A_RWL<15> RM_IHPSG13_1P_COLUMN_256_0[1]/RM_IHPSG13_1P_BITKIT_16x2_SRAM_0[1]/A_RWL<0>
+ RM_IHPSG13_1P_COLUMN_256_0[1]/RM_IHPSG13_1P_BITKIT_16x2_SRAM_3[0]/A_RWL<2> RM_IHPSG13_1P_COLUMN_256_0[1]/RM_IHPSG13_1P_BITKIT_16x2_SRAM_2[0]/A_RWL<11>
+ RM_IHPSG13_1P_COLUMN_256_0[1]/RM_IHPSG13_1P_BITKIT_16x2_SRAM_2[0]/A_LWL<2> RM_IHPSG13_1P_COLUMN_256_0[1]/RM_IHPSG13_1P_BITKIT_16x2_SRAM_3[0]/A_RWL<15>
+ RM_IHPSG13_1P_COLUMN_256_0[1]/RM_IHPSG13_1P_BITKIT_16x2_SRAM_0[0]/A_LWL<4> RM_IHPSG13_1P_COLUMN_256_0[1]/RM_IHPSG13_1P_BITKIT_16x2_SRAM_1[0]/A_LWL<12>
+ RM_IHPSG13_1P_COLUMN_256_0[1]/RM_IHPSG13_1P_BITKIT_16x2_SRAM_2[0]/A_RWL<8> RM_IHPSG13_1P_COLUMN_256_0[1]/RM_IHPSG13_1P_BITKIT_16x2_SRAM_1[0]/A_RWL<9>
+ RM_IHPSG13_1P_COLUMN_256_0[1]/RM_IHPSG13_1P_BITKIT_16x2_SRAM_3[1]/A_LWL<13> RM_IHPSG13_1P_COLUMN_256_0[1]/RM_IHPSG13_1P_BITKIT_16x2_SRAM_1[3]/A_RWL<9>
+ RM_IHPSG13_1P_COLUMN_256_0[1]/RM_IHPSG13_1P_BITKIT_16x2_SRAM_2[3]/A_LWL<10> RM_IHPSG13_1P_COLUMN_256_0[1]/RM_IHPSG13_1P_BITKIT_16x2_SRAM_3[2]/A_RWL<13>
+ RM_IHPSG13_1P_COLUMN_256_0[1]/RM_IHPSG13_1P_BITKIT_16x2_SRAM_3[2]/A_LWL<11> RM_IHPSG13_1P_COLUMN_256_0[1]/RM_IHPSG13_1P_BITKIT_16x2_SRAM_0[0]/A_RWL<7>
+ RM_IHPSG13_1P_COLUMN_256_0[1]/RM_IHPSG13_1P_BITKIT_16x2_SRAM_0[3]/A_LWL<5> RM_IHPSG13_1P_COLUMN_256_0[1]/RM_IHPSG13_1P_BITKIT_16x2_SRAM_1[0]/A_RWL<2>
+ RM_IHPSG13_1P_COLUMN_256_0[1]/RM_IHPSG13_1P_BITKIT_16x2_SRAM_2[2]/A_LWL<14> RM_IHPSG13_1P_COLUMN_256_0[1]/RM_IHPSG13_1P_BITKIT_16x2_SRAM_3[0]/A_LWL<3>
+ RM_IHPSG13_1P_COLUMN_256_0[1]/RM_IHPSG13_1P_BITKIT_16x2_SRAM_2[0]/A_LWL<4> RM_IHPSG13_1P_COLUMN_256_0[1]/RM_IHPSG13_1P_BITKIT_16x2_SRAM_3[3]/A_LWL<14>
+ RM_IHPSG13_1P_COLUMN_256_0[1]/RM_IHPSG13_1P_BITKIT_16x2_SRAM_2[1]/A_RWL<10> RM_IHPSG13_1P_COLUMN_256_0[1]/RM_IHPSG13_1P_BITKIT_16x2_SRAM_1[0]/A_LWL<5>
+ RM_IHPSG13_1P_COLUMN_256_0[1]/RM_IHPSG13_1P_BITKIT_16x2_SRAM_3[1]/A_RWL<0> RM_IHPSG13_1P_COLUMN_256_0[1]/RM_IHPSG13_1P_BITKIT_16x2_SRAM_2[0]/A_RWL<10>
+ RM_IHPSG13_1P_COLUMN_256_0[1]/RM_IHPSG13_1P_BITKIT_16x2_SRAM_2[0]/A_RWL<12> RM_IHPSG13_1P_COLUMN_256_0[1]/RM_IHPSG13_1P_BITKIT_16x2_SRAM_3[3]/A_RWL<11>
+ RM_IHPSG13_1P_COLUMN_256_0[1]/RM_IHPSG13_1P_BITKIT_16x2_SRAM_0[0]/A_LWL<6> RM_IHPSG13_1P_COLUMN_256_0[1]/RM_IHPSG13_1P_BITKIT_16x2_SRAM_2[1]/A_RWL<1>
+ RM_IHPSG13_1P_COLUMN_256_0[1]/RM_IHPSG13_1P_BITKIT_16x2_SRAM_2[3]/A_RWL<8> RM_IHPSG13_1P_COLUMN_256_0[1]/RM_IHPSG13_1P_BITKIT_16x2_SRAM_1[1]/A_RWL<2>
+ RM_IHPSG13_1P_COLUMN_256_0[1]/RM_IHPSG13_1P_BITKIT_16x2_SRAM_2[0]/A_RWL<14> RM_IHPSG13_1P_COLUMN_256_0[1]/RM_IHPSG13_1P_BITKIT_16x2_SRAM_3[0]/A_LWL<13>
+ RM_IHPSG13_1P_COLUMN_256_0[1]/RM_IHPSG13_1P_BITKIT_16x2_SRAM_3[2]/A_RWL<15> RM_IHPSG13_1P_COLUMN_256_0[1]/RM_IHPSG13_1P_BITKIT_16x2_SRAM_2[1]/A_RWL<11>
+ RM_IHPSG13_1P_COLUMN_256_0[1]/RM_IHPSG13_1P_BITKIT_16x2_SRAM_3[1]/A_LWL<11> RM_IHPSG13_1P_COLUMN_256_0[1]/RM_IHPSG13_1P_BITKIT_16x2_SRAM_3[0]/A_LWL<0>
+ RM_IHPSG13_1P_COLUMN_256_0[1]/RM_IHPSG13_1P_BITKIT_16x2_SRAM_3[3]/A_RWL<12> RM_IHPSG13_1P_COLUMN_256_0[1]/RM_IHPSG13_1P_BITKIT_16x2_SRAM_0[0]/A_LWL<7>
+ RM_IHPSG13_1P_COLUMN_256_0[1]/RM_IHPSG13_1P_BITKIT_16x2_SRAM_1[0]/A_LWL<15> RM_IHPSG13_1P_COLUMN_256_0[1]/RM_IHPSG13_1P_BITKIT_16x2_SRAM_1[1]/A_RWL<3>
+ RM_IHPSG13_1P_COLUMN_256_0[1]/RM_IHPSG13_1P_BITKIT_16x2_SRAM_1[1]/A_LWL<12> RM_IHPSG13_1P_COLUMN_256_0[1]/RM_IHPSG13_1P_BITKIT_16x2_SRAM_0[1]/A_RWL<4>
+ RM_IHPSG13_1P_COLUMN_256_0[1]/RM_IHPSG13_1P_BITKIT_16x2_SRAM_3[0]/A_LWL<5> RM_IHPSG13_1P_COLUMN_256_0[1]/RM_IHPSG13_1P_BITKIT_16x2_SRAM_2[0]/A_LWL<6>
+ RM_IHPSG13_1P_COLUMN_256_0[1]/RM_IHPSG13_1P_BITKIT_16x2_SRAM_3[2]/A_LWL<14> RM_IHPSG13_1P_COLUMN_256_0[1]/RM_IHPSG13_1P_BITKIT_16x2_SRAM_1[0]/A_LWL<7>
+ RM_IHPSG13_1P_COLUMN_256_0[1]/RM_IHPSG13_1P_BITKIT_16x2_SRAM_3[1]/A_RWL<2> RM_IHPSG13_1P_COLUMN_256_0[1]/RM_IHPSG13_1P_BITKIT_16x2_SRAM_3[2]/A_RWL<11>
+ RM_IHPSG13_1P_COLUMN_256_0[1]/RM_IHPSG13_1P_BITKIT_16x2_SRAM_3[3]/A_RWL<13> RM_IHPSG13_1P_COLUMN_256_0[1]/RM_IHPSG13_1P_BITKIT_16x2_SRAM_0[0]/A_LWL<8>
+ RM_IHPSG13_1P_COLUMN_256_0[1]/RM_IHPSG13_1P_BITKIT_16x2_SRAM_2[3]/A_RWL<6> RM_IHPSG13_1P_COLUMN_256_0[1]/RM_IHPSG13_1P_BITKIT_16x2_SRAM_1[1]/A_RWL<4>
+ RM_IHPSG13_1P_COLUMN_256_0[1]/RM_IHPSG13_1P_BITKIT_16x2_SRAM_0[0]/A_RWL<1> RM_IHPSG13_1P_COLUMN_256_0[1]/RM_IHPSG13_1P_BITKIT_16x2_SRAM_1[1]/A_LWL<13>
+ RM_IHPSG13_1P_COLUMN_256_0[1]/RM_IHPSG13_1P_BITKIT_16x2_SRAM_1[0]/A_LWL<13> RM_IHPSG13_1P_COLUMN_256_0[1]/RM_IHPSG13_1P_BITKIT_16x2_SRAM_0[1]/A_RWL<5>
+ RM_IHPSG13_1P_COLUMN_256_0[1]/RM_IHPSG13_1P_BITKIT_16x2_SRAM_3[0]/A_LWL<6> RM_IHPSG13_1P_COLUMN_256_0[1]/RM_IHPSG13_1P_BITKIT_16x2_SRAM_2[3]/A_LWL<12>
+ RM_IHPSG13_1P_COLUMN_256_0[1]/RM_IHPSG13_1P_BITKIT_16x2_SRAM_1[1]/A_LWL<11> RM_IHPSG13_1P_COLUMN_256_0[1]/RM_IHPSG13_1P_BITKIT_16x2_SRAM_0[0]/A_RWL<8>
+ RM_IHPSG13_1P_COLUMN_256_0[1]/RM_IHPSG13_1P_BITKIT_16x2_SRAM_1[0]/A_LWL<0> RM_IHPSG13_1P_COLUMN_256_0[1]/RM_IHPSG13_1P_BITKIT_16x2_SRAM_0[3]/A_LWL<3>
+ RM_IHPSG13_1P_COLUMN_256_0[1]/RM_IHPSG13_1P_BITKIT_16x2_SRAM_2[1]/A_RWL<12> RM_IHPSG13_1P_COLUMN_256_0[1]/RM_IHPSG13_1P_BITKIT_16x2_SRAM_2[0]/A_RWL<9>
+ RM_IHPSG13_1P_COLUMN_256_0[1]/RM_IHPSG13_1P_BITKIT_16x2_SRAM_3[1]/A_RWL<3> RM_IHPSG13_1P_COLUMN_256_0[1]/RM_IHPSG13_1P_BITKIT_16x2_SRAM_2[3]/A_LWL<2>
+ RM_IHPSG13_1P_COLUMN_256_0[1]/RM_IHPSG13_1P_BITKIT_16x2_SRAM_3[3]/A_RWL<14> RM_IHPSG13_1P_COLUMN_256_0[1]/RM_IHPSG13_1P_BITKIT_16x2_SRAM_2[2]/A_RWL<10>
+ RM_IHPSG13_1P_COLUMN_256_0[1]/RM_IHPSG13_1P_BITKIT_16x2_SRAM_2[0]/A_LWL<5> RM_IHPSG13_1P_COLUMN_256_0[1]/RM_IHPSG13_1P_BITKIT_16x2_SRAM_3[3]/A_LWL<4>
+ RM_IHPSG13_1P_COLUMN_256_0[1]/RM_IHPSG13_1P_BITKIT_16x2_SRAM_2[1]/A_RWL<3> RM_IHPSG13_1P_COLUMN_256_0[1]/RM_IHPSG13_1P_BITKIT_16x2_SRAM_3[0]/A_LWL<7>
+ RM_IHPSG13_1P_COLUMN_256_0[1]/RM_IHPSG13_1P_BITKIT_16x2_SRAM_0[0]/A_LWL<10> RM_IHPSG13_1P_COLUMN_256_0[1]/RM_IHPSG13_1P_BITKIT_16x2_SRAM_1[1]/A_LWL<0>
+ RM_IHPSG13_1P_COLUMN_256_0[1]/RM_IHPSG13_1P_BITKIT_16x2_SRAM_2[0]/A_LWL<8> RM_IHPSG13_1P_COLUMN_256_0[1]/RM_IHPSG13_1P_BITKIT_16x2_SRAM_3[1]/A_LWL<14>
+ RM_IHPSG13_1P_COLUMN_256_0[1]/RM_IHPSG13_1P_BITKIT_16x2_SRAM_1[2]/A_LWL<11> RM_IHPSG13_1P_COLUMN_256_0[1]/RM_IHPSG13_1P_BITKIT_16x2_SRAM_2[1]/A_RWL<14>
+ RM_IHPSG13_1P_COLUMN_256_0[1]/RM_IHPSG13_1P_BITKIT_16x2_SRAM_0[1]/A_LWL<1> RM_IHPSG13_1P_COLUMN_256_0[1]/RM_IHPSG13_1P_BITKIT_16x2_SRAM_1[0]/A_LWL<9>
+ RM_IHPSG13_1P_COLUMN_256_0[1]/RM_IHPSG13_1P_BITKIT_16x2_SRAM_3[1]/A_RWL<4> RM_IHPSG13_1P_COLUMN_256_0[1]/RM_IHPSG13_1P_BITKIT_16x2_SRAM_1[0]/A_RWL<0>
+ RM_IHPSG13_1P_COLUMN_256_0[1]/RM_IHPSG13_1P_BITKIT_16x2_SRAM_3[1]/A_RWL<11> RM_IHPSG13_1P_COLUMN_256_0[1]/RM_IHPSG13_1P_BITKIT_16x2_SRAM_3[3]/A_RWL<15>
+ RM_IHPSG13_1P_COLUMN_256_0[1]/RM_IHPSG13_1P_BITKIT_16x2_SRAM_0[3]/A_RWL<6> RM_IHPSG13_1P_COLUMN_256_0[1]/RM_IHPSG13_1P_BITKIT_16x2_SRAM_2[1]/A_RWL<5>
+ RM_IHPSG13_1P_COLUMN_256_0[1]/RM_IHPSG13_1P_BITKIT_16x2_SRAM_2[2]/A_RWL<11> RM_IHPSG13_1P_COLUMN_256_0[1]/RM_IHPSG13_1P_BITKIT_16x2_SRAM_3[0]/A_RWL<1>
+ RM_IHPSG13_1P_COLUMN_256_0[1]/RM_IHPSG13_1P_BITKIT_16x2_SRAM_3[3]/A_RWL<5> RM_IHPSG13_1P_COLUMN_256_0[1]/RM_IHPSG13_1P_BITKIT_16x2_SRAM_1[1]/A_RWL<6>
+ RM_IHPSG13_1P_COLUMN_256_0[1]/RM_IHPSG13_1P_BITKIT_16x2_SRAM_3[0]/A_RWL<8> RM_IHPSG13_1P_COLUMN_256_0[1]/RM_IHPSG13_1P_BITKIT_16x2_SRAM_1[1]/A_LWL<15>
+ RM_IHPSG13_1P_COLUMN_256_0[1]/RM_IHPSG13_1P_BITKIT_16x2_SRAM_0[1]/A_RWL<7> RM_IHPSG13_1P_COLUMN_256_0[1]/RM_IHPSG13_1P_BITKIT_16x2_SRAM_3[3]/A_LWL<3>
+ RM_IHPSG13_1P_COLUMN_256_0[1]/RM_IHPSG13_1P_BITKIT_16x2_SRAM_0[0]/A_LWL<11> RM_IHPSG13_1P_COLUMN_256_0[1]/RM_IHPSG13_1P_BITKIT_16x2_SRAM_2[2]/A_LWL<12>
+ RM_IHPSG13_1P_COLUMN_256_0[1]/RM_IHPSG13_1P_BITKIT_16x2_SRAM_1[0]/A_LWL<11> RM_IHPSG13_1P_COLUMN_256_0[1]/RM_IHPSG13_1P_BITKIT_16x2_SRAM_1[2]/A_LWL<12>
+ RM_IHPSG13_1P_COLUMN_256_0[1]/RM_IHPSG13_1P_BITKIT_16x2_SRAM_3[2]/A_RWL<14> RM_IHPSG13_1P_COLUMN_256_0[1]/RM_IHPSG13_1P_BITKIT_16x2_SRAM_3[1]/A_RWL<5>
+ RM_IHPSG13_1P_COLUMN_256_0[1]/RM_IHPSG13_1P_BITKIT_16x2_SRAM_0[0]/A_LWL<5> RM_IHPSG13_1P_COLUMN_256_0[1]/RM_IHPSG13_1P_BITKIT_16x2_SRAM_1[3]/A_LWL<4>
+ RM_IHPSG13_1P_COLUMN_256_0[1]/RM_IHPSG13_1P_BITKIT_16x2_SRAM_0[1]/A_RWL<1> RM_IHPSG13_1P_COLUMN_256_0[1]/RM_IHPSG13_1P_BITKIT_16x2_SRAM_0[1]/A_RWL<3>
+ RM_IHPSG13_1P_COLUMN_256_0[1]/RM_IHPSG13_1P_BITKIT_16x2_SRAM_3[1]/A_LWL<0> RM_IHPSG13_1P_COLUMN_256_0[1]/RM_IHPSG13_1P_BITKIT_16x2_SRAM_2[0]/A_RWL<3>
+ RM_IHPSG13_1P_COLUMN_256_0[1]/RM_IHPSG13_1P_BITKIT_16x2_SRAM_2[3]/A_LWL<9> RM_IHPSG13_1P_COLUMN_256_0[1]/RM_IHPSG13_1P_BITKIT_16x2_SRAM_2[1]/A_LWL<1>
+ RM_IHPSG13_1P_COLUMN_256_0[1]/RM_IHPSG13_1P_BITKIT_16x2_SRAM_3[0]/A_LWL<9> RM_IHPSG13_1P_COLUMN_256_0[1]/RM_IHPSG13_1P_BITKIT_16x2_SRAM_0[1]/A_RWL<8>
+ RM_IHPSG13_1P_COLUMN_256_0[1]/RM_IHPSG13_1P_BITKIT_16x2_SRAM_1[1]/A_LWL<14> RM_IHPSG13_1P_COLUMN_256_0[1]/RM_IHPSG13_1P_BITKIT_16x2_SRAM_0[0]/A_LWL<2>
+ RM_IHPSG13_1P_COLUMN_256_0[1]/RM_IHPSG13_1P_BITKIT_16x2_SRAM_2[2]/A_RWL<12> RM_IHPSG13_1P_COLUMN_256_0[1]/RM_IHPSG13_1P_BITKIT_16x2_SRAM_1[1]/A_LWL<2>
+ RM_IHPSG13_1P_COLUMN_256_0[1]/RM_IHPSG13_1P_BITKIT_16x2_SRAM_0[3]/A_LWL<6> RM_IHPSG13_1P_COLUMN_256_0[1]/RM_IHPSG13_1P_BITKIT_16x2_SRAM_3[0]/A_LWL<14>
+ RM_IHPSG13_1P_COLUMN_256_0[1]/RM_IHPSG13_1P_BITKIT_16x2_SRAM_1[2]/A_LWL<13> RM_IHPSG13_1P_COLUMN_256_0[1]/RM_IHPSG13_1P_BITKIT_16x2_SRAM_0[1]/A_LWL<3>
+ RM_IHPSG13_1P_COLUMN_256_0[1]/RM_IHPSG13_1P_BITKIT_16x2_SRAM_1[0]/A_RWL<12> RM_IHPSG13_1P_COLUMN_256_0[1]/RM_IHPSG13_1P_BITKIT_16x2_SRAM_3[1]/A_RWL<6>
+ RM_IHPSG13_1P_COLUMN_256_0[1]/RM_IHPSG13_1P_BITKIT_16x2_SRAM_3[0]/A_RWL<11> RM_IHPSG13_1P_COLUMN_256_0[1]/RM_IHPSG13_1P_BITKIT_16x2_SRAM_3[3]/A_LWL<1>
+ RM_IHPSG13_1P_COLUMN_256_0[1]/RM_IHPSG13_1P_BITKIT_16x2_SRAM_2[1]/A_RWL<7> RM_IHPSG13_1P_COLUMN_256_0[1]/RM_IHPSG13_1P_BITKIT_16x2_SRAM_2[1]/A_RWL<6>
+ RM_IHPSG13_1P_COLUMN_256_0[1]/RM_IHPSG13_1P_BITKIT_16x2_SRAM_0[2]/A_RWL<0> RM_IHPSG13_1P_COLUMN_256_0[1]/RM_IHPSG13_1P_BITKIT_16x2_SRAM_2[3]/A_RWL<10>
+ RM_IHPSG13_1P_COLUMN_256_0[1]/RM_IHPSG13_1P_BITKIT_16x2_SRAM_2[1]/A_LWL<2> RM_IHPSG13_1P_COLUMN_256_0[1]/RM_IHPSG13_1P_BITKIT_16x2_SRAM_0[0]/A_LWL<13>
+ RM_IHPSG13_1P_COLUMN_256_0[1]/RM_IHPSG13_1P_BITKIT_16x2_SRAM_2[1]/A_LWL<12> RM_IHPSG13_1P_COLUMN_256_0[1]/RM_IHPSG13_1P_BITKIT_16x2_SRAM_1[1]/A_RWL<0>
+ RM_IHPSG13_1P_COLUMN_256_0[1]/RM_IHPSG13_1P_BITKIT_16x2_SRAM_1[2]/A_LWL<14> RM_IHPSG13_1P_COLUMN_256_0[1]/RM_IHPSG13_1P_BITKIT_16x2_SRAM_1[0]/A_RWL<5>
+ RM_IHPSG13_1P_COLUMN_256_0[1]/RM_IHPSG13_1P_BITKIT_16x2_SRAM_0[1]/A_LWL<10> RM_IHPSG13_1P_COLUMN_256_0[1]/RM_IHPSG13_1P_BITKIT_16x2_SRAM_0[1]/A_LWL<4>
+ RM_IHPSG13_1P_COLUMN_256_0[1]/RM_IHPSG13_1P_BITKIT_16x2_SRAM_3[1]/A_RWL<14> RM_IHPSG13_1P_COLUMN_256_0[1]/RM_IHPSG13_1P_BITKIT_16x2_SRAM_3[1]/A_RWL<1>
+ RM_IHPSG13_1P_COLUMN_256_0[1]/RM_IHPSG13_1P_BITKIT_16x2_SRAM_1[0]/A_RWL<13> RM_IHPSG13_1P_COLUMN_256_0[1]/RM_IHPSG13_1P_BITKIT_16x2_SRAM_1[3]/A_LWL<11>
+ RM_IHPSG13_1P_COLUMN_256_0[1]/RM_IHPSG13_1P_BITKIT_16x2_SRAM_2[1]/A_RWL<8> RM_IHPSG13_1P_COLUMN_256_0[1]/RM_IHPSG13_1P_BITKIT_16x2_SRAM_1[0]/A_LWL<3>
+ RM_IHPSG13_1P_COLUMN_256_0[1]/RM_IHPSG13_1P_BITKIT_16x2_SRAM_2[2]/A_RWL<14> RM_IHPSG13_1P_COLUMN_256_0[1]/RM_IHPSG13_1P_BITKIT_16x2_SRAM_1[3]/A_LWL<7>
+ RM_IHPSG13_1P_COLUMN_256_0[1]/RM_IHPSG13_1P_BITKIT_16x2_SRAM_0[0]/A_RWL<3> RM_IHPSG13_1P_COLUMN_256_0[1]/RM_IHPSG13_1P_BITKIT_16x2_SRAM_0[3]/A_LWL<9>
+ RM_IHPSG13_1P_COLUMN_256_0[1]/RM_IHPSG13_1P_BITKIT_16x2_SRAM_3[0]/A_LWL<2> RM_IHPSG13_1P_COLUMN_256_0[1]/RM_IHPSG13_1P_BITKIT_16x2_SRAM_1[1]/A_RWL<9>
+ RM_IHPSG13_1P_COLUMN_256_0[1]/RM_IHPSG13_1P_BITKIT_16x2_SRAM_3[3]/A_LWL<6> RM_IHPSG13_1P_COLUMN_256_0[1]/RM_IHPSG13_1P_BITKIT_16x2_SRAM_2[2]/A_LWL<9>
+ RM_IHPSG13_1P_COLUMN_256_0[1]/RM_IHPSG13_1P_BITKIT_16x2_SRAM_2[1]/A_LWL<3> RM_IHPSG13_1P_COLUMN_256_0[1]/RM_IHPSG13_1P_BITKIT_16x2_SRAM_0[0]/A_LWL<14>
+ RM_IHPSG13_1P_COLUMN_256_0[1]/RM_IHPSG13_1P_BITKIT_16x2_SRAM_1[0]/A_LWL<14> RM_IHPSG13_1P_COLUMN_256_0[1]/RM_IHPSG13_1P_BITKIT_16x2_SRAM_2[3]/A_LWL<15>
+ RM_IHPSG13_1P_COLUMN_256_0[1]/RM_IHPSG13_1P_BITKIT_16x2_SRAM_1[2]/A_LWL<15> RM_IHPSG13_1P_COLUMN_256_0[1]/RM_IHPSG13_1P_BITKIT_16x2_SRAM_0[1]/A_LWL<11>
+ RM_IHPSG13_1P_COLUMN_256_0[1]/RM_IHPSG13_1P_BITKIT_16x2_SRAM_0[1]/A_LWL<5> RM_IHPSG13_1P_COLUMN_256_0[1]/RM_IHPSG13_1P_BITKIT_16x2_SRAM_1[0]/A_RWL<11>
+ RM_IHPSG13_1P_COLUMN_256_0[1]/RM_IHPSG13_1P_BITKIT_16x2_SRAM_2[2]/A_RWL<0> RM_IHPSG13_1P_COLUMN_256_0[1]/RM_IHPSG13_1P_BITKIT_16x2_SRAM_1[3]/A_LWL<1>
+ RM_IHPSG13_1P_COLUMN_256_0[1]/RM_IHPSG13_1P_BITKIT_16x2_SRAM_3[1]/A_RWL<8> RM_IHPSG13_1P_COLUMN_256_0[1]/RM_IHPSG13_1P_BITKIT_16x2_SRAM_0[2]/A_RWL<1>
+ RM_IHPSG13_1P_COLUMN_256_0[1]/RM_IHPSG13_1P_BITKIT_16x2_SRAM_3[3]/A_LWL<10> RM_IHPSG13_1P_COLUMN_256_0[1]/RM_IHPSG13_1P_BITKIT_16x2_SRAM_1[3]/A_LWL<12>
+ RM_IHPSG13_1P_COLUMN_256_0[1]/RM_IHPSG13_1P_BITKIT_16x2_SRAM_1[2]/A_RWL<1> RM_IHPSG13_1P_COLUMN_256_0[1]/RM_IHPSG13_1P_BITKIT_16x2_SRAM_0[1]/A_RWL<6>
+ RM_IHPSG13_1P_COLUMN_256_0[1]/RM_IHPSG13_1P_BITKIT_16x2_SRAM_2[1]/A_RWL<9> RM_IHPSG13_1P_COLUMN_256_0[1]/RM_IHPSG13_1P_BITKIT_16x2_SRAM_1[1]/A_RWL<11>
+ RM_IHPSG13_1P_COLUMN_256_0[1]/RM_IHPSG13_1P_BITKIT_16x2_SRAM_2[0]/A_RWL<6> RM_IHPSG13_1P_COLUMN_256_0[1]/RM_IHPSG13_1P_BITKIT_16x2_SRAM_3[1]/A_LWL<3>
+ RM_IHPSG13_1P_COLUMN_256_0[1]/RM_IHPSG13_1P_BITKIT_16x2_SRAM_2[0]/A_RWL<4> RM_IHPSG13_1P_COLUMN_256_0[1]/RM_IHPSG13_1P_BITKIT_16x2_SRAM_3[3]/A_RWL<7>
+ RM_IHPSG13_1P_COLUMN_256_0[1]/RM_IHPSG13_1P_BITKIT_16x2_SRAM_0[1]/A_LWL<2> RM_IHPSG13_1P_COLUMN_256_0[1]/RM_IHPSG13_1P_BITKIT_16x2_SRAM_2[3]/A_RWL<12>
+ RM_IHPSG13_1P_COLUMN_256_0[1]/RM_IHPSG13_1P_BITKIT_16x2_SRAM_2[1]/A_LWL<4> RM_IHPSG13_1P_COLUMN_256_0[1]/RM_IHPSG13_1P_BITKIT_16x2_SRAM_2[0]/A_LWL<12>
+ RM_IHPSG13_1P_COLUMN_256_0[1]/RM_IHPSG13_1P_BITKIT_16x2_SRAM_1[1]/A_LWL<5> RM_IHPSG13_1P_COLUMN_256_0[1]/RM_IHPSG13_1P_BITKIT_16x2_SRAM_3[2]/A_RWL<0>
+ RM_IHPSG13_1P_COLUMN_256_0[1]/RM_IHPSG13_1P_BITKIT_16x2_SRAM_0[1]/A_LWL<12> RM_IHPSG13_1P_COLUMN_256_0[1]/RM_IHPSG13_1P_BITKIT_16x2_SRAM_0[1]/A_LWL<6>
+ RM_IHPSG13_1P_COLUMN_256_0[1]/RM_IHPSG13_1P_BITKIT_16x2_SRAM_2[2]/A_RWL<1> RM_IHPSG13_1P_COLUMN_256_0[1]/RM_IHPSG13_1P_BITKIT_16x2_SRAM_3[0]/A_RWL<14>
+ RM_IHPSG13_1P_COLUMN_256_0[1]/RM_IHPSG13_1P_BITKIT_16x2_SRAM_1[0]/A_RWL<15> RM_IHPSG13_1P_COLUMN_256_0[1]/RM_IHPSG13_1P_BITKIT_16x2_SRAM_1[1]/A_LWL<4>
+ RM_IHPSG13_1P_COLUMN_256_0[1]/RM_IHPSG13_1P_BITKIT_16x2_SRAM_1[3]/A_LWL<13> RM_IHPSG13_1P_COLUMN_256_0[1]/RM_IHPSG13_1P_BITKIT_16x2_SRAM_1[2]/A_RWL<2>
+ RM_IHPSG13_1P_COLUMN_256_0[1]/RM_IHPSG13_1P_BITKIT_16x2_SRAM_1[1]/A_RWL<12> RM_IHPSG13_1P_COLUMN_256_0[1]/RM_IHPSG13_1P_BITKIT_16x2_SRAM_3[0]/A_LWL<4>
+ RM_IHPSG13_1P_COLUMN_256_0[1]/RM_IHPSG13_1P_BITKIT_16x2_SRAM_0[2]/A_LWL<9> RM_IHPSG13_1P_COLUMN_256_0[1]/RM_IHPSG13_1P_BITKIT_16x2_SRAM_0[2]/A_RWL<3>
+ RM_IHPSG13_1P_COLUMN_256_0[1]/RM_IHPSG13_1P_BITKIT_16x2_SRAM_3[1]/A_LWL<4> RM_IHPSG13_1P_COLUMN_256_0[1]/RM_IHPSG13_1P_BITKIT_16x2_SRAM_2[1]/A_LWL<5>
+ RM_IHPSG13_1P_COLUMN_256_0[1]/RM_IHPSG13_1P_BITKIT_16x2_SRAM_1[2]/A_RWL<0> RM_IHPSG13_1P_COLUMN_256_0[1]/RM_IHPSG13_1P_BITKIT_16x2_SRAM_1[1]/A_RWL<5>
+ RM_IHPSG13_1P_COLUMN_256_0[1]/RM_IHPSG13_1P_BITKIT_16x2_SRAM_2[2]/A_LWL<15> RM_IHPSG13_1P_COLUMN_256_0[1]/RM_IHPSG13_1P_BITKIT_16x2_SRAM_3[2]/A_RWL<1>
+ RM_IHPSG13_1P_COLUMN_256_0[1]/RM_IHPSG13_1P_BITKIT_16x2_SRAM_1[3]/A_LWL<10> RM_IHPSG13_1P_COLUMN_256_0[1]/RM_IHPSG13_1P_BITKIT_16x2_SRAM_0[1]/A_LWL<7>
+ RM_IHPSG13_1P_COLUMN_256_0[1]/RM_IHPSG13_1P_BITKIT_16x2_SRAM_1[1]/A_LWL<3> RM_IHPSG13_1P_COLUMN_256_0[1]/RM_IHPSG13_1P_BITKIT_16x2_SRAM_1[0]/A_LWL<6>
+ RM_IHPSG13_1P_COLUMN_256_0[1]/RM_IHPSG13_1P_BITKIT_16x2_SRAM_3[2]/A_LWL<10> RM_IHPSG13_1P_COLUMN_256_0[1]/RM_IHPSG13_1P_BITKIT_16x2_SRAM_1[3]/A_LWL<14>
+ RM_IHPSG13_1P_COLUMN_256_0[1]/RM_IHPSG13_1P_BITKIT_16x2_SRAM_3[1]/A_LWL<1> RM_IHPSG13_1P_COLUMN_256_0[1]/RM_IHPSG13_1P_BITKIT_16x2_SRAM_3[1]/A_LWL<2>
+ RM_IHPSG13_1P_COLUMN_256_0[1]/RM_IHPSG13_1P_BITKIT_16x2_SRAM_0[0]/A_RWL<6> RM_IHPSG13_1P_COLUMN_256_0[1]/RM_IHPSG13_1P_BITKIT_16x2_SRAM_1[2]/A_RWL<3>
+ RM_IHPSG13_1P_COLUMN_256_0[1]/RM_IHPSG13_1P_BITKIT_16x2_SRAM_0[2]/A_LWL<10> RM_IHPSG13_1P_COLUMN_256_0[1]/RM_IHPSG13_1P_BITKIT_16x2_SRAM_1[3]/A_RWL<7>
+ RM_IHPSG13_1P_COLUMN_256_0[1]/RM_IHPSG13_1P_BITKIT_16x2_SRAM_1[1]/A_RWL<13> RM_IHPSG13_1P_COLUMN_256_0[1]/RM_IHPSG13_1P_BITKIT_16x2_SRAM_0[2]/A_RWL<4>
+ RM_IHPSG13_1P_COLUMN_256_0[1]/RM_IHPSG13_1P_BITKIT_16x2_SRAM_0[0]/A_LWL<12> RM_IHPSG13_1P_COLUMN_256_0[1]/RM_IHPSG13_1P_BITKIT_16x2_SRAM_2[3]/A_RWL<14>
+ RM_IHPSG13_1P_COLUMN_256_0[1]/RM_IHPSG13_1P_BITKIT_16x2_SRAM_2[1]/A_LWL<6> RM_IHPSG13_1P_COLUMN_256_0[1]/RM_IHPSG13_1P_BITKIT_16x2_SRAM_1[1]/A_LWL<7>
+ RM_IHPSG13_1P_COLUMN_256_0[1]/RM_IHPSG13_1P_BITKIT_16x2_SRAM_3[2]/A_RWL<2> RM_IHPSG13_1P_COLUMN_256_0[1]/RM_IHPSG13_1P_BITKIT_16x2_SRAM_1[0]/A_RWL<14>
+ RM_IHPSG13_1P_COLUMN_256_0[1]/RM_IHPSG13_1P_BITKIT_16x2_SRAM_0[1]/A_LWL<14> RM_IHPSG13_1P_COLUMN_256_0[1]/RM_IHPSG13_1P_BITKIT_16x2_SRAM_0[1]/A_LWL<8>
+ RM_IHPSG13_1P_COLUMN_256_0[1]/RM_IHPSG13_1P_BITKIT_16x2_SRAM_2[2]/A_RWL<3> RM_IHPSG13_1P_COLUMN_256_0[1]/RM_IHPSG13_1P_BITKIT_16x2_SRAM_1[3]/A_LWL<15>
+ RM_IHPSG13_1P_COLUMN_256_0[1]/RM_IHPSG13_1P_BITKIT_16x2_SRAM_1[0]/A_LWL<4> RM_IHPSG13_1P_COLUMN_256_0[1]/RM_IHPSG13_1P_BITKIT_16x2_SRAM_1[2]/A_RWL<4>
+ RM_IHPSG13_1P_COLUMN_256_0[1]/RM_IHPSG13_1P_BITKIT_16x2_SRAM_0[3]/A_RWL<8> RM_IHPSG13_1P_COLUMN_256_0[1]/RM_IHPSG13_1P_BITKIT_16x2_SRAM_2[1]/A_RWL<4>
+ RM_IHPSG13_1P_COLUMN_256_0[1]/RM_IHPSG13_1P_BITKIT_16x2_SRAM_2[0]/A_RWL<13> RM_IHPSG13_1P_COLUMN_256_0[1]/RM_IHPSG13_1P_BITKIT_16x2_SRAM_3[3]/A_RWL<10>
+ RM_IHPSG13_1P_COLUMN_256_0[1]/RM_IHPSG13_1P_BITKIT_16x2_SRAM_1[1]/A_RWL<14> RM_IHPSG13_1P_COLUMN_256_0[1]/RM_IHPSG13_1P_BITKIT_16x2_SRAM_0[2]/A_RWL<5>
+ RM_IHPSG13_1P_COLUMN_256_0[1]/RM_IHPSG13_1P_BITKIT_16x2_SRAM_0[0]/A_RWL<10> RM_IHPSG13_1P_COLUMN_256_0[1]/RM_IHPSG13_1P_BITKIT_16x2_SRAM_2[3]/A_RWL<9>
+ RM_IHPSG13_1P_COLUMN_256_0[1]/RM_IHPSG13_1P_BITKIT_16x2_SRAM_3[1]/A_LWL<6> RM_IHPSG13_1P_COLUMN_256_0[1]/RM_IHPSG13_1P_BITKIT_16x2_SRAM_2[0]/A_LWL<9>
+ RM_IHPSG13_1P_COLUMN_256_0[1]/RM_IHPSG13_1P_BITKIT_16x2_SRAM_2[3]/A_RWL<15> RM_IHPSG13_1P_COLUMN_256_0[1]/RM_IHPSG13_1P_BITKIT_16x2_SRAM_1[2]/A_RWL<11>
+ RM_IHPSG13_1P_COLUMN_256_0[1]/RM_IHPSG13_1P_BITKIT_16x2_SRAM_2[0]/A_LWL<7> RM_IHPSG13_1P_COLUMN_256_0[1]/RM_IHPSG13_1P_BITKIT_16x2_SRAM_3[3]/A_LWL<8>
+ RM_IHPSG13_1P_COLUMN_256_0[1]/RM_IHPSG13_1P_BITKIT_16x2_SRAM_2[1]/A_LWL<15> RM_IHPSG13_1P_COLUMN_256_0[1]/RM_IHPSG13_1P_BITKIT_16x2_SRAM_1[2]/A_LWL<10>
+ RM_IHPSG13_1P_COLUMN_256_0[1]/RM_IHPSG13_1P_BITKIT_16x2_SRAM_0[1]/A_LWL<9> RM_IHPSG13_1P_COLUMN_256_0[1]/RM_IHPSG13_1P_BITKIT_16x2_SRAM_1[1]/A_LWL<1>
+ RM_IHPSG13_1P_COLUMN_256_0[1]/RM_IHPSG13_1P_BITKIT_16x2_SRAM_3[1]/A_LWL<10> RM_IHPSG13_1P_COLUMN_256_0[1]/RM_IHPSG13_1P_BITKIT_16x2_SRAM_3[0]/A_LWL<1>
+ RM_IHPSG13_1P_COLUMN_256_0[1]/RM_IHPSG13_1P_BITKIT_16x2_SRAM_0[2]/A_LWL<12> RM_IHPSG13_1P_COLUMN_256_0[1]/RM_IHPSG13_1P_BITKIT_16x2_SRAM_1[1]/A_RWL<15>
+ RM_IHPSG13_1P_COLUMN_256_0[1]/RM_IHPSG13_1P_BITKIT_16x2_SRAM_0[2]/A_RWL<6> RM_IHPSG13_1P_COLUMN_256_0[1]/RM_IHPSG13_1P_BITKIT_16x2_SRAM_0[0]/A_RWL<11>
+ RM_IHPSG13_1P_COLUMN_256_0[1]/RM_IHPSG13_1P_BITKIT_16x2_SRAM_3[1]/A_LWL<7> RM_IHPSG13_1P_COLUMN_256_0[1]/RM_IHPSG13_1P_BITKIT_16x2_SRAM_3[1]/A_RWL<7>
+ RM_IHPSG13_1P_COLUMN_256_0[1]/RM_IHPSG13_1P_BITKIT_16x2_SRAM_1[2]/A_RWL<5> RM_IHPSG13_1P_COLUMN_256_0[1]/RM_IHPSG13_1P_BITKIT_16x2_SRAM_1[2]/A_LWL<0>
+ RM_IHPSG13_1P_COLUMN_256_0[1]/RM_IHPSG13_1P_BITKIT_16x2_SRAM_1[2]/A_RWL<12> RM_IHPSG13_1P_COLUMN_256_0[1]/RM_IHPSG13_1P_BITKIT_16x2_SRAM_2[1]/A_LWL<8>
+ RM_IHPSG13_1P_COLUMN_256_0[1]/RM_IHPSG13_1P_BITKIT_16x2_SRAM_2[2]/A_RWL<2> RM_IHPSG13_1P_COLUMN_256_0[1]/RM_IHPSG13_1P_BITKIT_16x2_SRAM_0[2]/A_LWL<1>
+ RM_IHPSG13_1P_COLUMN_256_0[1]/RM_IHPSG13_1P_BITKIT_16x2_SRAM_0[3]/A_RWL<15> RM_IHPSG13_1P_COLUMN_256_0[1]/RM_IHPSG13_1P_BITKIT_16x2_SRAM_1[1]/A_LWL<9>
+ RM_IHPSG13_1P_COLUMN_256_0[1]/RM_IHPSG13_1P_BITKIT_16x2_SRAM_3[2]/A_RWL<4> RM_IHPSG13_1P_COLUMN_256_0[1]/RM_IHPSG13_1P_BITKIT_16x2_SRAM_3[0]/A_RWL<12>
+ RM_IHPSG13_1P_COLUMN_256_0[1]/RM_IHPSG13_1P_BITKIT_16x2_SRAM_1[1]/A_LWL<6> RM_IHPSG13_1P_COLUMN_256_0[1]/RM_IHPSG13_1P_BITKIT_16x2_SRAM_3[3]/A_RWL<8>
+ RM_IHPSG13_1P_COLUMN_256_0[1]/RM_IHPSG13_1P_BITKIT_16x2_SRAM_2[2]/A_RWL<15> RM_IHPSG13_1P_COLUMN_256_0[1]/RM_IHPSG13_1P_BITKIT_16x2_SRAM_2[2]/A_RWL<5>
+ RM_IHPSG13_1P_COLUMN_256_0[1]/RM_IHPSG13_1P_BITKIT_16x2_SRAM_1[2]/A_RWL<6> RM_IHPSG13_1P_COLUMN_256_0[1]/RM_IHPSG13_1P_BITKIT_16x2_SRAM_3[2]/A_RWL<10>
+ RM_IHPSG13_1P_COLUMN_256_0[1]/RM_IHPSG13_1P_BITKIT_16x2_SRAM_0[0]/A_LWL<9> RM_IHPSG13_1P_COLUMN_256_0[1]/RM_IHPSG13_1P_BITKIT_16x2_SRAM_0[0]/A_RWL<12>
+ RM_IHPSG13_1P_COLUMN_256_0[1]/RM_IHPSG13_1P_BITKIT_16x2_SRAM_0[2]/A_RWL<7> RM_IHPSG13_1P_COLUMN_256_0[1]/RM_IHPSG13_1P_BITKIT_16x2_SRAM_1[3]/A_LWL<8>
+ RM_IHPSG13_1P_COLUMN_256_0[1]/RM_IHPSG13_1P_BITKIT_16x2_SRAM_0[3]/A_LWL<10> RM_IHPSG13_1P_COLUMN_256_0[1]/RM_IHPSG13_1P_BITKIT_16x2_SRAM_1[2]/A_LWL<1>
+ RM_IHPSG13_1P_COLUMN_256_0[1]/RM_IHPSG13_1P_BITKIT_16x2_SRAM_2[1]/A_LWL<9> RM_IHPSG13_1P_COLUMN_256_0[1]/RM_IHPSG13_1P_BITKIT_16x2_SRAM_1[2]/A_RWL<13>
+ RM_IHPSG13_1P_COLUMN_256_0[1]/RM_IHPSG13_1P_BITKIT_16x2_SRAM_0[1]/A_LWL<15> RM_IHPSG13_1P_COLUMN_256_0[1]/RM_IHPSG13_1P_BITKIT_16x2_SRAM_3[2]/A_LWL<8>
+ RM_IHPSG13_1P_COLUMN_256_0[1]/RM_IHPSG13_1P_BITKIT_16x2_SRAM_0[2]/A_LWL<2> RM_IHPSG13_1P_COLUMN_256_0[1]/RM_IHPSG13_1P_BITKIT_16x2_SRAM_2[0]/A_LWL<15>
+ RM_IHPSG13_1P_COLUMN_256_0[1]/RM_IHPSG13_1P_BITKIT_16x2_SRAM_2[3]/A_LWL<13> RM_IHPSG13_1P_COLUMN_256_0[1]/RM_IHPSG13_1P_BITKIT_16x2_SRAM_3[2]/A_RWL<5>
+ RM_IHPSG13_1P_COLUMN_256_0[1]/RM_IHPSG13_1P_BITKIT_16x2_SRAM_1[3]/A_RWL<10> RM_IHPSG13_1P_COLUMN_256_0[1]/RM_IHPSG13_1P_BITKIT_16x2_SRAM_1[1]/A_LWL<10>
+ RM_IHPSG13_1P_COLUMN_256_0[1]/RM_IHPSG13_1P_BITKIT_16x2_SRAM_0[0]/A_RWL<9> RM_IHPSG13_1P_COLUMN_256_0[1]/RM_IHPSG13_1P_BITKIT_16x2_SRAM_1[0]/A_LWL<1>
+ RM_IHPSG13_1P_COLUMN_256_0[1]/RM_IHPSG13_1P_BITKIT_16x2_SRAM_2[2]/A_RWL<6> RM_IHPSG13_1P_COLUMN_256_0[1]/RM_IHPSG13_1P_BITKIT_16x2_SRAM_2[2]/A_RWL<4>
+ RM_IHPSG13_1P_COLUMN_256_0[1]/RM_IHPSG13_1P_BITKIT_16x2_SRAM_2[1]/A_RWL<13> RM_IHPSG13_1P_COLUMN_256_0[1]/RM_IHPSG13_1P_BITKIT_16x2_SRAM_0[3]/A_LWL<2>
+ RM_IHPSG13_1P_COLUMN_256_0[1]/RM_IHPSG13_1P_BITKIT_16x2_SRAM_2[3]/A_LWL<0> RM_IHPSG13_1P_COLUMN_256_0[1]/RM_IHPSG13_1P_BITKIT_16x2_SRAM_3[2]/A_LWL<0>
+ RM_IHPSG13_1P_COLUMN_256_0[1]/RM_IHPSG13_1P_BITKIT_16x2_SRAM_1[2]/A_RWL<7> RM_IHPSG13_1P_COLUMN_256_0[1]/RM_IHPSG13_1P_BITKIT_16x2_SRAM_0[2]/A_LWL<14>
+ RM_IHPSG13_1P_COLUMN_256_0[1]/RM_IHPSG13_1P_BITKIT_16x2_SRAM_1[1]/A_RWL<7> RM_IHPSG13_1P_COLUMN_256_0[1]/RM_IHPSG13_1P_BITKIT_16x2_SRAM_2[2]/A_LWL<1>
+ RM_IHPSG13_1P_COLUMN_256_0[1]/RM_IHPSG13_1P_BITKIT_16x2_SRAM_0[0]/A_RWL<13> RM_IHPSG13_1P_COLUMN_256_0[1]/RM_IHPSG13_1P_BITKIT_16x2_SRAM_2[1]/A_LWL<7>
+ RM_IHPSG13_1P_COLUMN_256_0[1]/RM_IHPSG13_1P_BITKIT_16x2_SRAM_0[2]/A_RWL<8> RM_IHPSG13_1P_COLUMN_256_0[1]/RM_IHPSG13_1P_BITKIT_16x2_SRAM_3[0]/A_RWL<7>
+ RM_IHPSG13_1P_COLUMN_256_0[1]/RM_IHPSG13_1P_BITKIT_16x2_SRAM_3[1]/A_LWL<9> RM_IHPSG13_1P_COLUMN_256_0[1]/RM_IHPSG13_1P_BITKIT_16x2_SRAM_3[3]/A_LWL<5>
+ RM_IHPSG13_1P_COLUMN_256_0[1]/RM_IHPSG13_1P_BITKIT_16x2_SRAM_0[2]/A_RWL<2> RM_IHPSG13_1P_COLUMN_256_0[1]/RM_IHPSG13_1P_BITKIT_16x2_SRAM_1[2]/A_LWL<2>
+ RM_IHPSG13_1P_COLUMN_256_0[1]/RM_IHPSG13_1P_BITKIT_16x2_SRAM_1[2]/A_RWL<14> RM_IHPSG13_1P_COLUMN_256_0[1]/RM_IHPSG13_1P_BITKIT_16x2_SRAM_2[1]/A_RWL<2>
+ RM_IHPSG13_1P_COLUMN_256_0[1]/RM_IHPSG13_1P_BITKIT_16x2_SRAM_0[1]/A_RWL<10> RM_IHPSG13_1P_COLUMN_256_0[1]/RM_IHPSG13_1P_BITKIT_16x2_SRAM_0[2]/A_LWL<3>
+ RM_IHPSG13_1P_COLUMN_256_0[1]/RM_IHPSG13_1P_BITKIT_16x2_SRAM_0[2]/A_RWL<15> RM_IHPSG13_1P_COLUMN_256_0[1]/RM_IHPSG13_1P_BITKIT_16x2_SRAM_3[2]/A_RWL<6>
+ RM_IHPSG13_1P_COLUMN_256_0[1]/RM_IHPSG13_1P_BITKIT_16x2_SRAM_1[3]/A_RWL<11> RM_IHPSG13_1P_COLUMN_256_0[1]/RM_IHPSG13_1P_BITKIT_16x2_SRAM_2[1]/A_RWL<15>
+ RM_IHPSG13_1P_COLUMN_256_0[1]/RM_IHPSG13_1P_BITKIT_16x2_SRAM_2[2]/A_RWL<7> RM_IHPSG13_1P_COLUMN_256_0[1]/RM_IHPSG13_1P_BITKIT_16x2_SRAM_1[2]/A_RWL<10>
+ RM_IHPSG13_1P_COLUMN_256_0[1]/RM_IHPSG13_1P_BITKIT_16x2_SRAM_0[3]/A_RWL<0> RM_IHPSG13_1P_COLUMN_256_0[1]/RM_IHPSG13_1P_BITKIT_16x2_SRAM_1[0]/A_RWL<1>
+ RM_IHPSG13_1P_COLUMN_256_0[1]/RM_IHPSG13_1P_BITKIT_16x2_SRAM_3[2]/A_LWL<1> RM_IHPSG13_1P_COLUMN_256_0[1]/RM_IHPSG13_1P_BITKIT_16x2_SRAM_1[2]/A_RWL<8>
+ RM_IHPSG13_1P_COLUMN_256_0[1]/RM_IHPSG13_1P_BITKIT_16x2_SRAM_0[2]/A_LWL<15> RM_IHPSG13_1P_COLUMN_256_0[1]/RM_IHPSG13_1P_BITKIT_16x2_SRAM_1[3]/A_RWL<5>
+ RM_IHPSG13_1P_COLUMN_256_0[1]/RM_IHPSG13_1P_BITKIT_16x2_SRAM_3[1]/A_RWL<10> RM_IHPSG13_1P_COLUMN_256_0[1]/RM_IHPSG13_1P_BITKIT_16x2_SRAM_0[0]/A_RWL<14>
+ RM_IHPSG13_1P_COLUMN_256_0[1]/RM_IHPSG13_1P_BITKIT_16x2_SRAM_2[2]/A_LWL<2> RM_IHPSG13_1P_COLUMN_256_0[1]/RM_IHPSG13_1P_BITKIT_16x2_SRAM_1[2]/A_LWL<8>
+ RM_IHPSG13_1P_COLUMN_256_0[1]/RM_IHPSG13_1P_BITKIT_16x2_SRAM_1[0]/A_RWL<8> RM_IHPSG13_1P_COLUMN_256_0[1]/RM_IHPSG13_1P_BITKIT_16x2_SRAM_0[3]/A_LWL<12>
+ RM_IHPSG13_1P_COLUMN_256_0[1]/RM_IHPSG13_1P_BITKIT_16x2_SRAM_1[2]/A_LWL<3> RM_IHPSG13_1P_COLUMN_256_0[1]/RM_IHPSG13_1P_BITKIT_16x2_SRAM_3[1]/A_LWL<8>
+ RM_IHPSG13_1P_COLUMN_256_0[1]/RM_IHPSG13_1P_BITKIT_16x2_SRAM_3[1]/A_RWL<12> RM_IHPSG13_1P_COLUMN_256_0[1]/RM_IHPSG13_1P_BITKIT_16x2_SRAM_1[3]/A_LWL<3>
+ RM_IHPSG13_1P_COLUMN_256_0[1]/RM_IHPSG13_1P_BITKIT_16x2_SRAM_1[2]/A_RWL<15> RM_IHPSG13_1P_COLUMN_256_0[1]/RM_IHPSG13_1P_BITKIT_16x2_SRAM_0[0]/A_LWL<15>
+ RM_IHPSG13_1P_COLUMN_256_0[1]/RM_IHPSG13_1P_BITKIT_16x2_SRAM_3[0]/A_RWL<9> RM_IHPSG13_1P_COLUMN_256_0[1]/RM_IHPSG13_1P_BITKIT_16x2_SRAM_0[1]/A_RWL<11>
+ RM_IHPSG13_1P_COLUMN_256_0[1]/RM_IHPSG13_1P_BITKIT_16x2_SRAM_3[3]/A_LWL<2> RM_IHPSG13_1P_COLUMN_256_0[1]/RM_IHPSG13_1P_BITKIT_16x2_SRAM_0[2]/A_LWL<4>
+ RM_IHPSG13_1P_COLUMN_256_0[1]/RM_IHPSG13_1P_BITKIT_16x2_SRAM_2[2]/A_LWL<13> RM_IHPSG13_1P_COLUMN_256_0[1]/RM_IHPSG13_1P_BITKIT_16x2_SRAM_3[2]/A_RWL<7>
+ RM_IHPSG13_1P_COLUMN_256_0[1]/RM_IHPSG13_1P_BITKIT_16x2_SRAM_1[3]/A_RWL<12> RM_IHPSG13_1P_COLUMN_256_0[1]/RM_IHPSG13_1P_BITKIT_16x2_SRAM_0[3]/A_LWL<0>
+ RM_IHPSG13_1P_COLUMN_256_0[1]/RM_IHPSG13_1P_BITKIT_16x2_SRAM_1[0]/A_LWL<10> RM_IHPSG13_1P_COLUMN_256_0[1]/RM_IHPSG13_1P_BITKIT_16x2_SRAM_1[3]/A_RWL<0>
+ RM_IHPSG13_1P_COLUMN_256_0[1]/RM_IHPSG13_1P_BITKIT_16x2_SRAM_2[2]/A_RWL<8> RM_IHPSG13_1P_COLUMN_256_0[1]/RM_IHPSG13_1P_BITKIT_16x2_SRAM_2[3]/A_LWL<11>
+ RM_IHPSG13_1P_COLUMN_256_0[1]/RM_IHPSG13_1P_BITKIT_16x2_SRAM_2[2]/A_LWL<0> RM_IHPSG13_1P_COLUMN_256_0[1]/RM_IHPSG13_1P_BITKIT_16x2_SRAM_0[3]/A_RWL<1>
+ RM_IHPSG13_1P_COLUMN_256_0[1]/RM_IHPSG13_1P_BITKIT_16x2_SRAM_3[2]/A_LWL<2> RM_IHPSG13_1P_COLUMN_256_0[1]/RM_IHPSG13_1P_BITKIT_16x2_SRAM_1[2]/A_RWL<9>
+ RM_IHPSG13_1P_COLUMN_256_0[1]/RM_IHPSG13_1P_BITKIT_16x2_SRAM_1[0]/A_RWL<7> RM_IHPSG13_1P_COLUMN_256_0[1]/RM_IHPSG13_1P_BITKIT_16x2_SRAM_1[3]/A_LWL<5>
+ RM_IHPSG13_1P_COLUMN_256_0[1]/RM_IHPSG13_1P_BITKIT_16x2_SRAM_2[2]/A_LWL<3> RM_IHPSG13_1P_COLUMN_256_0[1]/RM_IHPSG13_1P_BITKIT_16x2_SRAM_0[1]/A_RWL<2>
+ RM_IHPSG13_1P_COLUMN_256_0[1]/RM_IHPSG13_1P_BITKIT_16x2_SRAM_0[3]/A_LWL<13> RM_IHPSG13_1P_COLUMN_256_0[1]/RM_IHPSG13_1P_BITKIT_16x2_SRAM_1[2]/A_LWL<4>
+ RM_IHPSG13_1P_COLUMN_256_0[1]/RM_IHPSG13_1P_BITKIT_16x2_SRAM_2[0]/A_RWL<2> RM_IHPSG13_1P_COLUMN_256_0[1]/RM_IHPSG13_1P_BITKIT_16x2_SRAM_0[1]/A_RWL<12>
+ RM_IHPSG13_1P_COLUMN_256_0[1]/RM_IHPSG13_1P_BITKIT_16x2_SRAM_2[0]/A_RWL<0> RM_IHPSG13_1P_COLUMN_256_0[1]/RM_IHPSG13_1P_BITKIT_16x2_SRAM_3[3]/A_RWL<3>
+ RM_IHPSG13_1P_COLUMN_256_0[1]/RM_IHPSG13_1P_BITKIT_16x2_SRAM_0[1]/A_RWL<9> RM_IHPSG13_1P_COLUMN_256_0[1]/RM_IHPSG13_1P_BITKIT_16x2_SRAM_0[2]/A_LWL<5>
+ RM_IHPSG13_1P_COLUMN_256_0[1]/RM_IHPSG13_1P_BITKIT_16x2_SRAM_2[3]/A_RWL<4> RM_IHPSG13_1P_COLUMN_256_0[1]/RM_IHPSG13_1P_BITKIT_16x2_SRAM_2[3]/A_RWL<0>
+ RM_IHPSG13_1P_COLUMN_256_0[1]/RM_IHPSG13_1P_BITKIT_16x2_SRAM_3[2]/A_RWL<8> RM_IHPSG13_1P_COLUMN_256_0[1]/RM_IHPSG13_1P_BITKIT_16x2_SRAM_2[2]/A_RWL<13>
+ RM_IHPSG13_1P_COLUMN_256_0[1]/RM_IHPSG13_1P_BITKIT_16x2_SRAM_1[3]/A_RWL<13> RM_IHPSG13_1P_COLUMN_256_0[1]/RM_IHPSG13_1P_BITKIT_16x2_SRAM_2[0]/A_RWL<15>
+ RM_IHPSG13_1P_COLUMN_256_0[1]/RM_IHPSG13_1P_BITKIT_16x2_SRAM_1[3]/A_RWL<1> RM_IHPSG13_1P_COLUMN_256_0[1]/RM_IHPSG13_1P_BITKIT_16x2_SRAM_2[2]/A_RWL<9>
+ RM_IHPSG13_1P_COLUMN_256_0[1]/RM_IHPSG13_1P_BITKIT_16x2_SRAM_1[1]/A_RWL<10> RM_IHPSG13_1P_COLUMN_256_0[1]/RM_IHPSG13_1P_BITKIT_16x2_SRAM_2[2]/A_LWL<7>
+ RM_IHPSG13_1P_COLUMN_256_0[1]/RM_IHPSG13_1P_BITKIT_16x2_SRAM_0[3]/A_RWL<2> RM_IHPSG13_1P_COLUMN_256_0[1]/RM_IHPSG13_1P_BITKIT_16x2_SRAM_3[2]/A_LWL<3>
+ RM_IHPSG13_1P_COLUMN_256_0[1]/RM_IHPSG13_1P_BITKIT_16x2_SRAM_3[0]/A_RWL<10> RM_IHPSG13_1P_COLUMN_256_0[1]/RM_IHPSG13_1P_BITKIT_16x2_SRAM_2[2]/A_LWL<4>
+ RM_IHPSG13_1P_COLUMN_256_0[1]/RM_IHPSG13_1P_BITKIT_16x2_SRAM_1[1]/A_LWL<8> RM_IHPSG13_1P_COLUMN_256_0[1]/RM_IHPSG13_1P_BITKIT_16x2_SRAM_0[3]/A_LWL<14>
+ RM_IHPSG13_1P_COLUMN_256_0[1]/RM_IHPSG13_1P_BITKIT_16x2_SRAM_3[0]/A_LWL<8> RM_IHPSG13_1P_COLUMN_256_0[1]/RM_IHPSG13_1P_BITKIT_16x2_SRAM_3[3]/A_RWL<0>
+ RM_IHPSG13_1P_COLUMN_256_0[1]/RM_IHPSG13_1P_BITKIT_16x2_SRAM_0[2]/A_LWL<13> RM_IHPSG13_1P_COLUMN_256_0[1]/RM_IHPSG13_1P_BITKIT_16x2_SRAM_0[1]/A_RWL<13>
+ RM_IHPSG13_1P_COLUMN_256_0[1]/RM_IHPSG13_1P_BITKIT_16x2_SRAM_3[0]/A_LWL<10> RM_IHPSG13_1P_COLUMN_256_0[1]/RM_IHPSG13_1P_BITKIT_16x2_SRAM_2[1]/A_LWL<13>
+ RM_IHPSG13_1P_COLUMN_256_0[1]/RM_IHPSG13_1P_BITKIT_16x2_SRAM_0[2]/A_LWL<6> RM_IHPSG13_1P_COLUMN_256_0[1]/RM_IHPSG13_1P_BITKIT_16x2_SRAM_2[3]/A_RWL<1>
+ RM_IHPSG13_1P_COLUMN_256_0[1]/RM_IHPSG13_1P_BITKIT_16x2_SRAM_3[2]/A_RWL<9> RM_IHPSG13_1P_COLUMN_256_0[1]/RM_IHPSG13_1P_BITKIT_16x2_SRAM_0[3]/A_LWL<11>
+ RM_IHPSG13_1P_COLUMN_256_0[1]/RM_IHPSG13_1P_BITKIT_16x2_SRAM_1[3]/A_RWL<14> RM_IHPSG13_1P_COLUMN_256_0[1]/RM_IHPSG13_1P_BITKIT_16x2_SRAM_0[2]/A_LWL<0>
+ RM_IHPSG13_1P_COLUMN_256_0[1]/RM_IHPSG13_1P_BITKIT_16x2_SRAM_1[1]/A_RWL<1> RM_IHPSG13_1P_COLUMN_256_0[1]/RM_IHPSG13_1P_BITKIT_16x2_SRAM_0[2]/A_RWL<10>
+ RM_IHPSG13_1P_COLUMN_256_0[1]/RM_IHPSG13_1P_BITKIT_16x2_SRAM_1[3]/A_RWL<2> RM_IHPSG13_1P_COLUMN_256_0[1]/RM_IHPSG13_1P_BITKIT_16x2_SRAM_2[2]/A_LWL<11>
+ RM_IHPSG13_1P_COLUMN_256_0[1]/RM_IHPSG13_1P_BITKIT_16x2_SRAM_2[1]/A_LWL<0> RM_IHPSG13_1P_COLUMN_256_0[1]/RM_IHPSG13_1P_BITKIT_16x2_SRAM_0[3]/A_RWL<3>
+ RM_IHPSG13_1P_COLUMN_256_0[1]/RM_IHPSG13_1P_BITKIT_16x2_SRAM_3[2]/A_LWL<4> RM_IHPSG13_1P_COLUMN_256_0[1]/RM_IHPSG13_1P_BITKIT_16x2_SRAM_1[1]/A_RWL<8>
+ RM_IHPSG13_1P_COLUMN_256_0[1]/RM_IHPSG13_1P_BITKIT_16x2_SRAM_1[2]/A_LWL<5> RM_IHPSG13_1P_COLUMN_256_0[1]/RM_IHPSG13_1P_BITKIT_16x2_SRAM_1[0]/A_LWL<2>
+ RM_IHPSG13_1P_COLUMN_256_0[1]/RM_IHPSG13_1P_BITKIT_16x2_SRAM_3[2]/A_RWL<12> RM_IHPSG13_1P_COLUMN_256_0[1]/RM_IHPSG13_1P_BITKIT_16x2_SRAM_2[2]/A_LWL<5>
+ RM_IHPSG13_1P_COLUMN_256_0[1]/RM_IHPSG13_1P_BITKIT_16x2_SRAM_1[3]/A_LWL<6> RM_IHPSG13_1P_COLUMN_256_0[1]/RM_IHPSG13_1P_BITKIT_16x2_SRAM_3[1]/A_RWL<9>
+ RM_IHPSG13_1P_COLUMN_256_0[1]/RM_IHPSG13_1P_BITKIT_16x2_SRAM_3[1]/A_LWL<5> RM_IHPSG13_1P_COLUMN_256_0[1]/RM_IHPSG13_1P_BITKIT_16x2_SRAM_0[0]/A_RWL<2>
+ RM_IHPSG13_1P_COLUMN_256_0[1]/RM_IHPSG13_1P_BITKIT_16x2_SRAM_0[3]/A_LWL<15> RM_IHPSG13_1P_COLUMN_256_0[1]/RM_IHPSG13_1P_BITKIT_16x2_SRAM_1[2]/A_LWL<6>
+ RM_IHPSG13_1P_COLUMN_256_0[1]/RM_IHPSG13_1P_BITKIT_16x2_SRAM_3[3]/A_RWL<1> RM_IHPSG13_1P_COLUMN_256_0[1]/RM_IHPSG13_1P_BITKIT_16x2_SRAM_0[1]/A_RWL<14>
+ RM_IHPSG13_1P_COLUMN_256_0[1]/RM_IHPSG13_1P_BITKIT_16x2_SRAM_3[2]/A_RWL<3> RM_IHPSG13_1P_COLUMN_256_0[1]/RM_IHPSG13_1P_BITKIT_16x2_SRAM_3[0]/A_LWL<11>
+ RM_IHPSG13_1P_COLUMN_256_0[1]/RM_IHPSG13_1P_BITKIT_16x2_SRAM_0[2]/A_LWL<7> RM_IHPSG13_1P_COLUMN_256_0[1]/RM_IHPSG13_1P_BITKIT_16x2_SRAM_0[0]/A_RWL<15>
+ RM_IHPSG13_1P_COLUMN_256_0[1]/RM_IHPSG13_1P_BITKIT_16x2_SRAM_2[3]/A_RWL<2> RM_IHPSG13_1P_COLUMN_256_0[1]/RM_IHPSG13_1P_BITKIT_16x2_SRAM_2[3]/A_LWL<14>
+ RM_IHPSG13_1P_COLUMN_256_0[1]/RM_IHPSG13_1P_BITKIT_16x2_SRAM_1[3]/A_RWL<15> RM_IHPSG13_1P_COLUMN_256_0[1]/RM_IHPSG13_1P_BITKIT_16x2_SRAM_0[2]/A_RWL<11>
+ RM_IHPSG13_1P_COLUMN_256_0[1]/RM_IHPSG13_1P_BITKIT_16x2_SRAM_1[3]/A_RWL<3> RM_IHPSG13_1P_COLUMN_256_0[1]/RM_IHPSG13_1P_BITKIT_16x2_SRAM_1[0]/A_RWL<10>
+ RM_IHPSG13_1P_COLUMN_256_0[1]/RM_IHPSG13_1P_BITKIT_16x2_SRAM_0[3]/A_RWL<4> RM_IHPSG13_1P_COLUMN_256_0[1]/RM_IHPSG13_1P_BITKIT_16x2_SRAM_2[3]/A_RWL<11>
+ RM_IHPSG13_1P_COLUMN_256_0[1]/RM_IHPSG13_1P_BITKIT_16x2_SRAM_3[2]/A_LWL<5> RM_IHPSG13_1P_COLUMN_256_0[1]/RM_IHPSG13_1P_BITKIT_16x2_SRAM_0[0]/A_RWL<4>
+ RM_IHPSG13_1P_COLUMN_256_0[1]/RM_IHPSG13_1P_BITKIT_16x2_SRAM_2[2]/A_LWL<6> RM_IHPSG13_1P_COLUMN_256_0[1]/RM_IHPSG13_1P_BITKIT_16x2_SRAM_1[0]/A_LWL<8>
+ RM_IHPSG13_1P_COLUMN_256_0[1]/RM_IHPSG13_1P_BITKIT_16x2_SRAM_0[3]/A_RWL<12> RM_IHPSG13_1P_COLUMN_256_0[1]/RM_IHPSG13_1P_BITKIT_16x2_SRAM_2[1]/A_RWL<0>
+ RM_IHPSG13_1P_COLUMN_256_0[1]/RM_IHPSG13_1P_BITKIT_16x2_SRAM_3[3]/A_RWL<6> RM_IHPSG13_1P_COLUMN_256_0[1]/RM_IHPSG13_1P_BITKIT_16x2_SRAM_2[0]/A_RWL<5>
+ RM_IHPSG13_1P_COLUMN_256_0[1]/RM_IHPSG13_1P_BITKIT_16x2_SRAM_0[2]/A_RWL<9> RM_IHPSG13_1P_COLUMN_256_0[1]/RM_IHPSG13_1P_BITKIT_16x2_SRAM_1[2]/A_LWL<7>
+ RM_IHPSG13_1P_COLUMN_256_0[1]/RM_IHPSG13_1P_BITKIT_16x2_SRAM_0[1]/A_LWL<13> RM_IHPSG13_1P_COLUMN_256_0[1]/RM_IHPSG13_1P_BITKIT_16x2_SRAM_3[3]/A_RWL<2>
+ RM_IHPSG13_1P_COLUMN_256_0[1]/RM_IHPSG13_1P_BITKIT_16x2_SRAM_2[3]/A_RWL<13> RM_IHPSG13_1P_COLUMN_256_0[1]/RM_IHPSG13_1P_BITKIT_16x2_SRAM_0[1]/A_RWL<15>
+ RM_IHPSG13_1P_COLUMN_256_0[1]/RM_IHPSG13_1P_BITKIT_16x2_SRAM_3[0]/A_LWL<12> RM_IHPSG13_1P_COLUMN_256_0[1]/RM_IHPSG13_1P_BITKIT_16x2_SRAM_0[2]/A_LWL<8>
+ RM_IHPSG13_1P_COLUMN_256_0[1]/RM_IHPSG13_1P_BITKIT_16x2_SRAM_2[0]/A_LWL<13> RM_IHPSG13_1P_COLUMN_256_0[1]/RM_IHPSG13_1P_BITKIT_16x2_SRAM_2[3]/A_RWL<3>
+ RM_IHPSG13_1P_COLUMN_256_0[1]/RM_IHPSG13_1P_BITKIT_16x2_SRAM_0[2]/A_LWL<11> RM_IHPSG13_1P_COLUMN_256_0[1]/RM_IHPSG13_1P_BITKIT_16x2_SRAM_3[3]/A_LWL<12>
+ RM_IHPSG13_1P_COLUMN_256_0[1]/RM_IHPSG13_1P_BITKIT_16x2_SRAM_2[0]/A_LWL<3> RM_IHPSG13_1P_COLUMN_256_0[1]/RM_IHPSG13_1P_BITKIT_16x2_SRAM_0[1]/A_LWL<0>
+ RM_IHPSG13_1P_COLUMN_256_0[1]/RM_IHPSG13_1P_BITKIT_16x2_SRAM_2[3]/A_LWL<7> RM_IHPSG13_1P_COLUMN_256_0[1]/RM_IHPSG13_1P_BITKIT_16x2_SRAM_0[2]/A_RWL<12>
+ RM_IHPSG13_1P_COLUMN_256_0[1]/RM_IHPSG13_1P_BITKIT_16x2_SRAM_1[3]/A_RWL<4> RM_IHPSG13_1P_COLUMN_256_0[1]/RM_IHPSG13_1P_BITKIT_16x2_SRAM_2[1]/A_LWL<11>
+ RM_IHPSG13_1P_COLUMN_256_0[1]/RM_IHPSG13_1P_BITKIT_16x2_SRAM_2[0]/A_LWL<0> RM_IHPSG13_1P_COLUMN_256_0[7]/RM_IHPSG13_1P_BITKIT_16x2_SRAM_3[3]/VSS
+ RM_IHPSG13_1P_COLUMN_256_0[1]/RM_IHPSG13_1P_BITKIT_16x2_SRAM_0[3]/A_RWL<5> RM_IHPSG13_1P_COLUMN_256_0[7]/RM_IHPSG13_1P_BITKIT_16x2_SRAM_3[3]/VDD
+ RM_IHPSG13_1P_COLUMN_256_0[1]/RM_IHPSG13_1P_BITKIT_16x2_SRAM_3[2]/A_LWL<6> RM_IHPSG13_1P_COLUMN_256
XRM_IHPSG13_1P_COLUMN_256_0[2] RM_IHPSG13_1P_COLUMN_256_0[2]/RM_IHPSG13_1P_BITKIT_16x2_SRAM_0[0]/A_BLT_BOT<0>
+ RM_IHPSG13_1P_COLUMN_256_0[2]/RM_IHPSG13_1P_BITKIT_16x2_SRAM_0[0]/A_BLT_BOT<1> RM_IHPSG13_1P_COLUMN_256_0[2]/RM_IHPSG13_1P_BITKIT_16x2_SRAM_0[0]/A_BLC_BOT<0>
+ RM_IHPSG13_1P_COLUMN_256_0[2]/RM_IHPSG13_1P_BITKIT_16x2_SRAM_1[3]/A_RWL<6> RM_IHPSG13_1P_COLUMN_256_0[2]/RM_IHPSG13_1P_BITKIT_16x2_SRAM_0[3]/A_RWL<11>
+ RM_IHPSG13_1P_COLUMN_256_0[2]/RM_IHPSG13_1P_BITKIT_16x2_SRAM_0[0]/A_BLC_BOT<1> RM_IHPSG13_1P_COLUMN_256_0[2]/RM_IHPSG13_1P_BITKIT_16x2_SRAM_3[1]/A_LWL<12>
+ RM_IHPSG13_1P_COLUMN_256_0[2]/RM_IHPSG13_1P_BITKIT_16x2_SRAM_1[3]/A_RWL<8> RM_IHPSG13_1P_COLUMN_256_0[2]/RM_IHPSG13_1P_BITKIT_16x2_SRAM_0[3]/A_RWL<9>
+ RM_IHPSG13_1P_COLUMN_256_0[2]/RM_IHPSG13_1P_BITKIT_16x2_SRAM_0[3]/A_LWL<4> RM_IHPSG13_1P_COLUMN_256_0[2]/RM_IHPSG13_1P_BITKIT_16x2_SRAM_3[2]/A_LWL<9>
+ RM_IHPSG13_1P_COLUMN_256_0[2]/RM_IHPSG13_1P_BITKIT_16x2_SRAM_2[3]/A_LWL<1> RM_IHPSG13_1P_COLUMN_256_0[2]/RM_IHPSG13_1P_BITKIT_16x2_SRAM_0[3]/A_RWL<14>
+ RM_IHPSG13_1P_COLUMN_256_0[2]/RM_IHPSG13_1P_BITKIT_16x2_SRAM_0[2]/A_RWL<14> RM_IHPSG13_1P_COLUMN_256_0[2]/RM_IHPSG13_1P_BITKIT_16x2_SRAM_2[0]/A_LWL<11>
+ RM_IHPSG13_1P_COLUMN_256_0[2]/RM_IHPSG13_1P_BITKIT_16x2_SRAM_2[3]/A_LWL<4> RM_IHPSG13_1P_COLUMN_256_0[2]/RM_IHPSG13_1P_BITKIT_16x2_SRAM_3[2]/A_LWL<12>
+ RM_IHPSG13_1P_COLUMN_256_0[2]/RM_IHPSG13_1P_BITKIT_16x2_SRAM_1[2]/A_LWL<9> RM_IHPSG13_1P_COLUMN_256_0[2]/RM_IHPSG13_1P_BITKIT_16x2_SRAM_3[3]/A_RWL<9>
+ RM_IHPSG13_1P_COLUMN_256_0[2]/RM_IHPSG13_1P_BITKIT_16x2_SRAM_1[3]/A_LWL<2> RM_IHPSG13_1P_COLUMN_256_0[2]/RM_IHPSG13_1P_BITKIT_16x2_SRAM_0[3]/A_LWL<1>
+ RM_IHPSG13_1P_COLUMN_256_0[2]/RM_IHPSG13_1P_BITKIT_16x2_SRAM_2[3]/A_RWL<7> RM_IHPSG13_1P_COLUMN_256_0[2]/RM_IHPSG13_1P_BITKIT_16x2_SRAM_0[0]/A_RWL<0>
+ RM_IHPSG13_1P_COLUMN_256_0[2]/RM_IHPSG13_1P_BITKIT_16x2_SRAM_2[0]/A_RWL<1> RM_IHPSG13_1P_COLUMN_256_0[2]/RM_IHPSG13_1P_BITKIT_16x2_SRAM_0[2]/A_RWL<13>
+ RM_IHPSG13_1P_COLUMN_256_0[2]/RM_IHPSG13_1P_BITKIT_16x2_SRAM_2[3]/A_RWL<5> RM_IHPSG13_1P_COLUMN_256_0[2]/RM_IHPSG13_1P_BITKIT_16x2_SRAM_2[3]/A_LWL<3>
+ RM_IHPSG13_1P_COLUMN_256_0[2]/RM_IHPSG13_1P_BITKIT_16x2_SRAM_3[0]/A_RWL<13> RM_IHPSG13_1P_COLUMN_256_0[2]/RM_IHPSG13_1P_BITKIT_16x2_SRAM_1[0]/A_RWL<3>
+ RM_IHPSG13_1P_COLUMN_256_0[2]/RM_IHPSG13_1P_BITKIT_16x2_SRAM_3[1]/A_LWL<15> RM_IHPSG13_1P_COLUMN_256_0[2]/RM_IHPSG13_1P_BITKIT_16x2_SRAM_2[0]/A_LWL<14>
+ RM_IHPSG13_1P_COLUMN_256_0[2]/RM_IHPSG13_1P_BITKIT_16x2_SRAM_0[3]/A_RWL<7> RM_IHPSG13_1P_COLUMN_256_0[2]/RM_IHPSG13_1P_BITKIT_16x2_SRAM_3[0]/A_RWL<0>
+ RM_IHPSG13_1P_COLUMN_256_0[2]/RM_IHPSG13_1P_BITKIT_16x2_SRAM_3[2]/A_LWL<15> RM_IHPSG13_1P_COLUMN_256_0[2]/RM_IHPSG13_1P_BITKIT_16x2_SRAM_3[3]/A_RWL<4>
+ RM_IHPSG13_1P_COLUMN_256_0[2]/RM_IHPSG13_1P_BITKIT_16x2_SRAM_3[2]/A_LWL<7> RM_IHPSG13_1P_COLUMN_256_0[2]/RM_IHPSG13_1P_BITKIT_16x2_SRAM_0[0]/A_LWL<0>
+ RM_IHPSG13_1P_COLUMN_256_0[2]/RM_IHPSG13_1P_BITKIT_16x2_SRAM_1[3]/A_LWL<9> RM_IHPSG13_1P_COLUMN_256_0[2]/RM_IHPSG13_1P_BITKIT_16x2_SRAM_3[0]/A_RWL<3>
+ RM_IHPSG13_1P_COLUMN_256_0[2]/RM_IHPSG13_1P_BITKIT_16x2_SRAM_0[0]/A_RWL<5> RM_IHPSG13_1P_COLUMN_256_0[2]/RM_IHPSG13_1P_BITKIT_16x2_SRAM_0[3]/A_RWL<13>
+ RM_IHPSG13_1P_COLUMN_256_0[2]/RM_IHPSG13_1P_BITKIT_16x2_SRAM_2[3]/A_LWL<8> RM_IHPSG13_1P_COLUMN_256_0[2]/RM_IHPSG13_1P_BITKIT_16x2_SRAM_0[3]/A_LWL<7>
+ RM_IHPSG13_1P_COLUMN_256_0[2]/RM_IHPSG13_1P_BITKIT_16x2_SRAM_3[0]/A_LWL<15> RM_IHPSG13_1P_COLUMN_256_0[2]/RM_IHPSG13_1P_BITKIT_16x2_SRAM_3[3]/A_LWL<13>
+ RM_IHPSG13_1P_COLUMN_256_0[2]/RM_IHPSG13_1P_BITKIT_16x2_SRAM_2[3]/A_LWL<6> RM_IHPSG13_1P_COLUMN_256_0[2]/RM_IHPSG13_1P_BITKIT_16x2_SRAM_2[1]/A_LWL<10>
+ RM_IHPSG13_1P_COLUMN_256_0[2]/RM_IHPSG13_1P_BITKIT_16x2_SRAM_3[3]/A_LWL<0> RM_IHPSG13_1P_COLUMN_256_0[2]/RM_IHPSG13_1P_BITKIT_16x2_SRAM_3[0]/A_RWL<4>
+ RM_IHPSG13_1P_COLUMN_256_0[2]/RM_IHPSG13_1P_BITKIT_16x2_SRAM_2[2]/A_LWL<10> RM_IHPSG13_1P_COLUMN_256_0[2]/RM_IHPSG13_1P_BITKIT_16x2_SRAM_3[1]/A_RWL<13>
+ RM_IHPSG13_1P_COLUMN_256_0[2]/RM_IHPSG13_1P_BITKIT_16x2_SRAM_1[0]/A_RWL<6> RM_IHPSG13_1P_COLUMN_256_0[2]/RM_IHPSG13_1P_BITKIT_16x2_SRAM_3[3]/A_LWL<9>
+ RM_IHPSG13_1P_COLUMN_256_0[2]/RM_IHPSG13_1P_BITKIT_16x2_SRAM_1[0]/A_RWL<4> RM_IHPSG13_1P_COLUMN_256_0[2]/RM_IHPSG13_1P_BITKIT_16x2_SRAM_0[3]/A_RWL<10>
+ RM_IHPSG13_1P_COLUMN_256_0[2]/RM_IHPSG13_1P_BITKIT_16x2_SRAM_2[1]/A_LWL<14> RM_IHPSG13_1P_COLUMN_256_0[2]/RM_IHPSG13_1P_BITKIT_16x2_SRAM_3[0]/A_RWL<5>
+ RM_IHPSG13_1P_COLUMN_256_0[2]/RM_IHPSG13_1P_BITKIT_16x2_SRAM_0[3]/A_LWL<8> RM_IHPSG13_1P_COLUMN_256_0[2]/RM_IHPSG13_1P_BITKIT_16x2_SRAM_3[3]/A_LWL<7>
+ RM_IHPSG13_1P_COLUMN_256_0[2]/RM_IHPSG13_1P_BITKIT_16x2_SRAM_2[2]/A_LWL<8> RM_IHPSG13_1P_COLUMN_256_0[2]/RM_IHPSG13_1P_BITKIT_16x2_SRAM_3[3]/A_LWL<15>
+ RM_IHPSG13_1P_COLUMN_256_0[2]/RM_IHPSG13_1P_BITKIT_16x2_SRAM_3[2]/A_LWL<13> RM_IHPSG13_1P_COLUMN_256_0[2]/RM_IHPSG13_1P_BITKIT_16x2_SRAM_2[0]/A_LWL<1>
+ RM_IHPSG13_1P_COLUMN_256_0[2]/RM_IHPSG13_1P_BITKIT_16x2_SRAM_0[0]/A_LWL<1> RM_IHPSG13_1P_COLUMN_256_0[2]/RM_IHPSG13_1P_BITKIT_16x2_SRAM_1[3]/A_LWL<0>
+ RM_IHPSG13_1P_COLUMN_256_0[2]/RM_IHPSG13_1P_BITKIT_16x2_SRAM_2[0]/A_LWL<10> RM_IHPSG13_1P_COLUMN_256_0[2]/RM_IHPSG13_1P_BITKIT_16x2_SRAM_3[3]/A_LWL<11>
+ RM_IHPSG13_1P_COLUMN_256_0[2]/RM_IHPSG13_1P_BITKIT_16x2_SRAM_0[0]/A_LWL<3> RM_IHPSG13_1P_COLUMN_256_0[2]/RM_IHPSG13_1P_BITKIT_16x2_SRAM_3[0]/A_RWL<6>
+ RM_IHPSG13_1P_COLUMN_256_0[2]/RM_IHPSG13_1P_BITKIT_16x2_SRAM_2[3]/A_LWL<5> RM_IHPSG13_1P_COLUMN_256_0[2]/RM_IHPSG13_1P_BITKIT_16x2_SRAM_2[0]/A_RWL<7>
+ RM_IHPSG13_1P_COLUMN_256_0[2]/RM_IHPSG13_1P_BITKIT_16x2_SRAM_3[1]/A_RWL<15> RM_IHPSG13_1P_COLUMN_256_0[2]/RM_IHPSG13_1P_BITKIT_16x2_SRAM_0[1]/A_RWL<0>
+ RM_IHPSG13_1P_COLUMN_256_0[2]/RM_IHPSG13_1P_BITKIT_16x2_SRAM_3[0]/A_RWL<2> RM_IHPSG13_1P_COLUMN_256_0[2]/RM_IHPSG13_1P_BITKIT_16x2_SRAM_2[0]/A_RWL<11>
+ RM_IHPSG13_1P_COLUMN_256_0[2]/RM_IHPSG13_1P_BITKIT_16x2_SRAM_2[0]/A_LWL<2> RM_IHPSG13_1P_COLUMN_256_0[2]/RM_IHPSG13_1P_BITKIT_16x2_SRAM_3[0]/A_RWL<15>
+ RM_IHPSG13_1P_COLUMN_256_0[2]/RM_IHPSG13_1P_BITKIT_16x2_SRAM_0[0]/A_LWL<4> RM_IHPSG13_1P_COLUMN_256_0[2]/RM_IHPSG13_1P_BITKIT_16x2_SRAM_1[0]/A_LWL<12>
+ RM_IHPSG13_1P_COLUMN_256_0[2]/RM_IHPSG13_1P_BITKIT_16x2_SRAM_2[0]/A_RWL<8> RM_IHPSG13_1P_COLUMN_256_0[2]/RM_IHPSG13_1P_BITKIT_16x2_SRAM_1[0]/A_RWL<9>
+ RM_IHPSG13_1P_COLUMN_256_0[2]/RM_IHPSG13_1P_BITKIT_16x2_SRAM_3[1]/A_LWL<13> RM_IHPSG13_1P_COLUMN_256_0[2]/RM_IHPSG13_1P_BITKIT_16x2_SRAM_1[3]/A_RWL<9>
+ RM_IHPSG13_1P_COLUMN_256_0[2]/RM_IHPSG13_1P_BITKIT_16x2_SRAM_2[3]/A_LWL<10> RM_IHPSG13_1P_COLUMN_256_0[2]/RM_IHPSG13_1P_BITKIT_16x2_SRAM_3[2]/A_RWL<13>
+ RM_IHPSG13_1P_COLUMN_256_0[2]/RM_IHPSG13_1P_BITKIT_16x2_SRAM_3[2]/A_LWL<11> RM_IHPSG13_1P_COLUMN_256_0[2]/RM_IHPSG13_1P_BITKIT_16x2_SRAM_0[0]/A_RWL<7>
+ RM_IHPSG13_1P_COLUMN_256_0[2]/RM_IHPSG13_1P_BITKIT_16x2_SRAM_0[3]/A_LWL<5> RM_IHPSG13_1P_COLUMN_256_0[2]/RM_IHPSG13_1P_BITKIT_16x2_SRAM_1[0]/A_RWL<2>
+ RM_IHPSG13_1P_COLUMN_256_0[2]/RM_IHPSG13_1P_BITKIT_16x2_SRAM_2[2]/A_LWL<14> RM_IHPSG13_1P_COLUMN_256_0[2]/RM_IHPSG13_1P_BITKIT_16x2_SRAM_3[0]/A_LWL<3>
+ RM_IHPSG13_1P_COLUMN_256_0[2]/RM_IHPSG13_1P_BITKIT_16x2_SRAM_2[0]/A_LWL<4> RM_IHPSG13_1P_COLUMN_256_0[2]/RM_IHPSG13_1P_BITKIT_16x2_SRAM_3[3]/A_LWL<14>
+ RM_IHPSG13_1P_COLUMN_256_0[2]/RM_IHPSG13_1P_BITKIT_16x2_SRAM_2[1]/A_RWL<10> RM_IHPSG13_1P_COLUMN_256_0[2]/RM_IHPSG13_1P_BITKIT_16x2_SRAM_1[0]/A_LWL<5>
+ RM_IHPSG13_1P_COLUMN_256_0[2]/RM_IHPSG13_1P_BITKIT_16x2_SRAM_3[1]/A_RWL<0> RM_IHPSG13_1P_COLUMN_256_0[2]/RM_IHPSG13_1P_BITKIT_16x2_SRAM_2[0]/A_RWL<10>
+ RM_IHPSG13_1P_COLUMN_256_0[2]/RM_IHPSG13_1P_BITKIT_16x2_SRAM_2[0]/A_RWL<12> RM_IHPSG13_1P_COLUMN_256_0[2]/RM_IHPSG13_1P_BITKIT_16x2_SRAM_3[3]/A_RWL<11>
+ RM_IHPSG13_1P_COLUMN_256_0[2]/RM_IHPSG13_1P_BITKIT_16x2_SRAM_0[0]/A_LWL<6> RM_IHPSG13_1P_COLUMN_256_0[2]/RM_IHPSG13_1P_BITKIT_16x2_SRAM_2[1]/A_RWL<1>
+ RM_IHPSG13_1P_COLUMN_256_0[2]/RM_IHPSG13_1P_BITKIT_16x2_SRAM_2[3]/A_RWL<8> RM_IHPSG13_1P_COLUMN_256_0[2]/RM_IHPSG13_1P_BITKIT_16x2_SRAM_1[1]/A_RWL<2>
+ RM_IHPSG13_1P_COLUMN_256_0[2]/RM_IHPSG13_1P_BITKIT_16x2_SRAM_2[0]/A_RWL<14> RM_IHPSG13_1P_COLUMN_256_0[2]/RM_IHPSG13_1P_BITKIT_16x2_SRAM_3[0]/A_LWL<13>
+ RM_IHPSG13_1P_COLUMN_256_0[2]/RM_IHPSG13_1P_BITKIT_16x2_SRAM_3[2]/A_RWL<15> RM_IHPSG13_1P_COLUMN_256_0[2]/RM_IHPSG13_1P_BITKIT_16x2_SRAM_2[1]/A_RWL<11>
+ RM_IHPSG13_1P_COLUMN_256_0[2]/RM_IHPSG13_1P_BITKIT_16x2_SRAM_3[1]/A_LWL<11> RM_IHPSG13_1P_COLUMN_256_0[2]/RM_IHPSG13_1P_BITKIT_16x2_SRAM_3[0]/A_LWL<0>
+ RM_IHPSG13_1P_COLUMN_256_0[2]/RM_IHPSG13_1P_BITKIT_16x2_SRAM_3[3]/A_RWL<12> RM_IHPSG13_1P_COLUMN_256_0[2]/RM_IHPSG13_1P_BITKIT_16x2_SRAM_0[0]/A_LWL<7>
+ RM_IHPSG13_1P_COLUMN_256_0[2]/RM_IHPSG13_1P_BITKIT_16x2_SRAM_1[0]/A_LWL<15> RM_IHPSG13_1P_COLUMN_256_0[2]/RM_IHPSG13_1P_BITKIT_16x2_SRAM_1[1]/A_RWL<3>
+ RM_IHPSG13_1P_COLUMN_256_0[2]/RM_IHPSG13_1P_BITKIT_16x2_SRAM_1[1]/A_LWL<12> RM_IHPSG13_1P_COLUMN_256_0[2]/RM_IHPSG13_1P_BITKIT_16x2_SRAM_0[1]/A_RWL<4>
+ RM_IHPSG13_1P_COLUMN_256_0[2]/RM_IHPSG13_1P_BITKIT_16x2_SRAM_3[0]/A_LWL<5> RM_IHPSG13_1P_COLUMN_256_0[2]/RM_IHPSG13_1P_BITKIT_16x2_SRAM_2[0]/A_LWL<6>
+ RM_IHPSG13_1P_COLUMN_256_0[2]/RM_IHPSG13_1P_BITKIT_16x2_SRAM_3[2]/A_LWL<14> RM_IHPSG13_1P_COLUMN_256_0[2]/RM_IHPSG13_1P_BITKIT_16x2_SRAM_1[0]/A_LWL<7>
+ RM_IHPSG13_1P_COLUMN_256_0[2]/RM_IHPSG13_1P_BITKIT_16x2_SRAM_3[1]/A_RWL<2> RM_IHPSG13_1P_COLUMN_256_0[2]/RM_IHPSG13_1P_BITKIT_16x2_SRAM_3[2]/A_RWL<11>
+ RM_IHPSG13_1P_COLUMN_256_0[2]/RM_IHPSG13_1P_BITKIT_16x2_SRAM_3[3]/A_RWL<13> RM_IHPSG13_1P_COLUMN_256_0[2]/RM_IHPSG13_1P_BITKIT_16x2_SRAM_0[0]/A_LWL<8>
+ RM_IHPSG13_1P_COLUMN_256_0[2]/RM_IHPSG13_1P_BITKIT_16x2_SRAM_2[3]/A_RWL<6> RM_IHPSG13_1P_COLUMN_256_0[2]/RM_IHPSG13_1P_BITKIT_16x2_SRAM_1[1]/A_RWL<4>
+ RM_IHPSG13_1P_COLUMN_256_0[2]/RM_IHPSG13_1P_BITKIT_16x2_SRAM_0[0]/A_RWL<1> RM_IHPSG13_1P_COLUMN_256_0[2]/RM_IHPSG13_1P_BITKIT_16x2_SRAM_1[1]/A_LWL<13>
+ RM_IHPSG13_1P_COLUMN_256_0[2]/RM_IHPSG13_1P_BITKIT_16x2_SRAM_1[0]/A_LWL<13> RM_IHPSG13_1P_COLUMN_256_0[2]/RM_IHPSG13_1P_BITKIT_16x2_SRAM_0[1]/A_RWL<5>
+ RM_IHPSG13_1P_COLUMN_256_0[2]/RM_IHPSG13_1P_BITKIT_16x2_SRAM_3[0]/A_LWL<6> RM_IHPSG13_1P_COLUMN_256_0[2]/RM_IHPSG13_1P_BITKIT_16x2_SRAM_2[3]/A_LWL<12>
+ RM_IHPSG13_1P_COLUMN_256_0[2]/RM_IHPSG13_1P_BITKIT_16x2_SRAM_1[1]/A_LWL<11> RM_IHPSG13_1P_COLUMN_256_0[2]/RM_IHPSG13_1P_BITKIT_16x2_SRAM_0[0]/A_RWL<8>
+ RM_IHPSG13_1P_COLUMN_256_0[2]/RM_IHPSG13_1P_BITKIT_16x2_SRAM_1[0]/A_LWL<0> RM_IHPSG13_1P_COLUMN_256_0[2]/RM_IHPSG13_1P_BITKIT_16x2_SRAM_0[3]/A_LWL<3>
+ RM_IHPSG13_1P_COLUMN_256_0[2]/RM_IHPSG13_1P_BITKIT_16x2_SRAM_2[1]/A_RWL<12> RM_IHPSG13_1P_COLUMN_256_0[2]/RM_IHPSG13_1P_BITKIT_16x2_SRAM_2[0]/A_RWL<9>
+ RM_IHPSG13_1P_COLUMN_256_0[2]/RM_IHPSG13_1P_BITKIT_16x2_SRAM_3[1]/A_RWL<3> RM_IHPSG13_1P_COLUMN_256_0[2]/RM_IHPSG13_1P_BITKIT_16x2_SRAM_2[3]/A_LWL<2>
+ RM_IHPSG13_1P_COLUMN_256_0[2]/RM_IHPSG13_1P_BITKIT_16x2_SRAM_3[3]/A_RWL<14> RM_IHPSG13_1P_COLUMN_256_0[2]/RM_IHPSG13_1P_BITKIT_16x2_SRAM_2[2]/A_RWL<10>
+ RM_IHPSG13_1P_COLUMN_256_0[2]/RM_IHPSG13_1P_BITKIT_16x2_SRAM_2[0]/A_LWL<5> RM_IHPSG13_1P_COLUMN_256_0[2]/RM_IHPSG13_1P_BITKIT_16x2_SRAM_3[3]/A_LWL<4>
+ RM_IHPSG13_1P_COLUMN_256_0[2]/RM_IHPSG13_1P_BITKIT_16x2_SRAM_2[1]/A_RWL<3> RM_IHPSG13_1P_COLUMN_256_0[2]/RM_IHPSG13_1P_BITKIT_16x2_SRAM_3[0]/A_LWL<7>
+ RM_IHPSG13_1P_COLUMN_256_0[2]/RM_IHPSG13_1P_BITKIT_16x2_SRAM_0[0]/A_LWL<10> RM_IHPSG13_1P_COLUMN_256_0[2]/RM_IHPSG13_1P_BITKIT_16x2_SRAM_1[1]/A_LWL<0>
+ RM_IHPSG13_1P_COLUMN_256_0[2]/RM_IHPSG13_1P_BITKIT_16x2_SRAM_2[0]/A_LWL<8> RM_IHPSG13_1P_COLUMN_256_0[2]/RM_IHPSG13_1P_BITKIT_16x2_SRAM_3[1]/A_LWL<14>
+ RM_IHPSG13_1P_COLUMN_256_0[2]/RM_IHPSG13_1P_BITKIT_16x2_SRAM_1[2]/A_LWL<11> RM_IHPSG13_1P_COLUMN_256_0[2]/RM_IHPSG13_1P_BITKIT_16x2_SRAM_2[1]/A_RWL<14>
+ RM_IHPSG13_1P_COLUMN_256_0[2]/RM_IHPSG13_1P_BITKIT_16x2_SRAM_0[1]/A_LWL<1> RM_IHPSG13_1P_COLUMN_256_0[2]/RM_IHPSG13_1P_BITKIT_16x2_SRAM_1[0]/A_LWL<9>
+ RM_IHPSG13_1P_COLUMN_256_0[2]/RM_IHPSG13_1P_BITKIT_16x2_SRAM_3[1]/A_RWL<4> RM_IHPSG13_1P_COLUMN_256_0[2]/RM_IHPSG13_1P_BITKIT_16x2_SRAM_1[0]/A_RWL<0>
+ RM_IHPSG13_1P_COLUMN_256_0[2]/RM_IHPSG13_1P_BITKIT_16x2_SRAM_3[1]/A_RWL<11> RM_IHPSG13_1P_COLUMN_256_0[2]/RM_IHPSG13_1P_BITKIT_16x2_SRAM_3[3]/A_RWL<15>
+ RM_IHPSG13_1P_COLUMN_256_0[2]/RM_IHPSG13_1P_BITKIT_16x2_SRAM_0[3]/A_RWL<6> RM_IHPSG13_1P_COLUMN_256_0[2]/RM_IHPSG13_1P_BITKIT_16x2_SRAM_2[1]/A_RWL<5>
+ RM_IHPSG13_1P_COLUMN_256_0[2]/RM_IHPSG13_1P_BITKIT_16x2_SRAM_2[2]/A_RWL<11> RM_IHPSG13_1P_COLUMN_256_0[2]/RM_IHPSG13_1P_BITKIT_16x2_SRAM_3[0]/A_RWL<1>
+ RM_IHPSG13_1P_COLUMN_256_0[2]/RM_IHPSG13_1P_BITKIT_16x2_SRAM_3[3]/A_RWL<5> RM_IHPSG13_1P_COLUMN_256_0[2]/RM_IHPSG13_1P_BITKIT_16x2_SRAM_1[1]/A_RWL<6>
+ RM_IHPSG13_1P_COLUMN_256_0[2]/RM_IHPSG13_1P_BITKIT_16x2_SRAM_3[0]/A_RWL<8> RM_IHPSG13_1P_COLUMN_256_0[2]/RM_IHPSG13_1P_BITKIT_16x2_SRAM_1[1]/A_LWL<15>
+ RM_IHPSG13_1P_COLUMN_256_0[2]/RM_IHPSG13_1P_BITKIT_16x2_SRAM_0[1]/A_RWL<7> RM_IHPSG13_1P_COLUMN_256_0[2]/RM_IHPSG13_1P_BITKIT_16x2_SRAM_3[3]/A_LWL<3>
+ RM_IHPSG13_1P_COLUMN_256_0[2]/RM_IHPSG13_1P_BITKIT_16x2_SRAM_0[0]/A_LWL<11> RM_IHPSG13_1P_COLUMN_256_0[2]/RM_IHPSG13_1P_BITKIT_16x2_SRAM_2[2]/A_LWL<12>
+ RM_IHPSG13_1P_COLUMN_256_0[2]/RM_IHPSG13_1P_BITKIT_16x2_SRAM_1[0]/A_LWL<11> RM_IHPSG13_1P_COLUMN_256_0[2]/RM_IHPSG13_1P_BITKIT_16x2_SRAM_1[2]/A_LWL<12>
+ RM_IHPSG13_1P_COLUMN_256_0[2]/RM_IHPSG13_1P_BITKIT_16x2_SRAM_3[2]/A_RWL<14> RM_IHPSG13_1P_COLUMN_256_0[2]/RM_IHPSG13_1P_BITKIT_16x2_SRAM_3[1]/A_RWL<5>
+ RM_IHPSG13_1P_COLUMN_256_0[2]/RM_IHPSG13_1P_BITKIT_16x2_SRAM_0[0]/A_LWL<5> RM_IHPSG13_1P_COLUMN_256_0[2]/RM_IHPSG13_1P_BITKIT_16x2_SRAM_1[3]/A_LWL<4>
+ RM_IHPSG13_1P_COLUMN_256_0[2]/RM_IHPSG13_1P_BITKIT_16x2_SRAM_0[1]/A_RWL<1> RM_IHPSG13_1P_COLUMN_256_0[2]/RM_IHPSG13_1P_BITKIT_16x2_SRAM_0[1]/A_RWL<3>
+ RM_IHPSG13_1P_COLUMN_256_0[2]/RM_IHPSG13_1P_BITKIT_16x2_SRAM_3[1]/A_LWL<0> RM_IHPSG13_1P_COLUMN_256_0[2]/RM_IHPSG13_1P_BITKIT_16x2_SRAM_2[0]/A_RWL<3>
+ RM_IHPSG13_1P_COLUMN_256_0[2]/RM_IHPSG13_1P_BITKIT_16x2_SRAM_2[3]/A_LWL<9> RM_IHPSG13_1P_COLUMN_256_0[2]/RM_IHPSG13_1P_BITKIT_16x2_SRAM_2[1]/A_LWL<1>
+ RM_IHPSG13_1P_COLUMN_256_0[2]/RM_IHPSG13_1P_BITKIT_16x2_SRAM_3[0]/A_LWL<9> RM_IHPSG13_1P_COLUMN_256_0[2]/RM_IHPSG13_1P_BITKIT_16x2_SRAM_0[1]/A_RWL<8>
+ RM_IHPSG13_1P_COLUMN_256_0[2]/RM_IHPSG13_1P_BITKIT_16x2_SRAM_1[1]/A_LWL<14> RM_IHPSG13_1P_COLUMN_256_0[2]/RM_IHPSG13_1P_BITKIT_16x2_SRAM_0[0]/A_LWL<2>
+ RM_IHPSG13_1P_COLUMN_256_0[2]/RM_IHPSG13_1P_BITKIT_16x2_SRAM_2[2]/A_RWL<12> RM_IHPSG13_1P_COLUMN_256_0[2]/RM_IHPSG13_1P_BITKIT_16x2_SRAM_1[1]/A_LWL<2>
+ RM_IHPSG13_1P_COLUMN_256_0[2]/RM_IHPSG13_1P_BITKIT_16x2_SRAM_0[3]/A_LWL<6> RM_IHPSG13_1P_COLUMN_256_0[2]/RM_IHPSG13_1P_BITKIT_16x2_SRAM_3[0]/A_LWL<14>
+ RM_IHPSG13_1P_COLUMN_256_0[2]/RM_IHPSG13_1P_BITKIT_16x2_SRAM_1[2]/A_LWL<13> RM_IHPSG13_1P_COLUMN_256_0[2]/RM_IHPSG13_1P_BITKIT_16x2_SRAM_0[1]/A_LWL<3>
+ RM_IHPSG13_1P_COLUMN_256_0[2]/RM_IHPSG13_1P_BITKIT_16x2_SRAM_1[0]/A_RWL<12> RM_IHPSG13_1P_COLUMN_256_0[2]/RM_IHPSG13_1P_BITKIT_16x2_SRAM_3[1]/A_RWL<6>
+ RM_IHPSG13_1P_COLUMN_256_0[2]/RM_IHPSG13_1P_BITKIT_16x2_SRAM_3[0]/A_RWL<11> RM_IHPSG13_1P_COLUMN_256_0[2]/RM_IHPSG13_1P_BITKIT_16x2_SRAM_3[3]/A_LWL<1>
+ RM_IHPSG13_1P_COLUMN_256_0[2]/RM_IHPSG13_1P_BITKIT_16x2_SRAM_2[1]/A_RWL<7> RM_IHPSG13_1P_COLUMN_256_0[2]/RM_IHPSG13_1P_BITKIT_16x2_SRAM_2[1]/A_RWL<6>
+ RM_IHPSG13_1P_COLUMN_256_0[2]/RM_IHPSG13_1P_BITKIT_16x2_SRAM_0[2]/A_RWL<0> RM_IHPSG13_1P_COLUMN_256_0[2]/RM_IHPSG13_1P_BITKIT_16x2_SRAM_2[3]/A_RWL<10>
+ RM_IHPSG13_1P_COLUMN_256_0[2]/RM_IHPSG13_1P_BITKIT_16x2_SRAM_2[1]/A_LWL<2> RM_IHPSG13_1P_COLUMN_256_0[2]/RM_IHPSG13_1P_BITKIT_16x2_SRAM_0[0]/A_LWL<13>
+ RM_IHPSG13_1P_COLUMN_256_0[2]/RM_IHPSG13_1P_BITKIT_16x2_SRAM_2[1]/A_LWL<12> RM_IHPSG13_1P_COLUMN_256_0[2]/RM_IHPSG13_1P_BITKIT_16x2_SRAM_1[1]/A_RWL<0>
+ RM_IHPSG13_1P_COLUMN_256_0[2]/RM_IHPSG13_1P_BITKIT_16x2_SRAM_1[2]/A_LWL<14> RM_IHPSG13_1P_COLUMN_256_0[2]/RM_IHPSG13_1P_BITKIT_16x2_SRAM_1[0]/A_RWL<5>
+ RM_IHPSG13_1P_COLUMN_256_0[2]/RM_IHPSG13_1P_BITKIT_16x2_SRAM_0[1]/A_LWL<10> RM_IHPSG13_1P_COLUMN_256_0[2]/RM_IHPSG13_1P_BITKIT_16x2_SRAM_0[1]/A_LWL<4>
+ RM_IHPSG13_1P_COLUMN_256_0[2]/RM_IHPSG13_1P_BITKIT_16x2_SRAM_3[1]/A_RWL<14> RM_IHPSG13_1P_COLUMN_256_0[2]/RM_IHPSG13_1P_BITKIT_16x2_SRAM_3[1]/A_RWL<1>
+ RM_IHPSG13_1P_COLUMN_256_0[2]/RM_IHPSG13_1P_BITKIT_16x2_SRAM_1[0]/A_RWL<13> RM_IHPSG13_1P_COLUMN_256_0[2]/RM_IHPSG13_1P_BITKIT_16x2_SRAM_1[3]/A_LWL<11>
+ RM_IHPSG13_1P_COLUMN_256_0[2]/RM_IHPSG13_1P_BITKIT_16x2_SRAM_2[1]/A_RWL<8> RM_IHPSG13_1P_COLUMN_256_0[2]/RM_IHPSG13_1P_BITKIT_16x2_SRAM_1[0]/A_LWL<3>
+ RM_IHPSG13_1P_COLUMN_256_0[2]/RM_IHPSG13_1P_BITKIT_16x2_SRAM_2[2]/A_RWL<14> RM_IHPSG13_1P_COLUMN_256_0[2]/RM_IHPSG13_1P_BITKIT_16x2_SRAM_1[3]/A_LWL<7>
+ RM_IHPSG13_1P_COLUMN_256_0[2]/RM_IHPSG13_1P_BITKIT_16x2_SRAM_0[0]/A_RWL<3> RM_IHPSG13_1P_COLUMN_256_0[2]/RM_IHPSG13_1P_BITKIT_16x2_SRAM_0[3]/A_LWL<9>
+ RM_IHPSG13_1P_COLUMN_256_0[2]/RM_IHPSG13_1P_BITKIT_16x2_SRAM_3[0]/A_LWL<2> RM_IHPSG13_1P_COLUMN_256_0[2]/RM_IHPSG13_1P_BITKIT_16x2_SRAM_1[1]/A_RWL<9>
+ RM_IHPSG13_1P_COLUMN_256_0[2]/RM_IHPSG13_1P_BITKIT_16x2_SRAM_3[3]/A_LWL<6> RM_IHPSG13_1P_COLUMN_256_0[2]/RM_IHPSG13_1P_BITKIT_16x2_SRAM_2[2]/A_LWL<9>
+ RM_IHPSG13_1P_COLUMN_256_0[2]/RM_IHPSG13_1P_BITKIT_16x2_SRAM_2[1]/A_LWL<3> RM_IHPSG13_1P_COLUMN_256_0[2]/RM_IHPSG13_1P_BITKIT_16x2_SRAM_0[0]/A_LWL<14>
+ RM_IHPSG13_1P_COLUMN_256_0[2]/RM_IHPSG13_1P_BITKIT_16x2_SRAM_1[0]/A_LWL<14> RM_IHPSG13_1P_COLUMN_256_0[2]/RM_IHPSG13_1P_BITKIT_16x2_SRAM_2[3]/A_LWL<15>
+ RM_IHPSG13_1P_COLUMN_256_0[2]/RM_IHPSG13_1P_BITKIT_16x2_SRAM_1[2]/A_LWL<15> RM_IHPSG13_1P_COLUMN_256_0[2]/RM_IHPSG13_1P_BITKIT_16x2_SRAM_0[1]/A_LWL<11>
+ RM_IHPSG13_1P_COLUMN_256_0[2]/RM_IHPSG13_1P_BITKIT_16x2_SRAM_0[1]/A_LWL<5> RM_IHPSG13_1P_COLUMN_256_0[2]/RM_IHPSG13_1P_BITKIT_16x2_SRAM_1[0]/A_RWL<11>
+ RM_IHPSG13_1P_COLUMN_256_0[2]/RM_IHPSG13_1P_BITKIT_16x2_SRAM_2[2]/A_RWL<0> RM_IHPSG13_1P_COLUMN_256_0[2]/RM_IHPSG13_1P_BITKIT_16x2_SRAM_1[3]/A_LWL<1>
+ RM_IHPSG13_1P_COLUMN_256_0[2]/RM_IHPSG13_1P_BITKIT_16x2_SRAM_3[1]/A_RWL<8> RM_IHPSG13_1P_COLUMN_256_0[2]/RM_IHPSG13_1P_BITKIT_16x2_SRAM_0[2]/A_RWL<1>
+ RM_IHPSG13_1P_COLUMN_256_0[2]/RM_IHPSG13_1P_BITKIT_16x2_SRAM_3[3]/A_LWL<10> RM_IHPSG13_1P_COLUMN_256_0[2]/RM_IHPSG13_1P_BITKIT_16x2_SRAM_1[3]/A_LWL<12>
+ RM_IHPSG13_1P_COLUMN_256_0[2]/RM_IHPSG13_1P_BITKIT_16x2_SRAM_1[2]/A_RWL<1> RM_IHPSG13_1P_COLUMN_256_0[2]/RM_IHPSG13_1P_BITKIT_16x2_SRAM_0[1]/A_RWL<6>
+ RM_IHPSG13_1P_COLUMN_256_0[2]/RM_IHPSG13_1P_BITKIT_16x2_SRAM_2[1]/A_RWL<9> RM_IHPSG13_1P_COLUMN_256_0[2]/RM_IHPSG13_1P_BITKIT_16x2_SRAM_1[1]/A_RWL<11>
+ RM_IHPSG13_1P_COLUMN_256_0[2]/RM_IHPSG13_1P_BITKIT_16x2_SRAM_2[0]/A_RWL<6> RM_IHPSG13_1P_COLUMN_256_0[2]/RM_IHPSG13_1P_BITKIT_16x2_SRAM_3[1]/A_LWL<3>
+ RM_IHPSG13_1P_COLUMN_256_0[2]/RM_IHPSG13_1P_BITKIT_16x2_SRAM_2[0]/A_RWL<4> RM_IHPSG13_1P_COLUMN_256_0[2]/RM_IHPSG13_1P_BITKIT_16x2_SRAM_3[3]/A_RWL<7>
+ RM_IHPSG13_1P_COLUMN_256_0[2]/RM_IHPSG13_1P_BITKIT_16x2_SRAM_0[1]/A_LWL<2> RM_IHPSG13_1P_COLUMN_256_0[2]/RM_IHPSG13_1P_BITKIT_16x2_SRAM_2[3]/A_RWL<12>
+ RM_IHPSG13_1P_COLUMN_256_0[2]/RM_IHPSG13_1P_BITKIT_16x2_SRAM_2[1]/A_LWL<4> RM_IHPSG13_1P_COLUMN_256_0[2]/RM_IHPSG13_1P_BITKIT_16x2_SRAM_2[0]/A_LWL<12>
+ RM_IHPSG13_1P_COLUMN_256_0[2]/RM_IHPSG13_1P_BITKIT_16x2_SRAM_1[1]/A_LWL<5> RM_IHPSG13_1P_COLUMN_256_0[2]/RM_IHPSG13_1P_BITKIT_16x2_SRAM_3[2]/A_RWL<0>
+ RM_IHPSG13_1P_COLUMN_256_0[2]/RM_IHPSG13_1P_BITKIT_16x2_SRAM_0[1]/A_LWL<12> RM_IHPSG13_1P_COLUMN_256_0[2]/RM_IHPSG13_1P_BITKIT_16x2_SRAM_0[1]/A_LWL<6>
+ RM_IHPSG13_1P_COLUMN_256_0[2]/RM_IHPSG13_1P_BITKIT_16x2_SRAM_2[2]/A_RWL<1> RM_IHPSG13_1P_COLUMN_256_0[2]/RM_IHPSG13_1P_BITKIT_16x2_SRAM_3[0]/A_RWL<14>
+ RM_IHPSG13_1P_COLUMN_256_0[2]/RM_IHPSG13_1P_BITKIT_16x2_SRAM_1[0]/A_RWL<15> RM_IHPSG13_1P_COLUMN_256_0[2]/RM_IHPSG13_1P_BITKIT_16x2_SRAM_1[1]/A_LWL<4>
+ RM_IHPSG13_1P_COLUMN_256_0[2]/RM_IHPSG13_1P_BITKIT_16x2_SRAM_1[3]/A_LWL<13> RM_IHPSG13_1P_COLUMN_256_0[2]/RM_IHPSG13_1P_BITKIT_16x2_SRAM_1[2]/A_RWL<2>
+ RM_IHPSG13_1P_COLUMN_256_0[2]/RM_IHPSG13_1P_BITKIT_16x2_SRAM_1[1]/A_RWL<12> RM_IHPSG13_1P_COLUMN_256_0[2]/RM_IHPSG13_1P_BITKIT_16x2_SRAM_3[0]/A_LWL<4>
+ RM_IHPSG13_1P_COLUMN_256_0[2]/RM_IHPSG13_1P_BITKIT_16x2_SRAM_0[2]/A_LWL<9> RM_IHPSG13_1P_COLUMN_256_0[2]/RM_IHPSG13_1P_BITKIT_16x2_SRAM_0[2]/A_RWL<3>
+ RM_IHPSG13_1P_COLUMN_256_0[2]/RM_IHPSG13_1P_BITKIT_16x2_SRAM_3[1]/A_LWL<4> RM_IHPSG13_1P_COLUMN_256_0[2]/RM_IHPSG13_1P_BITKIT_16x2_SRAM_2[1]/A_LWL<5>
+ RM_IHPSG13_1P_COLUMN_256_0[2]/RM_IHPSG13_1P_BITKIT_16x2_SRAM_1[2]/A_RWL<0> RM_IHPSG13_1P_COLUMN_256_0[2]/RM_IHPSG13_1P_BITKIT_16x2_SRAM_1[1]/A_RWL<5>
+ RM_IHPSG13_1P_COLUMN_256_0[2]/RM_IHPSG13_1P_BITKIT_16x2_SRAM_2[2]/A_LWL<15> RM_IHPSG13_1P_COLUMN_256_0[2]/RM_IHPSG13_1P_BITKIT_16x2_SRAM_3[2]/A_RWL<1>
+ RM_IHPSG13_1P_COLUMN_256_0[2]/RM_IHPSG13_1P_BITKIT_16x2_SRAM_1[3]/A_LWL<10> RM_IHPSG13_1P_COLUMN_256_0[2]/RM_IHPSG13_1P_BITKIT_16x2_SRAM_0[1]/A_LWL<7>
+ RM_IHPSG13_1P_COLUMN_256_0[2]/RM_IHPSG13_1P_BITKIT_16x2_SRAM_1[1]/A_LWL<3> RM_IHPSG13_1P_COLUMN_256_0[2]/RM_IHPSG13_1P_BITKIT_16x2_SRAM_1[0]/A_LWL<6>
+ RM_IHPSG13_1P_COLUMN_256_0[2]/RM_IHPSG13_1P_BITKIT_16x2_SRAM_3[2]/A_LWL<10> RM_IHPSG13_1P_COLUMN_256_0[2]/RM_IHPSG13_1P_BITKIT_16x2_SRAM_1[3]/A_LWL<14>
+ RM_IHPSG13_1P_COLUMN_256_0[2]/RM_IHPSG13_1P_BITKIT_16x2_SRAM_3[1]/A_LWL<1> RM_IHPSG13_1P_COLUMN_256_0[2]/RM_IHPSG13_1P_BITKIT_16x2_SRAM_3[1]/A_LWL<2>
+ RM_IHPSG13_1P_COLUMN_256_0[2]/RM_IHPSG13_1P_BITKIT_16x2_SRAM_0[0]/A_RWL<6> RM_IHPSG13_1P_COLUMN_256_0[2]/RM_IHPSG13_1P_BITKIT_16x2_SRAM_1[2]/A_RWL<3>
+ RM_IHPSG13_1P_COLUMN_256_0[2]/RM_IHPSG13_1P_BITKIT_16x2_SRAM_0[2]/A_LWL<10> RM_IHPSG13_1P_COLUMN_256_0[2]/RM_IHPSG13_1P_BITKIT_16x2_SRAM_1[3]/A_RWL<7>
+ RM_IHPSG13_1P_COLUMN_256_0[2]/RM_IHPSG13_1P_BITKIT_16x2_SRAM_1[1]/A_RWL<13> RM_IHPSG13_1P_COLUMN_256_0[2]/RM_IHPSG13_1P_BITKIT_16x2_SRAM_0[2]/A_RWL<4>
+ RM_IHPSG13_1P_COLUMN_256_0[2]/RM_IHPSG13_1P_BITKIT_16x2_SRAM_0[0]/A_LWL<12> RM_IHPSG13_1P_COLUMN_256_0[2]/RM_IHPSG13_1P_BITKIT_16x2_SRAM_2[3]/A_RWL<14>
+ RM_IHPSG13_1P_COLUMN_256_0[2]/RM_IHPSG13_1P_BITKIT_16x2_SRAM_2[1]/A_LWL<6> RM_IHPSG13_1P_COLUMN_256_0[2]/RM_IHPSG13_1P_BITKIT_16x2_SRAM_1[1]/A_LWL<7>
+ RM_IHPSG13_1P_COLUMN_256_0[2]/RM_IHPSG13_1P_BITKIT_16x2_SRAM_3[2]/A_RWL<2> RM_IHPSG13_1P_COLUMN_256_0[2]/RM_IHPSG13_1P_BITKIT_16x2_SRAM_1[0]/A_RWL<14>
+ RM_IHPSG13_1P_COLUMN_256_0[2]/RM_IHPSG13_1P_BITKIT_16x2_SRAM_0[1]/A_LWL<14> RM_IHPSG13_1P_COLUMN_256_0[2]/RM_IHPSG13_1P_BITKIT_16x2_SRAM_0[1]/A_LWL<8>
+ RM_IHPSG13_1P_COLUMN_256_0[2]/RM_IHPSG13_1P_BITKIT_16x2_SRAM_2[2]/A_RWL<3> RM_IHPSG13_1P_COLUMN_256_0[2]/RM_IHPSG13_1P_BITKIT_16x2_SRAM_1[3]/A_LWL<15>
+ RM_IHPSG13_1P_COLUMN_256_0[2]/RM_IHPSG13_1P_BITKIT_16x2_SRAM_1[0]/A_LWL<4> RM_IHPSG13_1P_COLUMN_256_0[2]/RM_IHPSG13_1P_BITKIT_16x2_SRAM_1[2]/A_RWL<4>
+ RM_IHPSG13_1P_COLUMN_256_0[2]/RM_IHPSG13_1P_BITKIT_16x2_SRAM_0[3]/A_RWL<8> RM_IHPSG13_1P_COLUMN_256_0[2]/RM_IHPSG13_1P_BITKIT_16x2_SRAM_2[1]/A_RWL<4>
+ RM_IHPSG13_1P_COLUMN_256_0[2]/RM_IHPSG13_1P_BITKIT_16x2_SRAM_2[0]/A_RWL<13> RM_IHPSG13_1P_COLUMN_256_0[2]/RM_IHPSG13_1P_BITKIT_16x2_SRAM_3[3]/A_RWL<10>
+ RM_IHPSG13_1P_COLUMN_256_0[2]/RM_IHPSG13_1P_BITKIT_16x2_SRAM_1[1]/A_RWL<14> RM_IHPSG13_1P_COLUMN_256_0[2]/RM_IHPSG13_1P_BITKIT_16x2_SRAM_0[2]/A_RWL<5>
+ RM_IHPSG13_1P_COLUMN_256_0[2]/RM_IHPSG13_1P_BITKIT_16x2_SRAM_0[0]/A_RWL<10> RM_IHPSG13_1P_COLUMN_256_0[2]/RM_IHPSG13_1P_BITKIT_16x2_SRAM_2[3]/A_RWL<9>
+ RM_IHPSG13_1P_COLUMN_256_0[2]/RM_IHPSG13_1P_BITKIT_16x2_SRAM_3[1]/A_LWL<6> RM_IHPSG13_1P_COLUMN_256_0[2]/RM_IHPSG13_1P_BITKIT_16x2_SRAM_2[0]/A_LWL<9>
+ RM_IHPSG13_1P_COLUMN_256_0[2]/RM_IHPSG13_1P_BITKIT_16x2_SRAM_2[3]/A_RWL<15> RM_IHPSG13_1P_COLUMN_256_0[2]/RM_IHPSG13_1P_BITKIT_16x2_SRAM_1[2]/A_RWL<11>
+ RM_IHPSG13_1P_COLUMN_256_0[2]/RM_IHPSG13_1P_BITKIT_16x2_SRAM_2[0]/A_LWL<7> RM_IHPSG13_1P_COLUMN_256_0[2]/RM_IHPSG13_1P_BITKIT_16x2_SRAM_3[3]/A_LWL<8>
+ RM_IHPSG13_1P_COLUMN_256_0[2]/RM_IHPSG13_1P_BITKIT_16x2_SRAM_2[1]/A_LWL<15> RM_IHPSG13_1P_COLUMN_256_0[2]/RM_IHPSG13_1P_BITKIT_16x2_SRAM_1[2]/A_LWL<10>
+ RM_IHPSG13_1P_COLUMN_256_0[2]/RM_IHPSG13_1P_BITKIT_16x2_SRAM_0[1]/A_LWL<9> RM_IHPSG13_1P_COLUMN_256_0[2]/RM_IHPSG13_1P_BITKIT_16x2_SRAM_1[1]/A_LWL<1>
+ RM_IHPSG13_1P_COLUMN_256_0[2]/RM_IHPSG13_1P_BITKIT_16x2_SRAM_3[1]/A_LWL<10> RM_IHPSG13_1P_COLUMN_256_0[2]/RM_IHPSG13_1P_BITKIT_16x2_SRAM_3[0]/A_LWL<1>
+ RM_IHPSG13_1P_COLUMN_256_0[2]/RM_IHPSG13_1P_BITKIT_16x2_SRAM_0[2]/A_LWL<12> RM_IHPSG13_1P_COLUMN_256_0[2]/RM_IHPSG13_1P_BITKIT_16x2_SRAM_1[1]/A_RWL<15>
+ RM_IHPSG13_1P_COLUMN_256_0[2]/RM_IHPSG13_1P_BITKIT_16x2_SRAM_0[2]/A_RWL<6> RM_IHPSG13_1P_COLUMN_256_0[2]/RM_IHPSG13_1P_BITKIT_16x2_SRAM_0[0]/A_RWL<11>
+ RM_IHPSG13_1P_COLUMN_256_0[2]/RM_IHPSG13_1P_BITKIT_16x2_SRAM_3[1]/A_LWL<7> RM_IHPSG13_1P_COLUMN_256_0[2]/RM_IHPSG13_1P_BITKIT_16x2_SRAM_3[1]/A_RWL<7>
+ RM_IHPSG13_1P_COLUMN_256_0[2]/RM_IHPSG13_1P_BITKIT_16x2_SRAM_1[2]/A_RWL<5> RM_IHPSG13_1P_COLUMN_256_0[2]/RM_IHPSG13_1P_BITKIT_16x2_SRAM_1[2]/A_LWL<0>
+ RM_IHPSG13_1P_COLUMN_256_0[2]/RM_IHPSG13_1P_BITKIT_16x2_SRAM_1[2]/A_RWL<12> RM_IHPSG13_1P_COLUMN_256_0[2]/RM_IHPSG13_1P_BITKIT_16x2_SRAM_2[1]/A_LWL<8>
+ RM_IHPSG13_1P_COLUMN_256_0[2]/RM_IHPSG13_1P_BITKIT_16x2_SRAM_2[2]/A_RWL<2> RM_IHPSG13_1P_COLUMN_256_0[2]/RM_IHPSG13_1P_BITKIT_16x2_SRAM_0[2]/A_LWL<1>
+ RM_IHPSG13_1P_COLUMN_256_0[2]/RM_IHPSG13_1P_BITKIT_16x2_SRAM_0[3]/A_RWL<15> RM_IHPSG13_1P_COLUMN_256_0[2]/RM_IHPSG13_1P_BITKIT_16x2_SRAM_1[1]/A_LWL<9>
+ RM_IHPSG13_1P_COLUMN_256_0[2]/RM_IHPSG13_1P_BITKIT_16x2_SRAM_3[2]/A_RWL<4> RM_IHPSG13_1P_COLUMN_256_0[2]/RM_IHPSG13_1P_BITKIT_16x2_SRAM_3[0]/A_RWL<12>
+ RM_IHPSG13_1P_COLUMN_256_0[2]/RM_IHPSG13_1P_BITKIT_16x2_SRAM_1[1]/A_LWL<6> RM_IHPSG13_1P_COLUMN_256_0[2]/RM_IHPSG13_1P_BITKIT_16x2_SRAM_3[3]/A_RWL<8>
+ RM_IHPSG13_1P_COLUMN_256_0[2]/RM_IHPSG13_1P_BITKIT_16x2_SRAM_2[2]/A_RWL<15> RM_IHPSG13_1P_COLUMN_256_0[2]/RM_IHPSG13_1P_BITKIT_16x2_SRAM_2[2]/A_RWL<5>
+ RM_IHPSG13_1P_COLUMN_256_0[2]/RM_IHPSG13_1P_BITKIT_16x2_SRAM_1[2]/A_RWL<6> RM_IHPSG13_1P_COLUMN_256_0[2]/RM_IHPSG13_1P_BITKIT_16x2_SRAM_3[2]/A_RWL<10>
+ RM_IHPSG13_1P_COLUMN_256_0[2]/RM_IHPSG13_1P_BITKIT_16x2_SRAM_0[0]/A_LWL<9> RM_IHPSG13_1P_COLUMN_256_0[2]/RM_IHPSG13_1P_BITKIT_16x2_SRAM_0[0]/A_RWL<12>
+ RM_IHPSG13_1P_COLUMN_256_0[2]/RM_IHPSG13_1P_BITKIT_16x2_SRAM_0[2]/A_RWL<7> RM_IHPSG13_1P_COLUMN_256_0[2]/RM_IHPSG13_1P_BITKIT_16x2_SRAM_1[3]/A_LWL<8>
+ RM_IHPSG13_1P_COLUMN_256_0[2]/RM_IHPSG13_1P_BITKIT_16x2_SRAM_0[3]/A_LWL<10> RM_IHPSG13_1P_COLUMN_256_0[2]/RM_IHPSG13_1P_BITKIT_16x2_SRAM_1[2]/A_LWL<1>
+ RM_IHPSG13_1P_COLUMN_256_0[2]/RM_IHPSG13_1P_BITKIT_16x2_SRAM_2[1]/A_LWL<9> RM_IHPSG13_1P_COLUMN_256_0[2]/RM_IHPSG13_1P_BITKIT_16x2_SRAM_1[2]/A_RWL<13>
+ RM_IHPSG13_1P_COLUMN_256_0[2]/RM_IHPSG13_1P_BITKIT_16x2_SRAM_0[1]/A_LWL<15> RM_IHPSG13_1P_COLUMN_256_0[2]/RM_IHPSG13_1P_BITKIT_16x2_SRAM_3[2]/A_LWL<8>
+ RM_IHPSG13_1P_COLUMN_256_0[2]/RM_IHPSG13_1P_BITKIT_16x2_SRAM_0[2]/A_LWL<2> RM_IHPSG13_1P_COLUMN_256_0[2]/RM_IHPSG13_1P_BITKIT_16x2_SRAM_2[0]/A_LWL<15>
+ RM_IHPSG13_1P_COLUMN_256_0[2]/RM_IHPSG13_1P_BITKIT_16x2_SRAM_2[3]/A_LWL<13> RM_IHPSG13_1P_COLUMN_256_0[2]/RM_IHPSG13_1P_BITKIT_16x2_SRAM_3[2]/A_RWL<5>
+ RM_IHPSG13_1P_COLUMN_256_0[2]/RM_IHPSG13_1P_BITKIT_16x2_SRAM_1[3]/A_RWL<10> RM_IHPSG13_1P_COLUMN_256_0[2]/RM_IHPSG13_1P_BITKIT_16x2_SRAM_1[1]/A_LWL<10>
+ RM_IHPSG13_1P_COLUMN_256_0[2]/RM_IHPSG13_1P_BITKIT_16x2_SRAM_0[0]/A_RWL<9> RM_IHPSG13_1P_COLUMN_256_0[2]/RM_IHPSG13_1P_BITKIT_16x2_SRAM_1[0]/A_LWL<1>
+ RM_IHPSG13_1P_COLUMN_256_0[2]/RM_IHPSG13_1P_BITKIT_16x2_SRAM_2[2]/A_RWL<6> RM_IHPSG13_1P_COLUMN_256_0[2]/RM_IHPSG13_1P_BITKIT_16x2_SRAM_2[2]/A_RWL<4>
+ RM_IHPSG13_1P_COLUMN_256_0[2]/RM_IHPSG13_1P_BITKIT_16x2_SRAM_2[1]/A_RWL<13> RM_IHPSG13_1P_COLUMN_256_0[2]/RM_IHPSG13_1P_BITKIT_16x2_SRAM_0[3]/A_LWL<2>
+ RM_IHPSG13_1P_COLUMN_256_0[2]/RM_IHPSG13_1P_BITKIT_16x2_SRAM_2[3]/A_LWL<0> RM_IHPSG13_1P_COLUMN_256_0[2]/RM_IHPSG13_1P_BITKIT_16x2_SRAM_3[2]/A_LWL<0>
+ RM_IHPSG13_1P_COLUMN_256_0[2]/RM_IHPSG13_1P_BITKIT_16x2_SRAM_1[2]/A_RWL<7> RM_IHPSG13_1P_COLUMN_256_0[2]/RM_IHPSG13_1P_BITKIT_16x2_SRAM_0[2]/A_LWL<14>
+ RM_IHPSG13_1P_COLUMN_256_0[2]/RM_IHPSG13_1P_BITKIT_16x2_SRAM_1[1]/A_RWL<7> RM_IHPSG13_1P_COLUMN_256_0[2]/RM_IHPSG13_1P_BITKIT_16x2_SRAM_2[2]/A_LWL<1>
+ RM_IHPSG13_1P_COLUMN_256_0[2]/RM_IHPSG13_1P_BITKIT_16x2_SRAM_0[0]/A_RWL<13> RM_IHPSG13_1P_COLUMN_256_0[2]/RM_IHPSG13_1P_BITKIT_16x2_SRAM_2[1]/A_LWL<7>
+ RM_IHPSG13_1P_COLUMN_256_0[2]/RM_IHPSG13_1P_BITKIT_16x2_SRAM_0[2]/A_RWL<8> RM_IHPSG13_1P_COLUMN_256_0[2]/RM_IHPSG13_1P_BITKIT_16x2_SRAM_3[0]/A_RWL<7>
+ RM_IHPSG13_1P_COLUMN_256_0[2]/RM_IHPSG13_1P_BITKIT_16x2_SRAM_3[1]/A_LWL<9> RM_IHPSG13_1P_COLUMN_256_0[2]/RM_IHPSG13_1P_BITKIT_16x2_SRAM_3[3]/A_LWL<5>
+ RM_IHPSG13_1P_COLUMN_256_0[2]/RM_IHPSG13_1P_BITKIT_16x2_SRAM_0[2]/A_RWL<2> RM_IHPSG13_1P_COLUMN_256_0[2]/RM_IHPSG13_1P_BITKIT_16x2_SRAM_1[2]/A_LWL<2>
+ RM_IHPSG13_1P_COLUMN_256_0[2]/RM_IHPSG13_1P_BITKIT_16x2_SRAM_1[2]/A_RWL<14> RM_IHPSG13_1P_COLUMN_256_0[2]/RM_IHPSG13_1P_BITKIT_16x2_SRAM_2[1]/A_RWL<2>
+ RM_IHPSG13_1P_COLUMN_256_0[2]/RM_IHPSG13_1P_BITKIT_16x2_SRAM_0[1]/A_RWL<10> RM_IHPSG13_1P_COLUMN_256_0[2]/RM_IHPSG13_1P_BITKIT_16x2_SRAM_0[2]/A_LWL<3>
+ RM_IHPSG13_1P_COLUMN_256_0[2]/RM_IHPSG13_1P_BITKIT_16x2_SRAM_0[2]/A_RWL<15> RM_IHPSG13_1P_COLUMN_256_0[2]/RM_IHPSG13_1P_BITKIT_16x2_SRAM_3[2]/A_RWL<6>
+ RM_IHPSG13_1P_COLUMN_256_0[2]/RM_IHPSG13_1P_BITKIT_16x2_SRAM_1[3]/A_RWL<11> RM_IHPSG13_1P_COLUMN_256_0[2]/RM_IHPSG13_1P_BITKIT_16x2_SRAM_2[1]/A_RWL<15>
+ RM_IHPSG13_1P_COLUMN_256_0[2]/RM_IHPSG13_1P_BITKIT_16x2_SRAM_2[2]/A_RWL<7> RM_IHPSG13_1P_COLUMN_256_0[2]/RM_IHPSG13_1P_BITKIT_16x2_SRAM_1[2]/A_RWL<10>
+ RM_IHPSG13_1P_COLUMN_256_0[2]/RM_IHPSG13_1P_BITKIT_16x2_SRAM_0[3]/A_RWL<0> RM_IHPSG13_1P_COLUMN_256_0[2]/RM_IHPSG13_1P_BITKIT_16x2_SRAM_1[0]/A_RWL<1>
+ RM_IHPSG13_1P_COLUMN_256_0[2]/RM_IHPSG13_1P_BITKIT_16x2_SRAM_3[2]/A_LWL<1> RM_IHPSG13_1P_COLUMN_256_0[2]/RM_IHPSG13_1P_BITKIT_16x2_SRAM_1[2]/A_RWL<8>
+ RM_IHPSG13_1P_COLUMN_256_0[2]/RM_IHPSG13_1P_BITKIT_16x2_SRAM_0[2]/A_LWL<15> RM_IHPSG13_1P_COLUMN_256_0[2]/RM_IHPSG13_1P_BITKIT_16x2_SRAM_1[3]/A_RWL<5>
+ RM_IHPSG13_1P_COLUMN_256_0[2]/RM_IHPSG13_1P_BITKIT_16x2_SRAM_3[1]/A_RWL<10> RM_IHPSG13_1P_COLUMN_256_0[2]/RM_IHPSG13_1P_BITKIT_16x2_SRAM_0[0]/A_RWL<14>
+ RM_IHPSG13_1P_COLUMN_256_0[2]/RM_IHPSG13_1P_BITKIT_16x2_SRAM_2[2]/A_LWL<2> RM_IHPSG13_1P_COLUMN_256_0[2]/RM_IHPSG13_1P_BITKIT_16x2_SRAM_1[2]/A_LWL<8>
+ RM_IHPSG13_1P_COLUMN_256_0[2]/RM_IHPSG13_1P_BITKIT_16x2_SRAM_1[0]/A_RWL<8> RM_IHPSG13_1P_COLUMN_256_0[2]/RM_IHPSG13_1P_BITKIT_16x2_SRAM_0[3]/A_LWL<12>
+ RM_IHPSG13_1P_COLUMN_256_0[2]/RM_IHPSG13_1P_BITKIT_16x2_SRAM_1[2]/A_LWL<3> RM_IHPSG13_1P_COLUMN_256_0[2]/RM_IHPSG13_1P_BITKIT_16x2_SRAM_3[1]/A_LWL<8>
+ RM_IHPSG13_1P_COLUMN_256_0[2]/RM_IHPSG13_1P_BITKIT_16x2_SRAM_3[1]/A_RWL<12> RM_IHPSG13_1P_COLUMN_256_0[2]/RM_IHPSG13_1P_BITKIT_16x2_SRAM_1[3]/A_LWL<3>
+ RM_IHPSG13_1P_COLUMN_256_0[2]/RM_IHPSG13_1P_BITKIT_16x2_SRAM_1[2]/A_RWL<15> RM_IHPSG13_1P_COLUMN_256_0[2]/RM_IHPSG13_1P_BITKIT_16x2_SRAM_0[0]/A_LWL<15>
+ RM_IHPSG13_1P_COLUMN_256_0[2]/RM_IHPSG13_1P_BITKIT_16x2_SRAM_3[0]/A_RWL<9> RM_IHPSG13_1P_COLUMN_256_0[2]/RM_IHPSG13_1P_BITKIT_16x2_SRAM_0[1]/A_RWL<11>
+ RM_IHPSG13_1P_COLUMN_256_0[2]/RM_IHPSG13_1P_BITKIT_16x2_SRAM_3[3]/A_LWL<2> RM_IHPSG13_1P_COLUMN_256_0[2]/RM_IHPSG13_1P_BITKIT_16x2_SRAM_0[2]/A_LWL<4>
+ RM_IHPSG13_1P_COLUMN_256_0[2]/RM_IHPSG13_1P_BITKIT_16x2_SRAM_2[2]/A_LWL<13> RM_IHPSG13_1P_COLUMN_256_0[2]/RM_IHPSG13_1P_BITKIT_16x2_SRAM_3[2]/A_RWL<7>
+ RM_IHPSG13_1P_COLUMN_256_0[2]/RM_IHPSG13_1P_BITKIT_16x2_SRAM_1[3]/A_RWL<12> RM_IHPSG13_1P_COLUMN_256_0[2]/RM_IHPSG13_1P_BITKIT_16x2_SRAM_0[3]/A_LWL<0>
+ RM_IHPSG13_1P_COLUMN_256_0[2]/RM_IHPSG13_1P_BITKIT_16x2_SRAM_1[0]/A_LWL<10> RM_IHPSG13_1P_COLUMN_256_0[2]/RM_IHPSG13_1P_BITKIT_16x2_SRAM_1[3]/A_RWL<0>
+ RM_IHPSG13_1P_COLUMN_256_0[2]/RM_IHPSG13_1P_BITKIT_16x2_SRAM_2[2]/A_RWL<8> RM_IHPSG13_1P_COLUMN_256_0[2]/RM_IHPSG13_1P_BITKIT_16x2_SRAM_2[3]/A_LWL<11>
+ RM_IHPSG13_1P_COLUMN_256_0[2]/RM_IHPSG13_1P_BITKIT_16x2_SRAM_2[2]/A_LWL<0> RM_IHPSG13_1P_COLUMN_256_0[2]/RM_IHPSG13_1P_BITKIT_16x2_SRAM_0[3]/A_RWL<1>
+ RM_IHPSG13_1P_COLUMN_256_0[2]/RM_IHPSG13_1P_BITKIT_16x2_SRAM_3[2]/A_LWL<2> RM_IHPSG13_1P_COLUMN_256_0[2]/RM_IHPSG13_1P_BITKIT_16x2_SRAM_1[2]/A_RWL<9>
+ RM_IHPSG13_1P_COLUMN_256_0[2]/RM_IHPSG13_1P_BITKIT_16x2_SRAM_1[0]/A_RWL<7> RM_IHPSG13_1P_COLUMN_256_0[2]/RM_IHPSG13_1P_BITKIT_16x2_SRAM_1[3]/A_LWL<5>
+ RM_IHPSG13_1P_COLUMN_256_0[2]/RM_IHPSG13_1P_BITKIT_16x2_SRAM_2[2]/A_LWL<3> RM_IHPSG13_1P_COLUMN_256_0[2]/RM_IHPSG13_1P_BITKIT_16x2_SRAM_0[1]/A_RWL<2>
+ RM_IHPSG13_1P_COLUMN_256_0[2]/RM_IHPSG13_1P_BITKIT_16x2_SRAM_0[3]/A_LWL<13> RM_IHPSG13_1P_COLUMN_256_0[2]/RM_IHPSG13_1P_BITKIT_16x2_SRAM_1[2]/A_LWL<4>
+ RM_IHPSG13_1P_COLUMN_256_0[2]/RM_IHPSG13_1P_BITKIT_16x2_SRAM_2[0]/A_RWL<2> RM_IHPSG13_1P_COLUMN_256_0[2]/RM_IHPSG13_1P_BITKIT_16x2_SRAM_0[1]/A_RWL<12>
+ RM_IHPSG13_1P_COLUMN_256_0[2]/RM_IHPSG13_1P_BITKIT_16x2_SRAM_2[0]/A_RWL<0> RM_IHPSG13_1P_COLUMN_256_0[2]/RM_IHPSG13_1P_BITKIT_16x2_SRAM_3[3]/A_RWL<3>
+ RM_IHPSG13_1P_COLUMN_256_0[2]/RM_IHPSG13_1P_BITKIT_16x2_SRAM_0[1]/A_RWL<9> RM_IHPSG13_1P_COLUMN_256_0[2]/RM_IHPSG13_1P_BITKIT_16x2_SRAM_0[2]/A_LWL<5>
+ RM_IHPSG13_1P_COLUMN_256_0[2]/RM_IHPSG13_1P_BITKIT_16x2_SRAM_2[3]/A_RWL<4> RM_IHPSG13_1P_COLUMN_256_0[2]/RM_IHPSG13_1P_BITKIT_16x2_SRAM_2[3]/A_RWL<0>
+ RM_IHPSG13_1P_COLUMN_256_0[2]/RM_IHPSG13_1P_BITKIT_16x2_SRAM_3[2]/A_RWL<8> RM_IHPSG13_1P_COLUMN_256_0[2]/RM_IHPSG13_1P_BITKIT_16x2_SRAM_2[2]/A_RWL<13>
+ RM_IHPSG13_1P_COLUMN_256_0[2]/RM_IHPSG13_1P_BITKIT_16x2_SRAM_1[3]/A_RWL<13> RM_IHPSG13_1P_COLUMN_256_0[2]/RM_IHPSG13_1P_BITKIT_16x2_SRAM_2[0]/A_RWL<15>
+ RM_IHPSG13_1P_COLUMN_256_0[2]/RM_IHPSG13_1P_BITKIT_16x2_SRAM_1[3]/A_RWL<1> RM_IHPSG13_1P_COLUMN_256_0[2]/RM_IHPSG13_1P_BITKIT_16x2_SRAM_2[2]/A_RWL<9>
+ RM_IHPSG13_1P_COLUMN_256_0[2]/RM_IHPSG13_1P_BITKIT_16x2_SRAM_1[1]/A_RWL<10> RM_IHPSG13_1P_COLUMN_256_0[2]/RM_IHPSG13_1P_BITKIT_16x2_SRAM_2[2]/A_LWL<7>
+ RM_IHPSG13_1P_COLUMN_256_0[2]/RM_IHPSG13_1P_BITKIT_16x2_SRAM_0[3]/A_RWL<2> RM_IHPSG13_1P_COLUMN_256_0[2]/RM_IHPSG13_1P_BITKIT_16x2_SRAM_3[2]/A_LWL<3>
+ RM_IHPSG13_1P_COLUMN_256_0[2]/RM_IHPSG13_1P_BITKIT_16x2_SRAM_3[0]/A_RWL<10> RM_IHPSG13_1P_COLUMN_256_0[2]/RM_IHPSG13_1P_BITKIT_16x2_SRAM_2[2]/A_LWL<4>
+ RM_IHPSG13_1P_COLUMN_256_0[2]/RM_IHPSG13_1P_BITKIT_16x2_SRAM_1[1]/A_LWL<8> RM_IHPSG13_1P_COLUMN_256_0[2]/RM_IHPSG13_1P_BITKIT_16x2_SRAM_0[3]/A_LWL<14>
+ RM_IHPSG13_1P_COLUMN_256_0[2]/RM_IHPSG13_1P_BITKIT_16x2_SRAM_3[0]/A_LWL<8> RM_IHPSG13_1P_COLUMN_256_0[2]/RM_IHPSG13_1P_BITKIT_16x2_SRAM_3[3]/A_RWL<0>
+ RM_IHPSG13_1P_COLUMN_256_0[2]/RM_IHPSG13_1P_BITKIT_16x2_SRAM_0[2]/A_LWL<13> RM_IHPSG13_1P_COLUMN_256_0[2]/RM_IHPSG13_1P_BITKIT_16x2_SRAM_0[1]/A_RWL<13>
+ RM_IHPSG13_1P_COLUMN_256_0[2]/RM_IHPSG13_1P_BITKIT_16x2_SRAM_3[0]/A_LWL<10> RM_IHPSG13_1P_COLUMN_256_0[2]/RM_IHPSG13_1P_BITKIT_16x2_SRAM_2[1]/A_LWL<13>
+ RM_IHPSG13_1P_COLUMN_256_0[2]/RM_IHPSG13_1P_BITKIT_16x2_SRAM_0[2]/A_LWL<6> RM_IHPSG13_1P_COLUMN_256_0[2]/RM_IHPSG13_1P_BITKIT_16x2_SRAM_2[3]/A_RWL<1>
+ RM_IHPSG13_1P_COLUMN_256_0[2]/RM_IHPSG13_1P_BITKIT_16x2_SRAM_3[2]/A_RWL<9> RM_IHPSG13_1P_COLUMN_256_0[2]/RM_IHPSG13_1P_BITKIT_16x2_SRAM_0[3]/A_LWL<11>
+ RM_IHPSG13_1P_COLUMN_256_0[2]/RM_IHPSG13_1P_BITKIT_16x2_SRAM_1[3]/A_RWL<14> RM_IHPSG13_1P_COLUMN_256_0[2]/RM_IHPSG13_1P_BITKIT_16x2_SRAM_0[2]/A_LWL<0>
+ RM_IHPSG13_1P_COLUMN_256_0[2]/RM_IHPSG13_1P_BITKIT_16x2_SRAM_1[1]/A_RWL<1> RM_IHPSG13_1P_COLUMN_256_0[2]/RM_IHPSG13_1P_BITKIT_16x2_SRAM_0[2]/A_RWL<10>
+ RM_IHPSG13_1P_COLUMN_256_0[2]/RM_IHPSG13_1P_BITKIT_16x2_SRAM_1[3]/A_RWL<2> RM_IHPSG13_1P_COLUMN_256_0[2]/RM_IHPSG13_1P_BITKIT_16x2_SRAM_2[2]/A_LWL<11>
+ RM_IHPSG13_1P_COLUMN_256_0[2]/RM_IHPSG13_1P_BITKIT_16x2_SRAM_2[1]/A_LWL<0> RM_IHPSG13_1P_COLUMN_256_0[2]/RM_IHPSG13_1P_BITKIT_16x2_SRAM_0[3]/A_RWL<3>
+ RM_IHPSG13_1P_COLUMN_256_0[2]/RM_IHPSG13_1P_BITKIT_16x2_SRAM_3[2]/A_LWL<4> RM_IHPSG13_1P_COLUMN_256_0[2]/RM_IHPSG13_1P_BITKIT_16x2_SRAM_1[1]/A_RWL<8>
+ RM_IHPSG13_1P_COLUMN_256_0[2]/RM_IHPSG13_1P_BITKIT_16x2_SRAM_1[2]/A_LWL<5> RM_IHPSG13_1P_COLUMN_256_0[2]/RM_IHPSG13_1P_BITKIT_16x2_SRAM_1[0]/A_LWL<2>
+ RM_IHPSG13_1P_COLUMN_256_0[2]/RM_IHPSG13_1P_BITKIT_16x2_SRAM_3[2]/A_RWL<12> RM_IHPSG13_1P_COLUMN_256_0[2]/RM_IHPSG13_1P_BITKIT_16x2_SRAM_2[2]/A_LWL<5>
+ RM_IHPSG13_1P_COLUMN_256_0[2]/RM_IHPSG13_1P_BITKIT_16x2_SRAM_1[3]/A_LWL<6> RM_IHPSG13_1P_COLUMN_256_0[2]/RM_IHPSG13_1P_BITKIT_16x2_SRAM_3[1]/A_RWL<9>
+ RM_IHPSG13_1P_COLUMN_256_0[2]/RM_IHPSG13_1P_BITKIT_16x2_SRAM_3[1]/A_LWL<5> RM_IHPSG13_1P_COLUMN_256_0[2]/RM_IHPSG13_1P_BITKIT_16x2_SRAM_0[0]/A_RWL<2>
+ RM_IHPSG13_1P_COLUMN_256_0[2]/RM_IHPSG13_1P_BITKIT_16x2_SRAM_0[3]/A_LWL<15> RM_IHPSG13_1P_COLUMN_256_0[2]/RM_IHPSG13_1P_BITKIT_16x2_SRAM_1[2]/A_LWL<6>
+ RM_IHPSG13_1P_COLUMN_256_0[2]/RM_IHPSG13_1P_BITKIT_16x2_SRAM_3[3]/A_RWL<1> RM_IHPSG13_1P_COLUMN_256_0[2]/RM_IHPSG13_1P_BITKIT_16x2_SRAM_0[1]/A_RWL<14>
+ RM_IHPSG13_1P_COLUMN_256_0[2]/RM_IHPSG13_1P_BITKIT_16x2_SRAM_3[2]/A_RWL<3> RM_IHPSG13_1P_COLUMN_256_0[2]/RM_IHPSG13_1P_BITKIT_16x2_SRAM_3[0]/A_LWL<11>
+ RM_IHPSG13_1P_COLUMN_256_0[2]/RM_IHPSG13_1P_BITKIT_16x2_SRAM_0[2]/A_LWL<7> RM_IHPSG13_1P_COLUMN_256_0[2]/RM_IHPSG13_1P_BITKIT_16x2_SRAM_0[0]/A_RWL<15>
+ RM_IHPSG13_1P_COLUMN_256_0[2]/RM_IHPSG13_1P_BITKIT_16x2_SRAM_2[3]/A_RWL<2> RM_IHPSG13_1P_COLUMN_256_0[2]/RM_IHPSG13_1P_BITKIT_16x2_SRAM_2[3]/A_LWL<14>
+ RM_IHPSG13_1P_COLUMN_256_0[2]/RM_IHPSG13_1P_BITKIT_16x2_SRAM_1[3]/A_RWL<15> RM_IHPSG13_1P_COLUMN_256_0[2]/RM_IHPSG13_1P_BITKIT_16x2_SRAM_0[2]/A_RWL<11>
+ RM_IHPSG13_1P_COLUMN_256_0[2]/RM_IHPSG13_1P_BITKIT_16x2_SRAM_1[3]/A_RWL<3> RM_IHPSG13_1P_COLUMN_256_0[2]/RM_IHPSG13_1P_BITKIT_16x2_SRAM_1[0]/A_RWL<10>
+ RM_IHPSG13_1P_COLUMN_256_0[2]/RM_IHPSG13_1P_BITKIT_16x2_SRAM_0[3]/A_RWL<4> RM_IHPSG13_1P_COLUMN_256_0[2]/RM_IHPSG13_1P_BITKIT_16x2_SRAM_2[3]/A_RWL<11>
+ RM_IHPSG13_1P_COLUMN_256_0[2]/RM_IHPSG13_1P_BITKIT_16x2_SRAM_3[2]/A_LWL<5> RM_IHPSG13_1P_COLUMN_256_0[2]/RM_IHPSG13_1P_BITKIT_16x2_SRAM_0[0]/A_RWL<4>
+ RM_IHPSG13_1P_COLUMN_256_0[2]/RM_IHPSG13_1P_BITKIT_16x2_SRAM_2[2]/A_LWL<6> RM_IHPSG13_1P_COLUMN_256_0[2]/RM_IHPSG13_1P_BITKIT_16x2_SRAM_1[0]/A_LWL<8>
+ RM_IHPSG13_1P_COLUMN_256_0[2]/RM_IHPSG13_1P_BITKIT_16x2_SRAM_0[3]/A_RWL<12> RM_IHPSG13_1P_COLUMN_256_0[2]/RM_IHPSG13_1P_BITKIT_16x2_SRAM_2[1]/A_RWL<0>
+ RM_IHPSG13_1P_COLUMN_256_0[2]/RM_IHPSG13_1P_BITKIT_16x2_SRAM_3[3]/A_RWL<6> RM_IHPSG13_1P_COLUMN_256_0[2]/RM_IHPSG13_1P_BITKIT_16x2_SRAM_2[0]/A_RWL<5>
+ RM_IHPSG13_1P_COLUMN_256_0[2]/RM_IHPSG13_1P_BITKIT_16x2_SRAM_0[2]/A_RWL<9> RM_IHPSG13_1P_COLUMN_256_0[2]/RM_IHPSG13_1P_BITKIT_16x2_SRAM_1[2]/A_LWL<7>
+ RM_IHPSG13_1P_COLUMN_256_0[2]/RM_IHPSG13_1P_BITKIT_16x2_SRAM_0[1]/A_LWL<13> RM_IHPSG13_1P_COLUMN_256_0[2]/RM_IHPSG13_1P_BITKIT_16x2_SRAM_3[3]/A_RWL<2>
+ RM_IHPSG13_1P_COLUMN_256_0[2]/RM_IHPSG13_1P_BITKIT_16x2_SRAM_2[3]/A_RWL<13> RM_IHPSG13_1P_COLUMN_256_0[2]/RM_IHPSG13_1P_BITKIT_16x2_SRAM_0[1]/A_RWL<15>
+ RM_IHPSG13_1P_COLUMN_256_0[2]/RM_IHPSG13_1P_BITKIT_16x2_SRAM_3[0]/A_LWL<12> RM_IHPSG13_1P_COLUMN_256_0[2]/RM_IHPSG13_1P_BITKIT_16x2_SRAM_0[2]/A_LWL<8>
+ RM_IHPSG13_1P_COLUMN_256_0[2]/RM_IHPSG13_1P_BITKIT_16x2_SRAM_2[0]/A_LWL<13> RM_IHPSG13_1P_COLUMN_256_0[2]/RM_IHPSG13_1P_BITKIT_16x2_SRAM_2[3]/A_RWL<3>
+ RM_IHPSG13_1P_COLUMN_256_0[2]/RM_IHPSG13_1P_BITKIT_16x2_SRAM_0[2]/A_LWL<11> RM_IHPSG13_1P_COLUMN_256_0[2]/RM_IHPSG13_1P_BITKIT_16x2_SRAM_3[3]/A_LWL<12>
+ RM_IHPSG13_1P_COLUMN_256_0[2]/RM_IHPSG13_1P_BITKIT_16x2_SRAM_2[0]/A_LWL<3> RM_IHPSG13_1P_COLUMN_256_0[2]/RM_IHPSG13_1P_BITKIT_16x2_SRAM_0[1]/A_LWL<0>
+ RM_IHPSG13_1P_COLUMN_256_0[2]/RM_IHPSG13_1P_BITKIT_16x2_SRAM_2[3]/A_LWL<7> RM_IHPSG13_1P_COLUMN_256_0[2]/RM_IHPSG13_1P_BITKIT_16x2_SRAM_0[2]/A_RWL<12>
+ RM_IHPSG13_1P_COLUMN_256_0[2]/RM_IHPSG13_1P_BITKIT_16x2_SRAM_1[3]/A_RWL<4> RM_IHPSG13_1P_COLUMN_256_0[2]/RM_IHPSG13_1P_BITKIT_16x2_SRAM_2[1]/A_LWL<11>
+ RM_IHPSG13_1P_COLUMN_256_0[2]/RM_IHPSG13_1P_BITKIT_16x2_SRAM_2[0]/A_LWL<0> RM_IHPSG13_1P_COLUMN_256_0[7]/RM_IHPSG13_1P_BITKIT_16x2_SRAM_3[3]/VSS
+ RM_IHPSG13_1P_COLUMN_256_0[2]/RM_IHPSG13_1P_BITKIT_16x2_SRAM_0[3]/A_RWL<5> RM_IHPSG13_1P_COLUMN_256_0[7]/RM_IHPSG13_1P_BITKIT_16x2_SRAM_3[3]/VDD
+ RM_IHPSG13_1P_COLUMN_256_0[2]/RM_IHPSG13_1P_BITKIT_16x2_SRAM_3[2]/A_LWL<6> RM_IHPSG13_1P_COLUMN_256
XRM_IHPSG13_1P_COLUMN_256_0[3] RM_IHPSG13_1P_COLUMN_256_0[3]/RM_IHPSG13_1P_BITKIT_16x2_SRAM_0[0]/A_BLT_BOT<0>
+ RM_IHPSG13_1P_COLUMN_256_0[3]/RM_IHPSG13_1P_BITKIT_16x2_SRAM_0[0]/A_BLT_BOT<1> RM_IHPSG13_1P_COLUMN_256_0[3]/RM_IHPSG13_1P_BITKIT_16x2_SRAM_0[0]/A_BLC_BOT<0>
+ RM_IHPSG13_1P_COLUMN_256_0[3]/RM_IHPSG13_1P_BITKIT_16x2_SRAM_1[3]/A_RWL<6> RM_IHPSG13_1P_COLUMN_256_0[3]/RM_IHPSG13_1P_BITKIT_16x2_SRAM_0[3]/A_RWL<11>
+ RM_IHPSG13_1P_COLUMN_256_0[3]/RM_IHPSG13_1P_BITKIT_16x2_SRAM_0[0]/A_BLC_BOT<1> RM_IHPSG13_1P_COLUMN_256_0[3]/RM_IHPSG13_1P_BITKIT_16x2_SRAM_3[1]/A_LWL<12>
+ RM_IHPSG13_1P_COLUMN_256_0[3]/RM_IHPSG13_1P_BITKIT_16x2_SRAM_1[3]/A_RWL<8> RM_IHPSG13_1P_COLUMN_256_0[3]/RM_IHPSG13_1P_BITKIT_16x2_SRAM_0[3]/A_RWL<9>
+ RM_IHPSG13_1P_COLUMN_256_0[3]/RM_IHPSG13_1P_BITKIT_16x2_SRAM_0[3]/A_LWL<4> RM_IHPSG13_1P_COLUMN_256_0[3]/RM_IHPSG13_1P_BITKIT_16x2_SRAM_3[2]/A_LWL<9>
+ RM_IHPSG13_1P_COLUMN_256_0[3]/RM_IHPSG13_1P_BITKIT_16x2_SRAM_2[3]/A_LWL<1> RM_IHPSG13_1P_COLUMN_256_0[3]/RM_IHPSG13_1P_BITKIT_16x2_SRAM_0[3]/A_RWL<14>
+ RM_IHPSG13_1P_COLUMN_256_0[3]/RM_IHPSG13_1P_BITKIT_16x2_SRAM_0[2]/A_RWL<14> RM_IHPSG13_1P_COLUMN_256_0[3]/RM_IHPSG13_1P_BITKIT_16x2_SRAM_2[0]/A_LWL<11>
+ RM_IHPSG13_1P_COLUMN_256_0[3]/RM_IHPSG13_1P_BITKIT_16x2_SRAM_2[3]/A_LWL<4> RM_IHPSG13_1P_COLUMN_256_0[3]/RM_IHPSG13_1P_BITKIT_16x2_SRAM_3[2]/A_LWL<12>
+ RM_IHPSG13_1P_COLUMN_256_0[3]/RM_IHPSG13_1P_BITKIT_16x2_SRAM_1[2]/A_LWL<9> RM_IHPSG13_1P_COLUMN_256_0[3]/RM_IHPSG13_1P_BITKIT_16x2_SRAM_3[3]/A_RWL<9>
+ RM_IHPSG13_1P_COLUMN_256_0[3]/RM_IHPSG13_1P_BITKIT_16x2_SRAM_1[3]/A_LWL<2> RM_IHPSG13_1P_COLUMN_256_0[3]/RM_IHPSG13_1P_BITKIT_16x2_SRAM_0[3]/A_LWL<1>
+ RM_IHPSG13_1P_COLUMN_256_0[3]/RM_IHPSG13_1P_BITKIT_16x2_SRAM_2[3]/A_RWL<7> RM_IHPSG13_1P_COLUMN_256_0[3]/RM_IHPSG13_1P_BITKIT_16x2_SRAM_0[0]/A_RWL<0>
+ RM_IHPSG13_1P_COLUMN_256_0[3]/RM_IHPSG13_1P_BITKIT_16x2_SRAM_2[0]/A_RWL<1> RM_IHPSG13_1P_COLUMN_256_0[3]/RM_IHPSG13_1P_BITKIT_16x2_SRAM_0[2]/A_RWL<13>
+ RM_IHPSG13_1P_COLUMN_256_0[3]/RM_IHPSG13_1P_BITKIT_16x2_SRAM_2[3]/A_RWL<5> RM_IHPSG13_1P_COLUMN_256_0[3]/RM_IHPSG13_1P_BITKIT_16x2_SRAM_2[3]/A_LWL<3>
+ RM_IHPSG13_1P_COLUMN_256_0[3]/RM_IHPSG13_1P_BITKIT_16x2_SRAM_3[0]/A_RWL<13> RM_IHPSG13_1P_COLUMN_256_0[3]/RM_IHPSG13_1P_BITKIT_16x2_SRAM_1[0]/A_RWL<3>
+ RM_IHPSG13_1P_COLUMN_256_0[3]/RM_IHPSG13_1P_BITKIT_16x2_SRAM_3[1]/A_LWL<15> RM_IHPSG13_1P_COLUMN_256_0[3]/RM_IHPSG13_1P_BITKIT_16x2_SRAM_2[0]/A_LWL<14>
+ RM_IHPSG13_1P_COLUMN_256_0[3]/RM_IHPSG13_1P_BITKIT_16x2_SRAM_0[3]/A_RWL<7> RM_IHPSG13_1P_COLUMN_256_0[3]/RM_IHPSG13_1P_BITKIT_16x2_SRAM_3[0]/A_RWL<0>
+ RM_IHPSG13_1P_COLUMN_256_0[3]/RM_IHPSG13_1P_BITKIT_16x2_SRAM_3[2]/A_LWL<15> RM_IHPSG13_1P_COLUMN_256_0[3]/RM_IHPSG13_1P_BITKIT_16x2_SRAM_3[3]/A_RWL<4>
+ RM_IHPSG13_1P_COLUMN_256_0[3]/RM_IHPSG13_1P_BITKIT_16x2_SRAM_3[2]/A_LWL<7> RM_IHPSG13_1P_COLUMN_256_0[3]/RM_IHPSG13_1P_BITKIT_16x2_SRAM_0[0]/A_LWL<0>
+ RM_IHPSG13_1P_COLUMN_256_0[3]/RM_IHPSG13_1P_BITKIT_16x2_SRAM_1[3]/A_LWL<9> RM_IHPSG13_1P_COLUMN_256_0[3]/RM_IHPSG13_1P_BITKIT_16x2_SRAM_3[0]/A_RWL<3>
+ RM_IHPSG13_1P_COLUMN_256_0[3]/RM_IHPSG13_1P_BITKIT_16x2_SRAM_0[0]/A_RWL<5> RM_IHPSG13_1P_COLUMN_256_0[3]/RM_IHPSG13_1P_BITKIT_16x2_SRAM_0[3]/A_RWL<13>
+ RM_IHPSG13_1P_COLUMN_256_0[3]/RM_IHPSG13_1P_BITKIT_16x2_SRAM_2[3]/A_LWL<8> RM_IHPSG13_1P_COLUMN_256_0[3]/RM_IHPSG13_1P_BITKIT_16x2_SRAM_0[3]/A_LWL<7>
+ RM_IHPSG13_1P_COLUMN_256_0[3]/RM_IHPSG13_1P_BITKIT_16x2_SRAM_3[0]/A_LWL<15> RM_IHPSG13_1P_COLUMN_256_0[3]/RM_IHPSG13_1P_BITKIT_16x2_SRAM_3[3]/A_LWL<13>
+ RM_IHPSG13_1P_COLUMN_256_0[3]/RM_IHPSG13_1P_BITKIT_16x2_SRAM_2[3]/A_LWL<6> RM_IHPSG13_1P_COLUMN_256_0[3]/RM_IHPSG13_1P_BITKIT_16x2_SRAM_2[1]/A_LWL<10>
+ RM_IHPSG13_1P_COLUMN_256_0[3]/RM_IHPSG13_1P_BITKIT_16x2_SRAM_3[3]/A_LWL<0> RM_IHPSG13_1P_COLUMN_256_0[3]/RM_IHPSG13_1P_BITKIT_16x2_SRAM_3[0]/A_RWL<4>
+ RM_IHPSG13_1P_COLUMN_256_0[3]/RM_IHPSG13_1P_BITKIT_16x2_SRAM_2[2]/A_LWL<10> RM_IHPSG13_1P_COLUMN_256_0[3]/RM_IHPSG13_1P_BITKIT_16x2_SRAM_3[1]/A_RWL<13>
+ RM_IHPSG13_1P_COLUMN_256_0[3]/RM_IHPSG13_1P_BITKIT_16x2_SRAM_1[0]/A_RWL<6> RM_IHPSG13_1P_COLUMN_256_0[3]/RM_IHPSG13_1P_BITKIT_16x2_SRAM_3[3]/A_LWL<9>
+ RM_IHPSG13_1P_COLUMN_256_0[3]/RM_IHPSG13_1P_BITKIT_16x2_SRAM_1[0]/A_RWL<4> RM_IHPSG13_1P_COLUMN_256_0[3]/RM_IHPSG13_1P_BITKIT_16x2_SRAM_0[3]/A_RWL<10>
+ RM_IHPSG13_1P_COLUMN_256_0[3]/RM_IHPSG13_1P_BITKIT_16x2_SRAM_2[1]/A_LWL<14> RM_IHPSG13_1P_COLUMN_256_0[3]/RM_IHPSG13_1P_BITKIT_16x2_SRAM_3[0]/A_RWL<5>
+ RM_IHPSG13_1P_COLUMN_256_0[3]/RM_IHPSG13_1P_BITKIT_16x2_SRAM_0[3]/A_LWL<8> RM_IHPSG13_1P_COLUMN_256_0[3]/RM_IHPSG13_1P_BITKIT_16x2_SRAM_3[3]/A_LWL<7>
+ RM_IHPSG13_1P_COLUMN_256_0[3]/RM_IHPSG13_1P_BITKIT_16x2_SRAM_2[2]/A_LWL<8> RM_IHPSG13_1P_COLUMN_256_0[3]/RM_IHPSG13_1P_BITKIT_16x2_SRAM_3[3]/A_LWL<15>
+ RM_IHPSG13_1P_COLUMN_256_0[3]/RM_IHPSG13_1P_BITKIT_16x2_SRAM_3[2]/A_LWL<13> RM_IHPSG13_1P_COLUMN_256_0[3]/RM_IHPSG13_1P_BITKIT_16x2_SRAM_2[0]/A_LWL<1>
+ RM_IHPSG13_1P_COLUMN_256_0[3]/RM_IHPSG13_1P_BITKIT_16x2_SRAM_0[0]/A_LWL<1> RM_IHPSG13_1P_COLUMN_256_0[3]/RM_IHPSG13_1P_BITKIT_16x2_SRAM_1[3]/A_LWL<0>
+ RM_IHPSG13_1P_COLUMN_256_0[3]/RM_IHPSG13_1P_BITKIT_16x2_SRAM_2[0]/A_LWL<10> RM_IHPSG13_1P_COLUMN_256_0[3]/RM_IHPSG13_1P_BITKIT_16x2_SRAM_3[3]/A_LWL<11>
+ RM_IHPSG13_1P_COLUMN_256_0[3]/RM_IHPSG13_1P_BITKIT_16x2_SRAM_0[0]/A_LWL<3> RM_IHPSG13_1P_COLUMN_256_0[3]/RM_IHPSG13_1P_BITKIT_16x2_SRAM_3[0]/A_RWL<6>
+ RM_IHPSG13_1P_COLUMN_256_0[3]/RM_IHPSG13_1P_BITKIT_16x2_SRAM_2[3]/A_LWL<5> RM_IHPSG13_1P_COLUMN_256_0[3]/RM_IHPSG13_1P_BITKIT_16x2_SRAM_2[0]/A_RWL<7>
+ RM_IHPSG13_1P_COLUMN_256_0[3]/RM_IHPSG13_1P_BITKIT_16x2_SRAM_3[1]/A_RWL<15> RM_IHPSG13_1P_COLUMN_256_0[3]/RM_IHPSG13_1P_BITKIT_16x2_SRAM_0[1]/A_RWL<0>
+ RM_IHPSG13_1P_COLUMN_256_0[3]/RM_IHPSG13_1P_BITKIT_16x2_SRAM_3[0]/A_RWL<2> RM_IHPSG13_1P_COLUMN_256_0[3]/RM_IHPSG13_1P_BITKIT_16x2_SRAM_2[0]/A_RWL<11>
+ RM_IHPSG13_1P_COLUMN_256_0[3]/RM_IHPSG13_1P_BITKIT_16x2_SRAM_2[0]/A_LWL<2> RM_IHPSG13_1P_COLUMN_256_0[3]/RM_IHPSG13_1P_BITKIT_16x2_SRAM_3[0]/A_RWL<15>
+ RM_IHPSG13_1P_COLUMN_256_0[3]/RM_IHPSG13_1P_BITKIT_16x2_SRAM_0[0]/A_LWL<4> RM_IHPSG13_1P_COLUMN_256_0[3]/RM_IHPSG13_1P_BITKIT_16x2_SRAM_1[0]/A_LWL<12>
+ RM_IHPSG13_1P_COLUMN_256_0[3]/RM_IHPSG13_1P_BITKIT_16x2_SRAM_2[0]/A_RWL<8> RM_IHPSG13_1P_COLUMN_256_0[3]/RM_IHPSG13_1P_BITKIT_16x2_SRAM_1[0]/A_RWL<9>
+ RM_IHPSG13_1P_COLUMN_256_0[3]/RM_IHPSG13_1P_BITKIT_16x2_SRAM_3[1]/A_LWL<13> RM_IHPSG13_1P_COLUMN_256_0[3]/RM_IHPSG13_1P_BITKIT_16x2_SRAM_1[3]/A_RWL<9>
+ RM_IHPSG13_1P_COLUMN_256_0[3]/RM_IHPSG13_1P_BITKIT_16x2_SRAM_2[3]/A_LWL<10> RM_IHPSG13_1P_COLUMN_256_0[3]/RM_IHPSG13_1P_BITKIT_16x2_SRAM_3[2]/A_RWL<13>
+ RM_IHPSG13_1P_COLUMN_256_0[3]/RM_IHPSG13_1P_BITKIT_16x2_SRAM_3[2]/A_LWL<11> RM_IHPSG13_1P_COLUMN_256_0[3]/RM_IHPSG13_1P_BITKIT_16x2_SRAM_0[0]/A_RWL<7>
+ RM_IHPSG13_1P_COLUMN_256_0[3]/RM_IHPSG13_1P_BITKIT_16x2_SRAM_0[3]/A_LWL<5> RM_IHPSG13_1P_COLUMN_256_0[3]/RM_IHPSG13_1P_BITKIT_16x2_SRAM_1[0]/A_RWL<2>
+ RM_IHPSG13_1P_COLUMN_256_0[3]/RM_IHPSG13_1P_BITKIT_16x2_SRAM_2[2]/A_LWL<14> RM_IHPSG13_1P_COLUMN_256_0[3]/RM_IHPSG13_1P_BITKIT_16x2_SRAM_3[0]/A_LWL<3>
+ RM_IHPSG13_1P_COLUMN_256_0[3]/RM_IHPSG13_1P_BITKIT_16x2_SRAM_2[0]/A_LWL<4> RM_IHPSG13_1P_COLUMN_256_0[3]/RM_IHPSG13_1P_BITKIT_16x2_SRAM_3[3]/A_LWL<14>
+ RM_IHPSG13_1P_COLUMN_256_0[3]/RM_IHPSG13_1P_BITKIT_16x2_SRAM_2[1]/A_RWL<10> RM_IHPSG13_1P_COLUMN_256_0[3]/RM_IHPSG13_1P_BITKIT_16x2_SRAM_1[0]/A_LWL<5>
+ RM_IHPSG13_1P_COLUMN_256_0[3]/RM_IHPSG13_1P_BITKIT_16x2_SRAM_3[1]/A_RWL<0> RM_IHPSG13_1P_COLUMN_256_0[3]/RM_IHPSG13_1P_BITKIT_16x2_SRAM_2[0]/A_RWL<10>
+ RM_IHPSG13_1P_COLUMN_256_0[3]/RM_IHPSG13_1P_BITKIT_16x2_SRAM_2[0]/A_RWL<12> RM_IHPSG13_1P_COLUMN_256_0[3]/RM_IHPSG13_1P_BITKIT_16x2_SRAM_3[3]/A_RWL<11>
+ RM_IHPSG13_1P_COLUMN_256_0[3]/RM_IHPSG13_1P_BITKIT_16x2_SRAM_0[0]/A_LWL<6> RM_IHPSG13_1P_COLUMN_256_0[3]/RM_IHPSG13_1P_BITKIT_16x2_SRAM_2[1]/A_RWL<1>
+ RM_IHPSG13_1P_COLUMN_256_0[3]/RM_IHPSG13_1P_BITKIT_16x2_SRAM_2[3]/A_RWL<8> RM_IHPSG13_1P_COLUMN_256_0[3]/RM_IHPSG13_1P_BITKIT_16x2_SRAM_1[1]/A_RWL<2>
+ RM_IHPSG13_1P_COLUMN_256_0[3]/RM_IHPSG13_1P_BITKIT_16x2_SRAM_2[0]/A_RWL<14> RM_IHPSG13_1P_COLUMN_256_0[3]/RM_IHPSG13_1P_BITKIT_16x2_SRAM_3[0]/A_LWL<13>
+ RM_IHPSG13_1P_COLUMN_256_0[3]/RM_IHPSG13_1P_BITKIT_16x2_SRAM_3[2]/A_RWL<15> RM_IHPSG13_1P_COLUMN_256_0[3]/RM_IHPSG13_1P_BITKIT_16x2_SRAM_2[1]/A_RWL<11>
+ RM_IHPSG13_1P_COLUMN_256_0[3]/RM_IHPSG13_1P_BITKIT_16x2_SRAM_3[1]/A_LWL<11> RM_IHPSG13_1P_COLUMN_256_0[3]/RM_IHPSG13_1P_BITKIT_16x2_SRAM_3[0]/A_LWL<0>
+ RM_IHPSG13_1P_COLUMN_256_0[3]/RM_IHPSG13_1P_BITKIT_16x2_SRAM_3[3]/A_RWL<12> RM_IHPSG13_1P_COLUMN_256_0[3]/RM_IHPSG13_1P_BITKIT_16x2_SRAM_0[0]/A_LWL<7>
+ RM_IHPSG13_1P_COLUMN_256_0[3]/RM_IHPSG13_1P_BITKIT_16x2_SRAM_1[0]/A_LWL<15> RM_IHPSG13_1P_COLUMN_256_0[3]/RM_IHPSG13_1P_BITKIT_16x2_SRAM_1[1]/A_RWL<3>
+ RM_IHPSG13_1P_COLUMN_256_0[3]/RM_IHPSG13_1P_BITKIT_16x2_SRAM_1[1]/A_LWL<12> RM_IHPSG13_1P_COLUMN_256_0[3]/RM_IHPSG13_1P_BITKIT_16x2_SRAM_0[1]/A_RWL<4>
+ RM_IHPSG13_1P_COLUMN_256_0[3]/RM_IHPSG13_1P_BITKIT_16x2_SRAM_3[0]/A_LWL<5> RM_IHPSG13_1P_COLUMN_256_0[3]/RM_IHPSG13_1P_BITKIT_16x2_SRAM_2[0]/A_LWL<6>
+ RM_IHPSG13_1P_COLUMN_256_0[3]/RM_IHPSG13_1P_BITKIT_16x2_SRAM_3[2]/A_LWL<14> RM_IHPSG13_1P_COLUMN_256_0[3]/RM_IHPSG13_1P_BITKIT_16x2_SRAM_1[0]/A_LWL<7>
+ RM_IHPSG13_1P_COLUMN_256_0[3]/RM_IHPSG13_1P_BITKIT_16x2_SRAM_3[1]/A_RWL<2> RM_IHPSG13_1P_COLUMN_256_0[3]/RM_IHPSG13_1P_BITKIT_16x2_SRAM_3[2]/A_RWL<11>
+ RM_IHPSG13_1P_COLUMN_256_0[3]/RM_IHPSG13_1P_BITKIT_16x2_SRAM_3[3]/A_RWL<13> RM_IHPSG13_1P_COLUMN_256_0[3]/RM_IHPSG13_1P_BITKIT_16x2_SRAM_0[0]/A_LWL<8>
+ RM_IHPSG13_1P_COLUMN_256_0[3]/RM_IHPSG13_1P_BITKIT_16x2_SRAM_2[3]/A_RWL<6> RM_IHPSG13_1P_COLUMN_256_0[3]/RM_IHPSG13_1P_BITKIT_16x2_SRAM_1[1]/A_RWL<4>
+ RM_IHPSG13_1P_COLUMN_256_0[3]/RM_IHPSG13_1P_BITKIT_16x2_SRAM_0[0]/A_RWL<1> RM_IHPSG13_1P_COLUMN_256_0[3]/RM_IHPSG13_1P_BITKIT_16x2_SRAM_1[1]/A_LWL<13>
+ RM_IHPSG13_1P_COLUMN_256_0[3]/RM_IHPSG13_1P_BITKIT_16x2_SRAM_1[0]/A_LWL<13> RM_IHPSG13_1P_COLUMN_256_0[3]/RM_IHPSG13_1P_BITKIT_16x2_SRAM_0[1]/A_RWL<5>
+ RM_IHPSG13_1P_COLUMN_256_0[3]/RM_IHPSG13_1P_BITKIT_16x2_SRAM_3[0]/A_LWL<6> RM_IHPSG13_1P_COLUMN_256_0[3]/RM_IHPSG13_1P_BITKIT_16x2_SRAM_2[3]/A_LWL<12>
+ RM_IHPSG13_1P_COLUMN_256_0[3]/RM_IHPSG13_1P_BITKIT_16x2_SRAM_1[1]/A_LWL<11> RM_IHPSG13_1P_COLUMN_256_0[3]/RM_IHPSG13_1P_BITKIT_16x2_SRAM_0[0]/A_RWL<8>
+ RM_IHPSG13_1P_COLUMN_256_0[3]/RM_IHPSG13_1P_BITKIT_16x2_SRAM_1[0]/A_LWL<0> RM_IHPSG13_1P_COLUMN_256_0[3]/RM_IHPSG13_1P_BITKIT_16x2_SRAM_0[3]/A_LWL<3>
+ RM_IHPSG13_1P_COLUMN_256_0[3]/RM_IHPSG13_1P_BITKIT_16x2_SRAM_2[1]/A_RWL<12> RM_IHPSG13_1P_COLUMN_256_0[3]/RM_IHPSG13_1P_BITKIT_16x2_SRAM_2[0]/A_RWL<9>
+ RM_IHPSG13_1P_COLUMN_256_0[3]/RM_IHPSG13_1P_BITKIT_16x2_SRAM_3[1]/A_RWL<3> RM_IHPSG13_1P_COLUMN_256_0[3]/RM_IHPSG13_1P_BITKIT_16x2_SRAM_2[3]/A_LWL<2>
+ RM_IHPSG13_1P_COLUMN_256_0[3]/RM_IHPSG13_1P_BITKIT_16x2_SRAM_3[3]/A_RWL<14> RM_IHPSG13_1P_COLUMN_256_0[3]/RM_IHPSG13_1P_BITKIT_16x2_SRAM_2[2]/A_RWL<10>
+ RM_IHPSG13_1P_COLUMN_256_0[3]/RM_IHPSG13_1P_BITKIT_16x2_SRAM_2[0]/A_LWL<5> RM_IHPSG13_1P_COLUMN_256_0[3]/RM_IHPSG13_1P_BITKIT_16x2_SRAM_3[3]/A_LWL<4>
+ RM_IHPSG13_1P_COLUMN_256_0[3]/RM_IHPSG13_1P_BITKIT_16x2_SRAM_2[1]/A_RWL<3> RM_IHPSG13_1P_COLUMN_256_0[3]/RM_IHPSG13_1P_BITKIT_16x2_SRAM_3[0]/A_LWL<7>
+ RM_IHPSG13_1P_COLUMN_256_0[3]/RM_IHPSG13_1P_BITKIT_16x2_SRAM_0[0]/A_LWL<10> RM_IHPSG13_1P_COLUMN_256_0[3]/RM_IHPSG13_1P_BITKIT_16x2_SRAM_1[1]/A_LWL<0>
+ RM_IHPSG13_1P_COLUMN_256_0[3]/RM_IHPSG13_1P_BITKIT_16x2_SRAM_2[0]/A_LWL<8> RM_IHPSG13_1P_COLUMN_256_0[3]/RM_IHPSG13_1P_BITKIT_16x2_SRAM_3[1]/A_LWL<14>
+ RM_IHPSG13_1P_COLUMN_256_0[3]/RM_IHPSG13_1P_BITKIT_16x2_SRAM_1[2]/A_LWL<11> RM_IHPSG13_1P_COLUMN_256_0[3]/RM_IHPSG13_1P_BITKIT_16x2_SRAM_2[1]/A_RWL<14>
+ RM_IHPSG13_1P_COLUMN_256_0[3]/RM_IHPSG13_1P_BITKIT_16x2_SRAM_0[1]/A_LWL<1> RM_IHPSG13_1P_COLUMN_256_0[3]/RM_IHPSG13_1P_BITKIT_16x2_SRAM_1[0]/A_LWL<9>
+ RM_IHPSG13_1P_COLUMN_256_0[3]/RM_IHPSG13_1P_BITKIT_16x2_SRAM_3[1]/A_RWL<4> RM_IHPSG13_1P_COLUMN_256_0[3]/RM_IHPSG13_1P_BITKIT_16x2_SRAM_1[0]/A_RWL<0>
+ RM_IHPSG13_1P_COLUMN_256_0[3]/RM_IHPSG13_1P_BITKIT_16x2_SRAM_3[1]/A_RWL<11> RM_IHPSG13_1P_COLUMN_256_0[3]/RM_IHPSG13_1P_BITKIT_16x2_SRAM_3[3]/A_RWL<15>
+ RM_IHPSG13_1P_COLUMN_256_0[3]/RM_IHPSG13_1P_BITKIT_16x2_SRAM_0[3]/A_RWL<6> RM_IHPSG13_1P_COLUMN_256_0[3]/RM_IHPSG13_1P_BITKIT_16x2_SRAM_2[1]/A_RWL<5>
+ RM_IHPSG13_1P_COLUMN_256_0[3]/RM_IHPSG13_1P_BITKIT_16x2_SRAM_2[2]/A_RWL<11> RM_IHPSG13_1P_COLUMN_256_0[3]/RM_IHPSG13_1P_BITKIT_16x2_SRAM_3[0]/A_RWL<1>
+ RM_IHPSG13_1P_COLUMN_256_0[3]/RM_IHPSG13_1P_BITKIT_16x2_SRAM_3[3]/A_RWL<5> RM_IHPSG13_1P_COLUMN_256_0[3]/RM_IHPSG13_1P_BITKIT_16x2_SRAM_1[1]/A_RWL<6>
+ RM_IHPSG13_1P_COLUMN_256_0[3]/RM_IHPSG13_1P_BITKIT_16x2_SRAM_3[0]/A_RWL<8> RM_IHPSG13_1P_COLUMN_256_0[3]/RM_IHPSG13_1P_BITKIT_16x2_SRAM_1[1]/A_LWL<15>
+ RM_IHPSG13_1P_COLUMN_256_0[3]/RM_IHPSG13_1P_BITKIT_16x2_SRAM_0[1]/A_RWL<7> RM_IHPSG13_1P_COLUMN_256_0[3]/RM_IHPSG13_1P_BITKIT_16x2_SRAM_3[3]/A_LWL<3>
+ RM_IHPSG13_1P_COLUMN_256_0[3]/RM_IHPSG13_1P_BITKIT_16x2_SRAM_0[0]/A_LWL<11> RM_IHPSG13_1P_COLUMN_256_0[3]/RM_IHPSG13_1P_BITKIT_16x2_SRAM_2[2]/A_LWL<12>
+ RM_IHPSG13_1P_COLUMN_256_0[3]/RM_IHPSG13_1P_BITKIT_16x2_SRAM_1[0]/A_LWL<11> RM_IHPSG13_1P_COLUMN_256_0[3]/RM_IHPSG13_1P_BITKIT_16x2_SRAM_1[2]/A_LWL<12>
+ RM_IHPSG13_1P_COLUMN_256_0[3]/RM_IHPSG13_1P_BITKIT_16x2_SRAM_3[2]/A_RWL<14> RM_IHPSG13_1P_COLUMN_256_0[3]/RM_IHPSG13_1P_BITKIT_16x2_SRAM_3[1]/A_RWL<5>
+ RM_IHPSG13_1P_COLUMN_256_0[3]/RM_IHPSG13_1P_BITKIT_16x2_SRAM_0[0]/A_LWL<5> RM_IHPSG13_1P_COLUMN_256_0[3]/RM_IHPSG13_1P_BITKIT_16x2_SRAM_1[3]/A_LWL<4>
+ RM_IHPSG13_1P_COLUMN_256_0[3]/RM_IHPSG13_1P_BITKIT_16x2_SRAM_0[1]/A_RWL<1> RM_IHPSG13_1P_COLUMN_256_0[3]/RM_IHPSG13_1P_BITKIT_16x2_SRAM_0[1]/A_RWL<3>
+ RM_IHPSG13_1P_COLUMN_256_0[3]/RM_IHPSG13_1P_BITKIT_16x2_SRAM_3[1]/A_LWL<0> RM_IHPSG13_1P_COLUMN_256_0[3]/RM_IHPSG13_1P_BITKIT_16x2_SRAM_2[0]/A_RWL<3>
+ RM_IHPSG13_1P_COLUMN_256_0[3]/RM_IHPSG13_1P_BITKIT_16x2_SRAM_2[3]/A_LWL<9> RM_IHPSG13_1P_COLUMN_256_0[3]/RM_IHPSG13_1P_BITKIT_16x2_SRAM_2[1]/A_LWL<1>
+ RM_IHPSG13_1P_COLUMN_256_0[3]/RM_IHPSG13_1P_BITKIT_16x2_SRAM_3[0]/A_LWL<9> RM_IHPSG13_1P_COLUMN_256_0[3]/RM_IHPSG13_1P_BITKIT_16x2_SRAM_0[1]/A_RWL<8>
+ RM_IHPSG13_1P_COLUMN_256_0[3]/RM_IHPSG13_1P_BITKIT_16x2_SRAM_1[1]/A_LWL<14> RM_IHPSG13_1P_COLUMN_256_0[3]/RM_IHPSG13_1P_BITKIT_16x2_SRAM_0[0]/A_LWL<2>
+ RM_IHPSG13_1P_COLUMN_256_0[3]/RM_IHPSG13_1P_BITKIT_16x2_SRAM_2[2]/A_RWL<12> RM_IHPSG13_1P_COLUMN_256_0[3]/RM_IHPSG13_1P_BITKIT_16x2_SRAM_1[1]/A_LWL<2>
+ RM_IHPSG13_1P_COLUMN_256_0[3]/RM_IHPSG13_1P_BITKIT_16x2_SRAM_0[3]/A_LWL<6> RM_IHPSG13_1P_COLUMN_256_0[3]/RM_IHPSG13_1P_BITKIT_16x2_SRAM_3[0]/A_LWL<14>
+ RM_IHPSG13_1P_COLUMN_256_0[3]/RM_IHPSG13_1P_BITKIT_16x2_SRAM_1[2]/A_LWL<13> RM_IHPSG13_1P_COLUMN_256_0[3]/RM_IHPSG13_1P_BITKIT_16x2_SRAM_0[1]/A_LWL<3>
+ RM_IHPSG13_1P_COLUMN_256_0[3]/RM_IHPSG13_1P_BITKIT_16x2_SRAM_1[0]/A_RWL<12> RM_IHPSG13_1P_COLUMN_256_0[3]/RM_IHPSG13_1P_BITKIT_16x2_SRAM_3[1]/A_RWL<6>
+ RM_IHPSG13_1P_COLUMN_256_0[3]/RM_IHPSG13_1P_BITKIT_16x2_SRAM_3[0]/A_RWL<11> RM_IHPSG13_1P_COLUMN_256_0[3]/RM_IHPSG13_1P_BITKIT_16x2_SRAM_3[3]/A_LWL<1>
+ RM_IHPSG13_1P_COLUMN_256_0[3]/RM_IHPSG13_1P_BITKIT_16x2_SRAM_2[1]/A_RWL<7> RM_IHPSG13_1P_COLUMN_256_0[3]/RM_IHPSG13_1P_BITKIT_16x2_SRAM_2[1]/A_RWL<6>
+ RM_IHPSG13_1P_COLUMN_256_0[3]/RM_IHPSG13_1P_BITKIT_16x2_SRAM_0[2]/A_RWL<0> RM_IHPSG13_1P_COLUMN_256_0[3]/RM_IHPSG13_1P_BITKIT_16x2_SRAM_2[3]/A_RWL<10>
+ RM_IHPSG13_1P_COLUMN_256_0[3]/RM_IHPSG13_1P_BITKIT_16x2_SRAM_2[1]/A_LWL<2> RM_IHPSG13_1P_COLUMN_256_0[3]/RM_IHPSG13_1P_BITKIT_16x2_SRAM_0[0]/A_LWL<13>
+ RM_IHPSG13_1P_COLUMN_256_0[3]/RM_IHPSG13_1P_BITKIT_16x2_SRAM_2[1]/A_LWL<12> RM_IHPSG13_1P_COLUMN_256_0[3]/RM_IHPSG13_1P_BITKIT_16x2_SRAM_1[1]/A_RWL<0>
+ RM_IHPSG13_1P_COLUMN_256_0[3]/RM_IHPSG13_1P_BITKIT_16x2_SRAM_1[2]/A_LWL<14> RM_IHPSG13_1P_COLUMN_256_0[3]/RM_IHPSG13_1P_BITKIT_16x2_SRAM_1[0]/A_RWL<5>
+ RM_IHPSG13_1P_COLUMN_256_0[3]/RM_IHPSG13_1P_BITKIT_16x2_SRAM_0[1]/A_LWL<10> RM_IHPSG13_1P_COLUMN_256_0[3]/RM_IHPSG13_1P_BITKIT_16x2_SRAM_0[1]/A_LWL<4>
+ RM_IHPSG13_1P_COLUMN_256_0[3]/RM_IHPSG13_1P_BITKIT_16x2_SRAM_3[1]/A_RWL<14> RM_IHPSG13_1P_COLUMN_256_0[3]/RM_IHPSG13_1P_BITKIT_16x2_SRAM_3[1]/A_RWL<1>
+ RM_IHPSG13_1P_COLUMN_256_0[3]/RM_IHPSG13_1P_BITKIT_16x2_SRAM_1[0]/A_RWL<13> RM_IHPSG13_1P_COLUMN_256_0[3]/RM_IHPSG13_1P_BITKIT_16x2_SRAM_1[3]/A_LWL<11>
+ RM_IHPSG13_1P_COLUMN_256_0[3]/RM_IHPSG13_1P_BITKIT_16x2_SRAM_2[1]/A_RWL<8> RM_IHPSG13_1P_COLUMN_256_0[3]/RM_IHPSG13_1P_BITKIT_16x2_SRAM_1[0]/A_LWL<3>
+ RM_IHPSG13_1P_COLUMN_256_0[3]/RM_IHPSG13_1P_BITKIT_16x2_SRAM_2[2]/A_RWL<14> RM_IHPSG13_1P_COLUMN_256_0[3]/RM_IHPSG13_1P_BITKIT_16x2_SRAM_1[3]/A_LWL<7>
+ RM_IHPSG13_1P_COLUMN_256_0[3]/RM_IHPSG13_1P_BITKIT_16x2_SRAM_0[0]/A_RWL<3> RM_IHPSG13_1P_COLUMN_256_0[3]/RM_IHPSG13_1P_BITKIT_16x2_SRAM_0[3]/A_LWL<9>
+ RM_IHPSG13_1P_COLUMN_256_0[3]/RM_IHPSG13_1P_BITKIT_16x2_SRAM_3[0]/A_LWL<2> RM_IHPSG13_1P_COLUMN_256_0[3]/RM_IHPSG13_1P_BITKIT_16x2_SRAM_1[1]/A_RWL<9>
+ RM_IHPSG13_1P_COLUMN_256_0[3]/RM_IHPSG13_1P_BITKIT_16x2_SRAM_3[3]/A_LWL<6> RM_IHPSG13_1P_COLUMN_256_0[3]/RM_IHPSG13_1P_BITKIT_16x2_SRAM_2[2]/A_LWL<9>
+ RM_IHPSG13_1P_COLUMN_256_0[3]/RM_IHPSG13_1P_BITKIT_16x2_SRAM_2[1]/A_LWL<3> RM_IHPSG13_1P_COLUMN_256_0[3]/RM_IHPSG13_1P_BITKIT_16x2_SRAM_0[0]/A_LWL<14>
+ RM_IHPSG13_1P_COLUMN_256_0[3]/RM_IHPSG13_1P_BITKIT_16x2_SRAM_1[0]/A_LWL<14> RM_IHPSG13_1P_COLUMN_256_0[3]/RM_IHPSG13_1P_BITKIT_16x2_SRAM_2[3]/A_LWL<15>
+ RM_IHPSG13_1P_COLUMN_256_0[3]/RM_IHPSG13_1P_BITKIT_16x2_SRAM_1[2]/A_LWL<15> RM_IHPSG13_1P_COLUMN_256_0[3]/RM_IHPSG13_1P_BITKIT_16x2_SRAM_0[1]/A_LWL<11>
+ RM_IHPSG13_1P_COLUMN_256_0[3]/RM_IHPSG13_1P_BITKIT_16x2_SRAM_0[1]/A_LWL<5> RM_IHPSG13_1P_COLUMN_256_0[3]/RM_IHPSG13_1P_BITKIT_16x2_SRAM_1[0]/A_RWL<11>
+ RM_IHPSG13_1P_COLUMN_256_0[3]/RM_IHPSG13_1P_BITKIT_16x2_SRAM_2[2]/A_RWL<0> RM_IHPSG13_1P_COLUMN_256_0[3]/RM_IHPSG13_1P_BITKIT_16x2_SRAM_1[3]/A_LWL<1>
+ RM_IHPSG13_1P_COLUMN_256_0[3]/RM_IHPSG13_1P_BITKIT_16x2_SRAM_3[1]/A_RWL<8> RM_IHPSG13_1P_COLUMN_256_0[3]/RM_IHPSG13_1P_BITKIT_16x2_SRAM_0[2]/A_RWL<1>
+ RM_IHPSG13_1P_COLUMN_256_0[3]/RM_IHPSG13_1P_BITKIT_16x2_SRAM_3[3]/A_LWL<10> RM_IHPSG13_1P_COLUMN_256_0[3]/RM_IHPSG13_1P_BITKIT_16x2_SRAM_1[3]/A_LWL<12>
+ RM_IHPSG13_1P_COLUMN_256_0[3]/RM_IHPSG13_1P_BITKIT_16x2_SRAM_1[2]/A_RWL<1> RM_IHPSG13_1P_COLUMN_256_0[3]/RM_IHPSG13_1P_BITKIT_16x2_SRAM_0[1]/A_RWL<6>
+ RM_IHPSG13_1P_COLUMN_256_0[3]/RM_IHPSG13_1P_BITKIT_16x2_SRAM_2[1]/A_RWL<9> RM_IHPSG13_1P_COLUMN_256_0[3]/RM_IHPSG13_1P_BITKIT_16x2_SRAM_1[1]/A_RWL<11>
+ RM_IHPSG13_1P_COLUMN_256_0[3]/RM_IHPSG13_1P_BITKIT_16x2_SRAM_2[0]/A_RWL<6> RM_IHPSG13_1P_COLUMN_256_0[3]/RM_IHPSG13_1P_BITKIT_16x2_SRAM_3[1]/A_LWL<3>
+ RM_IHPSG13_1P_COLUMN_256_0[3]/RM_IHPSG13_1P_BITKIT_16x2_SRAM_2[0]/A_RWL<4> RM_IHPSG13_1P_COLUMN_256_0[3]/RM_IHPSG13_1P_BITKIT_16x2_SRAM_3[3]/A_RWL<7>
+ RM_IHPSG13_1P_COLUMN_256_0[3]/RM_IHPSG13_1P_BITKIT_16x2_SRAM_0[1]/A_LWL<2> RM_IHPSG13_1P_COLUMN_256_0[3]/RM_IHPSG13_1P_BITKIT_16x2_SRAM_2[3]/A_RWL<12>
+ RM_IHPSG13_1P_COLUMN_256_0[3]/RM_IHPSG13_1P_BITKIT_16x2_SRAM_2[1]/A_LWL<4> RM_IHPSG13_1P_COLUMN_256_0[3]/RM_IHPSG13_1P_BITKIT_16x2_SRAM_2[0]/A_LWL<12>
+ RM_IHPSG13_1P_COLUMN_256_0[3]/RM_IHPSG13_1P_BITKIT_16x2_SRAM_1[1]/A_LWL<5> RM_IHPSG13_1P_COLUMN_256_0[3]/RM_IHPSG13_1P_BITKIT_16x2_SRAM_3[2]/A_RWL<0>
+ RM_IHPSG13_1P_COLUMN_256_0[3]/RM_IHPSG13_1P_BITKIT_16x2_SRAM_0[1]/A_LWL<12> RM_IHPSG13_1P_COLUMN_256_0[3]/RM_IHPSG13_1P_BITKIT_16x2_SRAM_0[1]/A_LWL<6>
+ RM_IHPSG13_1P_COLUMN_256_0[3]/RM_IHPSG13_1P_BITKIT_16x2_SRAM_2[2]/A_RWL<1> RM_IHPSG13_1P_COLUMN_256_0[3]/RM_IHPSG13_1P_BITKIT_16x2_SRAM_3[0]/A_RWL<14>
+ RM_IHPSG13_1P_COLUMN_256_0[3]/RM_IHPSG13_1P_BITKIT_16x2_SRAM_1[0]/A_RWL<15> RM_IHPSG13_1P_COLUMN_256_0[3]/RM_IHPSG13_1P_BITKIT_16x2_SRAM_1[1]/A_LWL<4>
+ RM_IHPSG13_1P_COLUMN_256_0[3]/RM_IHPSG13_1P_BITKIT_16x2_SRAM_1[3]/A_LWL<13> RM_IHPSG13_1P_COLUMN_256_0[3]/RM_IHPSG13_1P_BITKIT_16x2_SRAM_1[2]/A_RWL<2>
+ RM_IHPSG13_1P_COLUMN_256_0[3]/RM_IHPSG13_1P_BITKIT_16x2_SRAM_1[1]/A_RWL<12> RM_IHPSG13_1P_COLUMN_256_0[3]/RM_IHPSG13_1P_BITKIT_16x2_SRAM_3[0]/A_LWL<4>
+ RM_IHPSG13_1P_COLUMN_256_0[3]/RM_IHPSG13_1P_BITKIT_16x2_SRAM_0[2]/A_LWL<9> RM_IHPSG13_1P_COLUMN_256_0[3]/RM_IHPSG13_1P_BITKIT_16x2_SRAM_0[2]/A_RWL<3>
+ RM_IHPSG13_1P_COLUMN_256_0[3]/RM_IHPSG13_1P_BITKIT_16x2_SRAM_3[1]/A_LWL<4> RM_IHPSG13_1P_COLUMN_256_0[3]/RM_IHPSG13_1P_BITKIT_16x2_SRAM_2[1]/A_LWL<5>
+ RM_IHPSG13_1P_COLUMN_256_0[3]/RM_IHPSG13_1P_BITKIT_16x2_SRAM_1[2]/A_RWL<0> RM_IHPSG13_1P_COLUMN_256_0[3]/RM_IHPSG13_1P_BITKIT_16x2_SRAM_1[1]/A_RWL<5>
+ RM_IHPSG13_1P_COLUMN_256_0[3]/RM_IHPSG13_1P_BITKIT_16x2_SRAM_2[2]/A_LWL<15> RM_IHPSG13_1P_COLUMN_256_0[3]/RM_IHPSG13_1P_BITKIT_16x2_SRAM_3[2]/A_RWL<1>
+ RM_IHPSG13_1P_COLUMN_256_0[3]/RM_IHPSG13_1P_BITKIT_16x2_SRAM_1[3]/A_LWL<10> RM_IHPSG13_1P_COLUMN_256_0[3]/RM_IHPSG13_1P_BITKIT_16x2_SRAM_0[1]/A_LWL<7>
+ RM_IHPSG13_1P_COLUMN_256_0[3]/RM_IHPSG13_1P_BITKIT_16x2_SRAM_1[1]/A_LWL<3> RM_IHPSG13_1P_COLUMN_256_0[3]/RM_IHPSG13_1P_BITKIT_16x2_SRAM_1[0]/A_LWL<6>
+ RM_IHPSG13_1P_COLUMN_256_0[3]/RM_IHPSG13_1P_BITKIT_16x2_SRAM_3[2]/A_LWL<10> RM_IHPSG13_1P_COLUMN_256_0[3]/RM_IHPSG13_1P_BITKIT_16x2_SRAM_1[3]/A_LWL<14>
+ RM_IHPSG13_1P_COLUMN_256_0[3]/RM_IHPSG13_1P_BITKIT_16x2_SRAM_3[1]/A_LWL<1> RM_IHPSG13_1P_COLUMN_256_0[3]/RM_IHPSG13_1P_BITKIT_16x2_SRAM_3[1]/A_LWL<2>
+ RM_IHPSG13_1P_COLUMN_256_0[3]/RM_IHPSG13_1P_BITKIT_16x2_SRAM_0[0]/A_RWL<6> RM_IHPSG13_1P_COLUMN_256_0[3]/RM_IHPSG13_1P_BITKIT_16x2_SRAM_1[2]/A_RWL<3>
+ RM_IHPSG13_1P_COLUMN_256_0[3]/RM_IHPSG13_1P_BITKIT_16x2_SRAM_0[2]/A_LWL<10> RM_IHPSG13_1P_COLUMN_256_0[3]/RM_IHPSG13_1P_BITKIT_16x2_SRAM_1[3]/A_RWL<7>
+ RM_IHPSG13_1P_COLUMN_256_0[3]/RM_IHPSG13_1P_BITKIT_16x2_SRAM_1[1]/A_RWL<13> RM_IHPSG13_1P_COLUMN_256_0[3]/RM_IHPSG13_1P_BITKIT_16x2_SRAM_0[2]/A_RWL<4>
+ RM_IHPSG13_1P_COLUMN_256_0[3]/RM_IHPSG13_1P_BITKIT_16x2_SRAM_0[0]/A_LWL<12> RM_IHPSG13_1P_COLUMN_256_0[3]/RM_IHPSG13_1P_BITKIT_16x2_SRAM_2[3]/A_RWL<14>
+ RM_IHPSG13_1P_COLUMN_256_0[3]/RM_IHPSG13_1P_BITKIT_16x2_SRAM_2[1]/A_LWL<6> RM_IHPSG13_1P_COLUMN_256_0[3]/RM_IHPSG13_1P_BITKIT_16x2_SRAM_1[1]/A_LWL<7>
+ RM_IHPSG13_1P_COLUMN_256_0[3]/RM_IHPSG13_1P_BITKIT_16x2_SRAM_3[2]/A_RWL<2> RM_IHPSG13_1P_COLUMN_256_0[3]/RM_IHPSG13_1P_BITKIT_16x2_SRAM_1[0]/A_RWL<14>
+ RM_IHPSG13_1P_COLUMN_256_0[3]/RM_IHPSG13_1P_BITKIT_16x2_SRAM_0[1]/A_LWL<14> RM_IHPSG13_1P_COLUMN_256_0[3]/RM_IHPSG13_1P_BITKIT_16x2_SRAM_0[1]/A_LWL<8>
+ RM_IHPSG13_1P_COLUMN_256_0[3]/RM_IHPSG13_1P_BITKIT_16x2_SRAM_2[2]/A_RWL<3> RM_IHPSG13_1P_COLUMN_256_0[3]/RM_IHPSG13_1P_BITKIT_16x2_SRAM_1[3]/A_LWL<15>
+ RM_IHPSG13_1P_COLUMN_256_0[3]/RM_IHPSG13_1P_BITKIT_16x2_SRAM_1[0]/A_LWL<4> RM_IHPSG13_1P_COLUMN_256_0[3]/RM_IHPSG13_1P_BITKIT_16x2_SRAM_1[2]/A_RWL<4>
+ RM_IHPSG13_1P_COLUMN_256_0[3]/RM_IHPSG13_1P_BITKIT_16x2_SRAM_0[3]/A_RWL<8> RM_IHPSG13_1P_COLUMN_256_0[3]/RM_IHPSG13_1P_BITKIT_16x2_SRAM_2[1]/A_RWL<4>
+ RM_IHPSG13_1P_COLUMN_256_0[3]/RM_IHPSG13_1P_BITKIT_16x2_SRAM_2[0]/A_RWL<13> RM_IHPSG13_1P_COLUMN_256_0[3]/RM_IHPSG13_1P_BITKIT_16x2_SRAM_3[3]/A_RWL<10>
+ RM_IHPSG13_1P_COLUMN_256_0[3]/RM_IHPSG13_1P_BITKIT_16x2_SRAM_1[1]/A_RWL<14> RM_IHPSG13_1P_COLUMN_256_0[3]/RM_IHPSG13_1P_BITKIT_16x2_SRAM_0[2]/A_RWL<5>
+ RM_IHPSG13_1P_COLUMN_256_0[3]/RM_IHPSG13_1P_BITKIT_16x2_SRAM_0[0]/A_RWL<10> RM_IHPSG13_1P_COLUMN_256_0[3]/RM_IHPSG13_1P_BITKIT_16x2_SRAM_2[3]/A_RWL<9>
+ RM_IHPSG13_1P_COLUMN_256_0[3]/RM_IHPSG13_1P_BITKIT_16x2_SRAM_3[1]/A_LWL<6> RM_IHPSG13_1P_COLUMN_256_0[3]/RM_IHPSG13_1P_BITKIT_16x2_SRAM_2[0]/A_LWL<9>
+ RM_IHPSG13_1P_COLUMN_256_0[3]/RM_IHPSG13_1P_BITKIT_16x2_SRAM_2[3]/A_RWL<15> RM_IHPSG13_1P_COLUMN_256_0[3]/RM_IHPSG13_1P_BITKIT_16x2_SRAM_1[2]/A_RWL<11>
+ RM_IHPSG13_1P_COLUMN_256_0[3]/RM_IHPSG13_1P_BITKIT_16x2_SRAM_2[0]/A_LWL<7> RM_IHPSG13_1P_COLUMN_256_0[3]/RM_IHPSG13_1P_BITKIT_16x2_SRAM_3[3]/A_LWL<8>
+ RM_IHPSG13_1P_COLUMN_256_0[3]/RM_IHPSG13_1P_BITKIT_16x2_SRAM_2[1]/A_LWL<15> RM_IHPSG13_1P_COLUMN_256_0[3]/RM_IHPSG13_1P_BITKIT_16x2_SRAM_1[2]/A_LWL<10>
+ RM_IHPSG13_1P_COLUMN_256_0[3]/RM_IHPSG13_1P_BITKIT_16x2_SRAM_0[1]/A_LWL<9> RM_IHPSG13_1P_COLUMN_256_0[3]/RM_IHPSG13_1P_BITKIT_16x2_SRAM_1[1]/A_LWL<1>
+ RM_IHPSG13_1P_COLUMN_256_0[3]/RM_IHPSG13_1P_BITKIT_16x2_SRAM_3[1]/A_LWL<10> RM_IHPSG13_1P_COLUMN_256_0[3]/RM_IHPSG13_1P_BITKIT_16x2_SRAM_3[0]/A_LWL<1>
+ RM_IHPSG13_1P_COLUMN_256_0[3]/RM_IHPSG13_1P_BITKIT_16x2_SRAM_0[2]/A_LWL<12> RM_IHPSG13_1P_COLUMN_256_0[3]/RM_IHPSG13_1P_BITKIT_16x2_SRAM_1[1]/A_RWL<15>
+ RM_IHPSG13_1P_COLUMN_256_0[3]/RM_IHPSG13_1P_BITKIT_16x2_SRAM_0[2]/A_RWL<6> RM_IHPSG13_1P_COLUMN_256_0[3]/RM_IHPSG13_1P_BITKIT_16x2_SRAM_0[0]/A_RWL<11>
+ RM_IHPSG13_1P_COLUMN_256_0[3]/RM_IHPSG13_1P_BITKIT_16x2_SRAM_3[1]/A_LWL<7> RM_IHPSG13_1P_COLUMN_256_0[3]/RM_IHPSG13_1P_BITKIT_16x2_SRAM_3[1]/A_RWL<7>
+ RM_IHPSG13_1P_COLUMN_256_0[3]/RM_IHPSG13_1P_BITKIT_16x2_SRAM_1[2]/A_RWL<5> RM_IHPSG13_1P_COLUMN_256_0[3]/RM_IHPSG13_1P_BITKIT_16x2_SRAM_1[2]/A_LWL<0>
+ RM_IHPSG13_1P_COLUMN_256_0[3]/RM_IHPSG13_1P_BITKIT_16x2_SRAM_1[2]/A_RWL<12> RM_IHPSG13_1P_COLUMN_256_0[3]/RM_IHPSG13_1P_BITKIT_16x2_SRAM_2[1]/A_LWL<8>
+ RM_IHPSG13_1P_COLUMN_256_0[3]/RM_IHPSG13_1P_BITKIT_16x2_SRAM_2[2]/A_RWL<2> RM_IHPSG13_1P_COLUMN_256_0[3]/RM_IHPSG13_1P_BITKIT_16x2_SRAM_0[2]/A_LWL<1>
+ RM_IHPSG13_1P_COLUMN_256_0[3]/RM_IHPSG13_1P_BITKIT_16x2_SRAM_0[3]/A_RWL<15> RM_IHPSG13_1P_COLUMN_256_0[3]/RM_IHPSG13_1P_BITKIT_16x2_SRAM_1[1]/A_LWL<9>
+ RM_IHPSG13_1P_COLUMN_256_0[3]/RM_IHPSG13_1P_BITKIT_16x2_SRAM_3[2]/A_RWL<4> RM_IHPSG13_1P_COLUMN_256_0[3]/RM_IHPSG13_1P_BITKIT_16x2_SRAM_3[0]/A_RWL<12>
+ RM_IHPSG13_1P_COLUMN_256_0[3]/RM_IHPSG13_1P_BITKIT_16x2_SRAM_1[1]/A_LWL<6> RM_IHPSG13_1P_COLUMN_256_0[3]/RM_IHPSG13_1P_BITKIT_16x2_SRAM_3[3]/A_RWL<8>
+ RM_IHPSG13_1P_COLUMN_256_0[3]/RM_IHPSG13_1P_BITKIT_16x2_SRAM_2[2]/A_RWL<15> RM_IHPSG13_1P_COLUMN_256_0[3]/RM_IHPSG13_1P_BITKIT_16x2_SRAM_2[2]/A_RWL<5>
+ RM_IHPSG13_1P_COLUMN_256_0[3]/RM_IHPSG13_1P_BITKIT_16x2_SRAM_1[2]/A_RWL<6> RM_IHPSG13_1P_COLUMN_256_0[3]/RM_IHPSG13_1P_BITKIT_16x2_SRAM_3[2]/A_RWL<10>
+ RM_IHPSG13_1P_COLUMN_256_0[3]/RM_IHPSG13_1P_BITKIT_16x2_SRAM_0[0]/A_LWL<9> RM_IHPSG13_1P_COLUMN_256_0[3]/RM_IHPSG13_1P_BITKIT_16x2_SRAM_0[0]/A_RWL<12>
+ RM_IHPSG13_1P_COLUMN_256_0[3]/RM_IHPSG13_1P_BITKIT_16x2_SRAM_0[2]/A_RWL<7> RM_IHPSG13_1P_COLUMN_256_0[3]/RM_IHPSG13_1P_BITKIT_16x2_SRAM_1[3]/A_LWL<8>
+ RM_IHPSG13_1P_COLUMN_256_0[3]/RM_IHPSG13_1P_BITKIT_16x2_SRAM_0[3]/A_LWL<10> RM_IHPSG13_1P_COLUMN_256_0[3]/RM_IHPSG13_1P_BITKIT_16x2_SRAM_1[2]/A_LWL<1>
+ RM_IHPSG13_1P_COLUMN_256_0[3]/RM_IHPSG13_1P_BITKIT_16x2_SRAM_2[1]/A_LWL<9> RM_IHPSG13_1P_COLUMN_256_0[3]/RM_IHPSG13_1P_BITKIT_16x2_SRAM_1[2]/A_RWL<13>
+ RM_IHPSG13_1P_COLUMN_256_0[3]/RM_IHPSG13_1P_BITKIT_16x2_SRAM_0[1]/A_LWL<15> RM_IHPSG13_1P_COLUMN_256_0[3]/RM_IHPSG13_1P_BITKIT_16x2_SRAM_3[2]/A_LWL<8>
+ RM_IHPSG13_1P_COLUMN_256_0[3]/RM_IHPSG13_1P_BITKIT_16x2_SRAM_0[2]/A_LWL<2> RM_IHPSG13_1P_COLUMN_256_0[3]/RM_IHPSG13_1P_BITKIT_16x2_SRAM_2[0]/A_LWL<15>
+ RM_IHPSG13_1P_COLUMN_256_0[3]/RM_IHPSG13_1P_BITKIT_16x2_SRAM_2[3]/A_LWL<13> RM_IHPSG13_1P_COLUMN_256_0[3]/RM_IHPSG13_1P_BITKIT_16x2_SRAM_3[2]/A_RWL<5>
+ RM_IHPSG13_1P_COLUMN_256_0[3]/RM_IHPSG13_1P_BITKIT_16x2_SRAM_1[3]/A_RWL<10> RM_IHPSG13_1P_COLUMN_256_0[3]/RM_IHPSG13_1P_BITKIT_16x2_SRAM_1[1]/A_LWL<10>
+ RM_IHPSG13_1P_COLUMN_256_0[3]/RM_IHPSG13_1P_BITKIT_16x2_SRAM_0[0]/A_RWL<9> RM_IHPSG13_1P_COLUMN_256_0[3]/RM_IHPSG13_1P_BITKIT_16x2_SRAM_1[0]/A_LWL<1>
+ RM_IHPSG13_1P_COLUMN_256_0[3]/RM_IHPSG13_1P_BITKIT_16x2_SRAM_2[2]/A_RWL<6> RM_IHPSG13_1P_COLUMN_256_0[3]/RM_IHPSG13_1P_BITKIT_16x2_SRAM_2[2]/A_RWL<4>
+ RM_IHPSG13_1P_COLUMN_256_0[3]/RM_IHPSG13_1P_BITKIT_16x2_SRAM_2[1]/A_RWL<13> RM_IHPSG13_1P_COLUMN_256_0[3]/RM_IHPSG13_1P_BITKIT_16x2_SRAM_0[3]/A_LWL<2>
+ RM_IHPSG13_1P_COLUMN_256_0[3]/RM_IHPSG13_1P_BITKIT_16x2_SRAM_2[3]/A_LWL<0> RM_IHPSG13_1P_COLUMN_256_0[3]/RM_IHPSG13_1P_BITKIT_16x2_SRAM_3[2]/A_LWL<0>
+ RM_IHPSG13_1P_COLUMN_256_0[3]/RM_IHPSG13_1P_BITKIT_16x2_SRAM_1[2]/A_RWL<7> RM_IHPSG13_1P_COLUMN_256_0[3]/RM_IHPSG13_1P_BITKIT_16x2_SRAM_0[2]/A_LWL<14>
+ RM_IHPSG13_1P_COLUMN_256_0[3]/RM_IHPSG13_1P_BITKIT_16x2_SRAM_1[1]/A_RWL<7> RM_IHPSG13_1P_COLUMN_256_0[3]/RM_IHPSG13_1P_BITKIT_16x2_SRAM_2[2]/A_LWL<1>
+ RM_IHPSG13_1P_COLUMN_256_0[3]/RM_IHPSG13_1P_BITKIT_16x2_SRAM_0[0]/A_RWL<13> RM_IHPSG13_1P_COLUMN_256_0[3]/RM_IHPSG13_1P_BITKIT_16x2_SRAM_2[1]/A_LWL<7>
+ RM_IHPSG13_1P_COLUMN_256_0[3]/RM_IHPSG13_1P_BITKIT_16x2_SRAM_0[2]/A_RWL<8> RM_IHPSG13_1P_COLUMN_256_0[3]/RM_IHPSG13_1P_BITKIT_16x2_SRAM_3[0]/A_RWL<7>
+ RM_IHPSG13_1P_COLUMN_256_0[3]/RM_IHPSG13_1P_BITKIT_16x2_SRAM_3[1]/A_LWL<9> RM_IHPSG13_1P_COLUMN_256_0[3]/RM_IHPSG13_1P_BITKIT_16x2_SRAM_3[3]/A_LWL<5>
+ RM_IHPSG13_1P_COLUMN_256_0[3]/RM_IHPSG13_1P_BITKIT_16x2_SRAM_0[2]/A_RWL<2> RM_IHPSG13_1P_COLUMN_256_0[3]/RM_IHPSG13_1P_BITKIT_16x2_SRAM_1[2]/A_LWL<2>
+ RM_IHPSG13_1P_COLUMN_256_0[3]/RM_IHPSG13_1P_BITKIT_16x2_SRAM_1[2]/A_RWL<14> RM_IHPSG13_1P_COLUMN_256_0[3]/RM_IHPSG13_1P_BITKIT_16x2_SRAM_2[1]/A_RWL<2>
+ RM_IHPSG13_1P_COLUMN_256_0[3]/RM_IHPSG13_1P_BITKIT_16x2_SRAM_0[1]/A_RWL<10> RM_IHPSG13_1P_COLUMN_256_0[3]/RM_IHPSG13_1P_BITKIT_16x2_SRAM_0[2]/A_LWL<3>
+ RM_IHPSG13_1P_COLUMN_256_0[3]/RM_IHPSG13_1P_BITKIT_16x2_SRAM_0[2]/A_RWL<15> RM_IHPSG13_1P_COLUMN_256_0[3]/RM_IHPSG13_1P_BITKIT_16x2_SRAM_3[2]/A_RWL<6>
+ RM_IHPSG13_1P_COLUMN_256_0[3]/RM_IHPSG13_1P_BITKIT_16x2_SRAM_1[3]/A_RWL<11> RM_IHPSG13_1P_COLUMN_256_0[3]/RM_IHPSG13_1P_BITKIT_16x2_SRAM_2[1]/A_RWL<15>
+ RM_IHPSG13_1P_COLUMN_256_0[3]/RM_IHPSG13_1P_BITKIT_16x2_SRAM_2[2]/A_RWL<7> RM_IHPSG13_1P_COLUMN_256_0[3]/RM_IHPSG13_1P_BITKIT_16x2_SRAM_1[2]/A_RWL<10>
+ RM_IHPSG13_1P_COLUMN_256_0[3]/RM_IHPSG13_1P_BITKIT_16x2_SRAM_0[3]/A_RWL<0> RM_IHPSG13_1P_COLUMN_256_0[3]/RM_IHPSG13_1P_BITKIT_16x2_SRAM_1[0]/A_RWL<1>
+ RM_IHPSG13_1P_COLUMN_256_0[3]/RM_IHPSG13_1P_BITKIT_16x2_SRAM_3[2]/A_LWL<1> RM_IHPSG13_1P_COLUMN_256_0[3]/RM_IHPSG13_1P_BITKIT_16x2_SRAM_1[2]/A_RWL<8>
+ RM_IHPSG13_1P_COLUMN_256_0[3]/RM_IHPSG13_1P_BITKIT_16x2_SRAM_0[2]/A_LWL<15> RM_IHPSG13_1P_COLUMN_256_0[3]/RM_IHPSG13_1P_BITKIT_16x2_SRAM_1[3]/A_RWL<5>
+ RM_IHPSG13_1P_COLUMN_256_0[3]/RM_IHPSG13_1P_BITKIT_16x2_SRAM_3[1]/A_RWL<10> RM_IHPSG13_1P_COLUMN_256_0[3]/RM_IHPSG13_1P_BITKIT_16x2_SRAM_0[0]/A_RWL<14>
+ RM_IHPSG13_1P_COLUMN_256_0[3]/RM_IHPSG13_1P_BITKIT_16x2_SRAM_2[2]/A_LWL<2> RM_IHPSG13_1P_COLUMN_256_0[3]/RM_IHPSG13_1P_BITKIT_16x2_SRAM_1[2]/A_LWL<8>
+ RM_IHPSG13_1P_COLUMN_256_0[3]/RM_IHPSG13_1P_BITKIT_16x2_SRAM_1[0]/A_RWL<8> RM_IHPSG13_1P_COLUMN_256_0[3]/RM_IHPSG13_1P_BITKIT_16x2_SRAM_0[3]/A_LWL<12>
+ RM_IHPSG13_1P_COLUMN_256_0[3]/RM_IHPSG13_1P_BITKIT_16x2_SRAM_1[2]/A_LWL<3> RM_IHPSG13_1P_COLUMN_256_0[3]/RM_IHPSG13_1P_BITKIT_16x2_SRAM_3[1]/A_LWL<8>
+ RM_IHPSG13_1P_COLUMN_256_0[3]/RM_IHPSG13_1P_BITKIT_16x2_SRAM_3[1]/A_RWL<12> RM_IHPSG13_1P_COLUMN_256_0[3]/RM_IHPSG13_1P_BITKIT_16x2_SRAM_1[3]/A_LWL<3>
+ RM_IHPSG13_1P_COLUMN_256_0[3]/RM_IHPSG13_1P_BITKIT_16x2_SRAM_1[2]/A_RWL<15> RM_IHPSG13_1P_COLUMN_256_0[3]/RM_IHPSG13_1P_BITKIT_16x2_SRAM_0[0]/A_LWL<15>
+ RM_IHPSG13_1P_COLUMN_256_0[3]/RM_IHPSG13_1P_BITKIT_16x2_SRAM_3[0]/A_RWL<9> RM_IHPSG13_1P_COLUMN_256_0[3]/RM_IHPSG13_1P_BITKIT_16x2_SRAM_0[1]/A_RWL<11>
+ RM_IHPSG13_1P_COLUMN_256_0[3]/RM_IHPSG13_1P_BITKIT_16x2_SRAM_3[3]/A_LWL<2> RM_IHPSG13_1P_COLUMN_256_0[3]/RM_IHPSG13_1P_BITKIT_16x2_SRAM_0[2]/A_LWL<4>
+ RM_IHPSG13_1P_COLUMN_256_0[3]/RM_IHPSG13_1P_BITKIT_16x2_SRAM_2[2]/A_LWL<13> RM_IHPSG13_1P_COLUMN_256_0[3]/RM_IHPSG13_1P_BITKIT_16x2_SRAM_3[2]/A_RWL<7>
+ RM_IHPSG13_1P_COLUMN_256_0[3]/RM_IHPSG13_1P_BITKIT_16x2_SRAM_1[3]/A_RWL<12> RM_IHPSG13_1P_COLUMN_256_0[3]/RM_IHPSG13_1P_BITKIT_16x2_SRAM_0[3]/A_LWL<0>
+ RM_IHPSG13_1P_COLUMN_256_0[3]/RM_IHPSG13_1P_BITKIT_16x2_SRAM_1[0]/A_LWL<10> RM_IHPSG13_1P_COLUMN_256_0[3]/RM_IHPSG13_1P_BITKIT_16x2_SRAM_1[3]/A_RWL<0>
+ RM_IHPSG13_1P_COLUMN_256_0[3]/RM_IHPSG13_1P_BITKIT_16x2_SRAM_2[2]/A_RWL<8> RM_IHPSG13_1P_COLUMN_256_0[3]/RM_IHPSG13_1P_BITKIT_16x2_SRAM_2[3]/A_LWL<11>
+ RM_IHPSG13_1P_COLUMN_256_0[3]/RM_IHPSG13_1P_BITKIT_16x2_SRAM_2[2]/A_LWL<0> RM_IHPSG13_1P_COLUMN_256_0[3]/RM_IHPSG13_1P_BITKIT_16x2_SRAM_0[3]/A_RWL<1>
+ RM_IHPSG13_1P_COLUMN_256_0[3]/RM_IHPSG13_1P_BITKIT_16x2_SRAM_3[2]/A_LWL<2> RM_IHPSG13_1P_COLUMN_256_0[3]/RM_IHPSG13_1P_BITKIT_16x2_SRAM_1[2]/A_RWL<9>
+ RM_IHPSG13_1P_COLUMN_256_0[3]/RM_IHPSG13_1P_BITKIT_16x2_SRAM_1[0]/A_RWL<7> RM_IHPSG13_1P_COLUMN_256_0[3]/RM_IHPSG13_1P_BITKIT_16x2_SRAM_1[3]/A_LWL<5>
+ RM_IHPSG13_1P_COLUMN_256_0[3]/RM_IHPSG13_1P_BITKIT_16x2_SRAM_2[2]/A_LWL<3> RM_IHPSG13_1P_COLUMN_256_0[3]/RM_IHPSG13_1P_BITKIT_16x2_SRAM_0[1]/A_RWL<2>
+ RM_IHPSG13_1P_COLUMN_256_0[3]/RM_IHPSG13_1P_BITKIT_16x2_SRAM_0[3]/A_LWL<13> RM_IHPSG13_1P_COLUMN_256_0[3]/RM_IHPSG13_1P_BITKIT_16x2_SRAM_1[2]/A_LWL<4>
+ RM_IHPSG13_1P_COLUMN_256_0[3]/RM_IHPSG13_1P_BITKIT_16x2_SRAM_2[0]/A_RWL<2> RM_IHPSG13_1P_COLUMN_256_0[3]/RM_IHPSG13_1P_BITKIT_16x2_SRAM_0[1]/A_RWL<12>
+ RM_IHPSG13_1P_COLUMN_256_0[3]/RM_IHPSG13_1P_BITKIT_16x2_SRAM_2[0]/A_RWL<0> RM_IHPSG13_1P_COLUMN_256_0[3]/RM_IHPSG13_1P_BITKIT_16x2_SRAM_3[3]/A_RWL<3>
+ RM_IHPSG13_1P_COLUMN_256_0[3]/RM_IHPSG13_1P_BITKIT_16x2_SRAM_0[1]/A_RWL<9> RM_IHPSG13_1P_COLUMN_256_0[3]/RM_IHPSG13_1P_BITKIT_16x2_SRAM_0[2]/A_LWL<5>
+ RM_IHPSG13_1P_COLUMN_256_0[3]/RM_IHPSG13_1P_BITKIT_16x2_SRAM_2[3]/A_RWL<4> RM_IHPSG13_1P_COLUMN_256_0[3]/RM_IHPSG13_1P_BITKIT_16x2_SRAM_2[3]/A_RWL<0>
+ RM_IHPSG13_1P_COLUMN_256_0[3]/RM_IHPSG13_1P_BITKIT_16x2_SRAM_3[2]/A_RWL<8> RM_IHPSG13_1P_COLUMN_256_0[3]/RM_IHPSG13_1P_BITKIT_16x2_SRAM_2[2]/A_RWL<13>
+ RM_IHPSG13_1P_COLUMN_256_0[3]/RM_IHPSG13_1P_BITKIT_16x2_SRAM_1[3]/A_RWL<13> RM_IHPSG13_1P_COLUMN_256_0[3]/RM_IHPSG13_1P_BITKIT_16x2_SRAM_2[0]/A_RWL<15>
+ RM_IHPSG13_1P_COLUMN_256_0[3]/RM_IHPSG13_1P_BITKIT_16x2_SRAM_1[3]/A_RWL<1> RM_IHPSG13_1P_COLUMN_256_0[3]/RM_IHPSG13_1P_BITKIT_16x2_SRAM_2[2]/A_RWL<9>
+ RM_IHPSG13_1P_COLUMN_256_0[3]/RM_IHPSG13_1P_BITKIT_16x2_SRAM_1[1]/A_RWL<10> RM_IHPSG13_1P_COLUMN_256_0[3]/RM_IHPSG13_1P_BITKIT_16x2_SRAM_2[2]/A_LWL<7>
+ RM_IHPSG13_1P_COLUMN_256_0[3]/RM_IHPSG13_1P_BITKIT_16x2_SRAM_0[3]/A_RWL<2> RM_IHPSG13_1P_COLUMN_256_0[3]/RM_IHPSG13_1P_BITKIT_16x2_SRAM_3[2]/A_LWL<3>
+ RM_IHPSG13_1P_COLUMN_256_0[3]/RM_IHPSG13_1P_BITKIT_16x2_SRAM_3[0]/A_RWL<10> RM_IHPSG13_1P_COLUMN_256_0[3]/RM_IHPSG13_1P_BITKIT_16x2_SRAM_2[2]/A_LWL<4>
+ RM_IHPSG13_1P_COLUMN_256_0[3]/RM_IHPSG13_1P_BITKIT_16x2_SRAM_1[1]/A_LWL<8> RM_IHPSG13_1P_COLUMN_256_0[3]/RM_IHPSG13_1P_BITKIT_16x2_SRAM_0[3]/A_LWL<14>
+ RM_IHPSG13_1P_COLUMN_256_0[3]/RM_IHPSG13_1P_BITKIT_16x2_SRAM_3[0]/A_LWL<8> RM_IHPSG13_1P_COLUMN_256_0[3]/RM_IHPSG13_1P_BITKIT_16x2_SRAM_3[3]/A_RWL<0>
+ RM_IHPSG13_1P_COLUMN_256_0[3]/RM_IHPSG13_1P_BITKIT_16x2_SRAM_0[2]/A_LWL<13> RM_IHPSG13_1P_COLUMN_256_0[3]/RM_IHPSG13_1P_BITKIT_16x2_SRAM_0[1]/A_RWL<13>
+ RM_IHPSG13_1P_COLUMN_256_0[3]/RM_IHPSG13_1P_BITKIT_16x2_SRAM_3[0]/A_LWL<10> RM_IHPSG13_1P_COLUMN_256_0[3]/RM_IHPSG13_1P_BITKIT_16x2_SRAM_2[1]/A_LWL<13>
+ RM_IHPSG13_1P_COLUMN_256_0[3]/RM_IHPSG13_1P_BITKIT_16x2_SRAM_0[2]/A_LWL<6> RM_IHPSG13_1P_COLUMN_256_0[3]/RM_IHPSG13_1P_BITKIT_16x2_SRAM_2[3]/A_RWL<1>
+ RM_IHPSG13_1P_COLUMN_256_0[3]/RM_IHPSG13_1P_BITKIT_16x2_SRAM_3[2]/A_RWL<9> RM_IHPSG13_1P_COLUMN_256_0[3]/RM_IHPSG13_1P_BITKIT_16x2_SRAM_0[3]/A_LWL<11>
+ RM_IHPSG13_1P_COLUMN_256_0[3]/RM_IHPSG13_1P_BITKIT_16x2_SRAM_1[3]/A_RWL<14> RM_IHPSG13_1P_COLUMN_256_0[3]/RM_IHPSG13_1P_BITKIT_16x2_SRAM_0[2]/A_LWL<0>
+ RM_IHPSG13_1P_COLUMN_256_0[3]/RM_IHPSG13_1P_BITKIT_16x2_SRAM_1[1]/A_RWL<1> RM_IHPSG13_1P_COLUMN_256_0[3]/RM_IHPSG13_1P_BITKIT_16x2_SRAM_0[2]/A_RWL<10>
+ RM_IHPSG13_1P_COLUMN_256_0[3]/RM_IHPSG13_1P_BITKIT_16x2_SRAM_1[3]/A_RWL<2> RM_IHPSG13_1P_COLUMN_256_0[3]/RM_IHPSG13_1P_BITKIT_16x2_SRAM_2[2]/A_LWL<11>
+ RM_IHPSG13_1P_COLUMN_256_0[3]/RM_IHPSG13_1P_BITKIT_16x2_SRAM_2[1]/A_LWL<0> RM_IHPSG13_1P_COLUMN_256_0[3]/RM_IHPSG13_1P_BITKIT_16x2_SRAM_0[3]/A_RWL<3>
+ RM_IHPSG13_1P_COLUMN_256_0[3]/RM_IHPSG13_1P_BITKIT_16x2_SRAM_3[2]/A_LWL<4> RM_IHPSG13_1P_COLUMN_256_0[3]/RM_IHPSG13_1P_BITKIT_16x2_SRAM_1[1]/A_RWL<8>
+ RM_IHPSG13_1P_COLUMN_256_0[3]/RM_IHPSG13_1P_BITKIT_16x2_SRAM_1[2]/A_LWL<5> RM_IHPSG13_1P_COLUMN_256_0[3]/RM_IHPSG13_1P_BITKIT_16x2_SRAM_1[0]/A_LWL<2>
+ RM_IHPSG13_1P_COLUMN_256_0[3]/RM_IHPSG13_1P_BITKIT_16x2_SRAM_3[2]/A_RWL<12> RM_IHPSG13_1P_COLUMN_256_0[3]/RM_IHPSG13_1P_BITKIT_16x2_SRAM_2[2]/A_LWL<5>
+ RM_IHPSG13_1P_COLUMN_256_0[3]/RM_IHPSG13_1P_BITKIT_16x2_SRAM_1[3]/A_LWL<6> RM_IHPSG13_1P_COLUMN_256_0[3]/RM_IHPSG13_1P_BITKIT_16x2_SRAM_3[1]/A_RWL<9>
+ RM_IHPSG13_1P_COLUMN_256_0[3]/RM_IHPSG13_1P_BITKIT_16x2_SRAM_3[1]/A_LWL<5> RM_IHPSG13_1P_COLUMN_256_0[3]/RM_IHPSG13_1P_BITKIT_16x2_SRAM_0[0]/A_RWL<2>
+ RM_IHPSG13_1P_COLUMN_256_0[3]/RM_IHPSG13_1P_BITKIT_16x2_SRAM_0[3]/A_LWL<15> RM_IHPSG13_1P_COLUMN_256_0[3]/RM_IHPSG13_1P_BITKIT_16x2_SRAM_1[2]/A_LWL<6>
+ RM_IHPSG13_1P_COLUMN_256_0[3]/RM_IHPSG13_1P_BITKIT_16x2_SRAM_3[3]/A_RWL<1> RM_IHPSG13_1P_COLUMN_256_0[3]/RM_IHPSG13_1P_BITKIT_16x2_SRAM_0[1]/A_RWL<14>
+ RM_IHPSG13_1P_COLUMN_256_0[3]/RM_IHPSG13_1P_BITKIT_16x2_SRAM_3[2]/A_RWL<3> RM_IHPSG13_1P_COLUMN_256_0[3]/RM_IHPSG13_1P_BITKIT_16x2_SRAM_3[0]/A_LWL<11>
+ RM_IHPSG13_1P_COLUMN_256_0[3]/RM_IHPSG13_1P_BITKIT_16x2_SRAM_0[2]/A_LWL<7> RM_IHPSG13_1P_COLUMN_256_0[3]/RM_IHPSG13_1P_BITKIT_16x2_SRAM_0[0]/A_RWL<15>
+ RM_IHPSG13_1P_COLUMN_256_0[3]/RM_IHPSG13_1P_BITKIT_16x2_SRAM_2[3]/A_RWL<2> RM_IHPSG13_1P_COLUMN_256_0[3]/RM_IHPSG13_1P_BITKIT_16x2_SRAM_2[3]/A_LWL<14>
+ RM_IHPSG13_1P_COLUMN_256_0[3]/RM_IHPSG13_1P_BITKIT_16x2_SRAM_1[3]/A_RWL<15> RM_IHPSG13_1P_COLUMN_256_0[3]/RM_IHPSG13_1P_BITKIT_16x2_SRAM_0[2]/A_RWL<11>
+ RM_IHPSG13_1P_COLUMN_256_0[3]/RM_IHPSG13_1P_BITKIT_16x2_SRAM_1[3]/A_RWL<3> RM_IHPSG13_1P_COLUMN_256_0[3]/RM_IHPSG13_1P_BITKIT_16x2_SRAM_1[0]/A_RWL<10>
+ RM_IHPSG13_1P_COLUMN_256_0[3]/RM_IHPSG13_1P_BITKIT_16x2_SRAM_0[3]/A_RWL<4> RM_IHPSG13_1P_COLUMN_256_0[3]/RM_IHPSG13_1P_BITKIT_16x2_SRAM_2[3]/A_RWL<11>
+ RM_IHPSG13_1P_COLUMN_256_0[3]/RM_IHPSG13_1P_BITKIT_16x2_SRAM_3[2]/A_LWL<5> RM_IHPSG13_1P_COLUMN_256_0[3]/RM_IHPSG13_1P_BITKIT_16x2_SRAM_0[0]/A_RWL<4>
+ RM_IHPSG13_1P_COLUMN_256_0[3]/RM_IHPSG13_1P_BITKIT_16x2_SRAM_2[2]/A_LWL<6> RM_IHPSG13_1P_COLUMN_256_0[3]/RM_IHPSG13_1P_BITKIT_16x2_SRAM_1[0]/A_LWL<8>
+ RM_IHPSG13_1P_COLUMN_256_0[3]/RM_IHPSG13_1P_BITKIT_16x2_SRAM_0[3]/A_RWL<12> RM_IHPSG13_1P_COLUMN_256_0[3]/RM_IHPSG13_1P_BITKIT_16x2_SRAM_2[1]/A_RWL<0>
+ RM_IHPSG13_1P_COLUMN_256_0[3]/RM_IHPSG13_1P_BITKIT_16x2_SRAM_3[3]/A_RWL<6> RM_IHPSG13_1P_COLUMN_256_0[3]/RM_IHPSG13_1P_BITKIT_16x2_SRAM_2[0]/A_RWL<5>
+ RM_IHPSG13_1P_COLUMN_256_0[3]/RM_IHPSG13_1P_BITKIT_16x2_SRAM_0[2]/A_RWL<9> RM_IHPSG13_1P_COLUMN_256_0[3]/RM_IHPSG13_1P_BITKIT_16x2_SRAM_1[2]/A_LWL<7>
+ RM_IHPSG13_1P_COLUMN_256_0[3]/RM_IHPSG13_1P_BITKIT_16x2_SRAM_0[1]/A_LWL<13> RM_IHPSG13_1P_COLUMN_256_0[3]/RM_IHPSG13_1P_BITKIT_16x2_SRAM_3[3]/A_RWL<2>
+ RM_IHPSG13_1P_COLUMN_256_0[3]/RM_IHPSG13_1P_BITKIT_16x2_SRAM_2[3]/A_RWL<13> RM_IHPSG13_1P_COLUMN_256_0[3]/RM_IHPSG13_1P_BITKIT_16x2_SRAM_0[1]/A_RWL<15>
+ RM_IHPSG13_1P_COLUMN_256_0[3]/RM_IHPSG13_1P_BITKIT_16x2_SRAM_3[0]/A_LWL<12> RM_IHPSG13_1P_COLUMN_256_0[3]/RM_IHPSG13_1P_BITKIT_16x2_SRAM_0[2]/A_LWL<8>
+ RM_IHPSG13_1P_COLUMN_256_0[3]/RM_IHPSG13_1P_BITKIT_16x2_SRAM_2[0]/A_LWL<13> RM_IHPSG13_1P_COLUMN_256_0[3]/RM_IHPSG13_1P_BITKIT_16x2_SRAM_2[3]/A_RWL<3>
+ RM_IHPSG13_1P_COLUMN_256_0[3]/RM_IHPSG13_1P_BITKIT_16x2_SRAM_0[2]/A_LWL<11> RM_IHPSG13_1P_COLUMN_256_0[3]/RM_IHPSG13_1P_BITKIT_16x2_SRAM_3[3]/A_LWL<12>
+ RM_IHPSG13_1P_COLUMN_256_0[3]/RM_IHPSG13_1P_BITKIT_16x2_SRAM_2[0]/A_LWL<3> RM_IHPSG13_1P_COLUMN_256_0[3]/RM_IHPSG13_1P_BITKIT_16x2_SRAM_0[1]/A_LWL<0>
+ RM_IHPSG13_1P_COLUMN_256_0[3]/RM_IHPSG13_1P_BITKIT_16x2_SRAM_2[3]/A_LWL<7> RM_IHPSG13_1P_COLUMN_256_0[3]/RM_IHPSG13_1P_BITKIT_16x2_SRAM_0[2]/A_RWL<12>
+ RM_IHPSG13_1P_COLUMN_256_0[3]/RM_IHPSG13_1P_BITKIT_16x2_SRAM_1[3]/A_RWL<4> RM_IHPSG13_1P_COLUMN_256_0[3]/RM_IHPSG13_1P_BITKIT_16x2_SRAM_2[1]/A_LWL<11>
+ RM_IHPSG13_1P_COLUMN_256_0[3]/RM_IHPSG13_1P_BITKIT_16x2_SRAM_2[0]/A_LWL<0> RM_IHPSG13_1P_COLUMN_256_0[7]/RM_IHPSG13_1P_BITKIT_16x2_SRAM_3[3]/VSS
+ RM_IHPSG13_1P_COLUMN_256_0[3]/RM_IHPSG13_1P_BITKIT_16x2_SRAM_0[3]/A_RWL<5> RM_IHPSG13_1P_COLUMN_256_0[7]/RM_IHPSG13_1P_BITKIT_16x2_SRAM_3[3]/VDD
+ RM_IHPSG13_1P_COLUMN_256_0[3]/RM_IHPSG13_1P_BITKIT_16x2_SRAM_3[2]/A_LWL<6> RM_IHPSG13_1P_COLUMN_256
XRM_IHPSG13_1P_COLUMN_256_0[4] RM_IHPSG13_1P_COLUMN_256_0[4]/RM_IHPSG13_1P_BITKIT_16x2_SRAM_0[0]/A_BLT_BOT<0>
+ RM_IHPSG13_1P_COLUMN_256_0[4]/RM_IHPSG13_1P_BITKIT_16x2_SRAM_0[0]/A_BLT_BOT<1> RM_IHPSG13_1P_COLUMN_256_0[4]/RM_IHPSG13_1P_BITKIT_16x2_SRAM_0[0]/A_BLC_BOT<0>
+ RM_IHPSG13_1P_COLUMN_256_0[4]/RM_IHPSG13_1P_BITKIT_16x2_SRAM_1[3]/A_RWL<6> RM_IHPSG13_1P_COLUMN_256_0[4]/RM_IHPSG13_1P_BITKIT_16x2_SRAM_0[3]/A_RWL<11>
+ RM_IHPSG13_1P_COLUMN_256_0[4]/RM_IHPSG13_1P_BITKIT_16x2_SRAM_0[0]/A_BLC_BOT<1> RM_IHPSG13_1P_COLUMN_256_0[4]/RM_IHPSG13_1P_BITKIT_16x2_SRAM_3[1]/A_LWL<12>
+ RM_IHPSG13_1P_COLUMN_256_0[4]/RM_IHPSG13_1P_BITKIT_16x2_SRAM_1[3]/A_RWL<8> RM_IHPSG13_1P_COLUMN_256_0[4]/RM_IHPSG13_1P_BITKIT_16x2_SRAM_0[3]/A_RWL<9>
+ RM_IHPSG13_1P_COLUMN_256_0[4]/RM_IHPSG13_1P_BITKIT_16x2_SRAM_0[3]/A_LWL<4> RM_IHPSG13_1P_COLUMN_256_0[4]/RM_IHPSG13_1P_BITKIT_16x2_SRAM_3[2]/A_LWL<9>
+ RM_IHPSG13_1P_COLUMN_256_0[4]/RM_IHPSG13_1P_BITKIT_16x2_SRAM_2[3]/A_LWL<1> RM_IHPSG13_1P_COLUMN_256_0[4]/RM_IHPSG13_1P_BITKIT_16x2_SRAM_0[3]/A_RWL<14>
+ RM_IHPSG13_1P_COLUMN_256_0[4]/RM_IHPSG13_1P_BITKIT_16x2_SRAM_0[2]/A_RWL<14> RM_IHPSG13_1P_COLUMN_256_0[4]/RM_IHPSG13_1P_BITKIT_16x2_SRAM_2[0]/A_LWL<11>
+ RM_IHPSG13_1P_COLUMN_256_0[4]/RM_IHPSG13_1P_BITKIT_16x2_SRAM_2[3]/A_LWL<4> RM_IHPSG13_1P_COLUMN_256_0[4]/RM_IHPSG13_1P_BITKIT_16x2_SRAM_3[2]/A_LWL<12>
+ RM_IHPSG13_1P_COLUMN_256_0[4]/RM_IHPSG13_1P_BITKIT_16x2_SRAM_1[2]/A_LWL<9> RM_IHPSG13_1P_COLUMN_256_0[4]/RM_IHPSG13_1P_BITKIT_16x2_SRAM_3[3]/A_RWL<9>
+ RM_IHPSG13_1P_COLUMN_256_0[4]/RM_IHPSG13_1P_BITKIT_16x2_SRAM_1[3]/A_LWL<2> RM_IHPSG13_1P_COLUMN_256_0[4]/RM_IHPSG13_1P_BITKIT_16x2_SRAM_0[3]/A_LWL<1>
+ RM_IHPSG13_1P_COLUMN_256_0[4]/RM_IHPSG13_1P_BITKIT_16x2_SRAM_2[3]/A_RWL<7> RM_IHPSG13_1P_COLUMN_256_0[4]/RM_IHPSG13_1P_BITKIT_16x2_SRAM_0[0]/A_RWL<0>
+ RM_IHPSG13_1P_COLUMN_256_0[4]/RM_IHPSG13_1P_BITKIT_16x2_SRAM_2[0]/A_RWL<1> RM_IHPSG13_1P_COLUMN_256_0[4]/RM_IHPSG13_1P_BITKIT_16x2_SRAM_0[2]/A_RWL<13>
+ RM_IHPSG13_1P_COLUMN_256_0[4]/RM_IHPSG13_1P_BITKIT_16x2_SRAM_2[3]/A_RWL<5> RM_IHPSG13_1P_COLUMN_256_0[4]/RM_IHPSG13_1P_BITKIT_16x2_SRAM_2[3]/A_LWL<3>
+ RM_IHPSG13_1P_COLUMN_256_0[4]/RM_IHPSG13_1P_BITKIT_16x2_SRAM_3[0]/A_RWL<13> RM_IHPSG13_1P_COLUMN_256_0[4]/RM_IHPSG13_1P_BITKIT_16x2_SRAM_1[0]/A_RWL<3>
+ RM_IHPSG13_1P_COLUMN_256_0[4]/RM_IHPSG13_1P_BITKIT_16x2_SRAM_3[1]/A_LWL<15> RM_IHPSG13_1P_COLUMN_256_0[4]/RM_IHPSG13_1P_BITKIT_16x2_SRAM_2[0]/A_LWL<14>
+ RM_IHPSG13_1P_COLUMN_256_0[4]/RM_IHPSG13_1P_BITKIT_16x2_SRAM_0[3]/A_RWL<7> RM_IHPSG13_1P_COLUMN_256_0[4]/RM_IHPSG13_1P_BITKIT_16x2_SRAM_3[0]/A_RWL<0>
+ RM_IHPSG13_1P_COLUMN_256_0[4]/RM_IHPSG13_1P_BITKIT_16x2_SRAM_3[2]/A_LWL<15> RM_IHPSG13_1P_COLUMN_256_0[4]/RM_IHPSG13_1P_BITKIT_16x2_SRAM_3[3]/A_RWL<4>
+ RM_IHPSG13_1P_COLUMN_256_0[4]/RM_IHPSG13_1P_BITKIT_16x2_SRAM_3[2]/A_LWL<7> RM_IHPSG13_1P_COLUMN_256_0[4]/RM_IHPSG13_1P_BITKIT_16x2_SRAM_0[0]/A_LWL<0>
+ RM_IHPSG13_1P_COLUMN_256_0[4]/RM_IHPSG13_1P_BITKIT_16x2_SRAM_1[3]/A_LWL<9> RM_IHPSG13_1P_COLUMN_256_0[4]/RM_IHPSG13_1P_BITKIT_16x2_SRAM_3[0]/A_RWL<3>
+ RM_IHPSG13_1P_COLUMN_256_0[4]/RM_IHPSG13_1P_BITKIT_16x2_SRAM_0[0]/A_RWL<5> RM_IHPSG13_1P_COLUMN_256_0[4]/RM_IHPSG13_1P_BITKIT_16x2_SRAM_0[3]/A_RWL<13>
+ RM_IHPSG13_1P_COLUMN_256_0[4]/RM_IHPSG13_1P_BITKIT_16x2_SRAM_2[3]/A_LWL<8> RM_IHPSG13_1P_COLUMN_256_0[4]/RM_IHPSG13_1P_BITKIT_16x2_SRAM_0[3]/A_LWL<7>
+ RM_IHPSG13_1P_COLUMN_256_0[4]/RM_IHPSG13_1P_BITKIT_16x2_SRAM_3[0]/A_LWL<15> RM_IHPSG13_1P_COLUMN_256_0[4]/RM_IHPSG13_1P_BITKIT_16x2_SRAM_3[3]/A_LWL<13>
+ RM_IHPSG13_1P_COLUMN_256_0[4]/RM_IHPSG13_1P_BITKIT_16x2_SRAM_2[3]/A_LWL<6> RM_IHPSG13_1P_COLUMN_256_0[4]/RM_IHPSG13_1P_BITKIT_16x2_SRAM_2[1]/A_LWL<10>
+ RM_IHPSG13_1P_COLUMN_256_0[4]/RM_IHPSG13_1P_BITKIT_16x2_SRAM_3[3]/A_LWL<0> RM_IHPSG13_1P_COLUMN_256_0[4]/RM_IHPSG13_1P_BITKIT_16x2_SRAM_3[0]/A_RWL<4>
+ RM_IHPSG13_1P_COLUMN_256_0[4]/RM_IHPSG13_1P_BITKIT_16x2_SRAM_2[2]/A_LWL<10> RM_IHPSG13_1P_COLUMN_256_0[4]/RM_IHPSG13_1P_BITKIT_16x2_SRAM_3[1]/A_RWL<13>
+ RM_IHPSG13_1P_COLUMN_256_0[4]/RM_IHPSG13_1P_BITKIT_16x2_SRAM_1[0]/A_RWL<6> RM_IHPSG13_1P_COLUMN_256_0[4]/RM_IHPSG13_1P_BITKIT_16x2_SRAM_3[3]/A_LWL<9>
+ RM_IHPSG13_1P_COLUMN_256_0[4]/RM_IHPSG13_1P_BITKIT_16x2_SRAM_1[0]/A_RWL<4> RM_IHPSG13_1P_COLUMN_256_0[4]/RM_IHPSG13_1P_BITKIT_16x2_SRAM_0[3]/A_RWL<10>
+ RM_IHPSG13_1P_COLUMN_256_0[4]/RM_IHPSG13_1P_BITKIT_16x2_SRAM_2[1]/A_LWL<14> RM_IHPSG13_1P_COLUMN_256_0[4]/RM_IHPSG13_1P_BITKIT_16x2_SRAM_3[0]/A_RWL<5>
+ RM_IHPSG13_1P_COLUMN_256_0[4]/RM_IHPSG13_1P_BITKIT_16x2_SRAM_0[3]/A_LWL<8> RM_IHPSG13_1P_COLUMN_256_0[4]/RM_IHPSG13_1P_BITKIT_16x2_SRAM_3[3]/A_LWL<7>
+ RM_IHPSG13_1P_COLUMN_256_0[4]/RM_IHPSG13_1P_BITKIT_16x2_SRAM_2[2]/A_LWL<8> RM_IHPSG13_1P_COLUMN_256_0[4]/RM_IHPSG13_1P_BITKIT_16x2_SRAM_3[3]/A_LWL<15>
+ RM_IHPSG13_1P_COLUMN_256_0[4]/RM_IHPSG13_1P_BITKIT_16x2_SRAM_3[2]/A_LWL<13> RM_IHPSG13_1P_COLUMN_256_0[4]/RM_IHPSG13_1P_BITKIT_16x2_SRAM_2[0]/A_LWL<1>
+ RM_IHPSG13_1P_COLUMN_256_0[4]/RM_IHPSG13_1P_BITKIT_16x2_SRAM_0[0]/A_LWL<1> RM_IHPSG13_1P_COLUMN_256_0[4]/RM_IHPSG13_1P_BITKIT_16x2_SRAM_1[3]/A_LWL<0>
+ RM_IHPSG13_1P_COLUMN_256_0[4]/RM_IHPSG13_1P_BITKIT_16x2_SRAM_2[0]/A_LWL<10> RM_IHPSG13_1P_COLUMN_256_0[4]/RM_IHPSG13_1P_BITKIT_16x2_SRAM_3[3]/A_LWL<11>
+ RM_IHPSG13_1P_COLUMN_256_0[4]/RM_IHPSG13_1P_BITKIT_16x2_SRAM_0[0]/A_LWL<3> RM_IHPSG13_1P_COLUMN_256_0[4]/RM_IHPSG13_1P_BITKIT_16x2_SRAM_3[0]/A_RWL<6>
+ RM_IHPSG13_1P_COLUMN_256_0[4]/RM_IHPSG13_1P_BITKIT_16x2_SRAM_2[3]/A_LWL<5> RM_IHPSG13_1P_COLUMN_256_0[4]/RM_IHPSG13_1P_BITKIT_16x2_SRAM_2[0]/A_RWL<7>
+ RM_IHPSG13_1P_COLUMN_256_0[4]/RM_IHPSG13_1P_BITKIT_16x2_SRAM_3[1]/A_RWL<15> RM_IHPSG13_1P_COLUMN_256_0[4]/RM_IHPSG13_1P_BITKIT_16x2_SRAM_0[1]/A_RWL<0>
+ RM_IHPSG13_1P_COLUMN_256_0[4]/RM_IHPSG13_1P_BITKIT_16x2_SRAM_3[0]/A_RWL<2> RM_IHPSG13_1P_COLUMN_256_0[4]/RM_IHPSG13_1P_BITKIT_16x2_SRAM_2[0]/A_RWL<11>
+ RM_IHPSG13_1P_COLUMN_256_0[4]/RM_IHPSG13_1P_BITKIT_16x2_SRAM_2[0]/A_LWL<2> RM_IHPSG13_1P_COLUMN_256_0[4]/RM_IHPSG13_1P_BITKIT_16x2_SRAM_3[0]/A_RWL<15>
+ RM_IHPSG13_1P_COLUMN_256_0[4]/RM_IHPSG13_1P_BITKIT_16x2_SRAM_0[0]/A_LWL<4> RM_IHPSG13_1P_COLUMN_256_0[4]/RM_IHPSG13_1P_BITKIT_16x2_SRAM_1[0]/A_LWL<12>
+ RM_IHPSG13_1P_COLUMN_256_0[4]/RM_IHPSG13_1P_BITKIT_16x2_SRAM_2[0]/A_RWL<8> RM_IHPSG13_1P_COLUMN_256_0[4]/RM_IHPSG13_1P_BITKIT_16x2_SRAM_1[0]/A_RWL<9>
+ RM_IHPSG13_1P_COLUMN_256_0[4]/RM_IHPSG13_1P_BITKIT_16x2_SRAM_3[1]/A_LWL<13> RM_IHPSG13_1P_COLUMN_256_0[4]/RM_IHPSG13_1P_BITKIT_16x2_SRAM_1[3]/A_RWL<9>
+ RM_IHPSG13_1P_COLUMN_256_0[4]/RM_IHPSG13_1P_BITKIT_16x2_SRAM_2[3]/A_LWL<10> RM_IHPSG13_1P_COLUMN_256_0[4]/RM_IHPSG13_1P_BITKIT_16x2_SRAM_3[2]/A_RWL<13>
+ RM_IHPSG13_1P_COLUMN_256_0[4]/RM_IHPSG13_1P_BITKIT_16x2_SRAM_3[2]/A_LWL<11> RM_IHPSG13_1P_COLUMN_256_0[4]/RM_IHPSG13_1P_BITKIT_16x2_SRAM_0[0]/A_RWL<7>
+ RM_IHPSG13_1P_COLUMN_256_0[4]/RM_IHPSG13_1P_BITKIT_16x2_SRAM_0[3]/A_LWL<5> RM_IHPSG13_1P_COLUMN_256_0[4]/RM_IHPSG13_1P_BITKIT_16x2_SRAM_1[0]/A_RWL<2>
+ RM_IHPSG13_1P_COLUMN_256_0[4]/RM_IHPSG13_1P_BITKIT_16x2_SRAM_2[2]/A_LWL<14> RM_IHPSG13_1P_COLUMN_256_0[4]/RM_IHPSG13_1P_BITKIT_16x2_SRAM_3[0]/A_LWL<3>
+ RM_IHPSG13_1P_COLUMN_256_0[4]/RM_IHPSG13_1P_BITKIT_16x2_SRAM_2[0]/A_LWL<4> RM_IHPSG13_1P_COLUMN_256_0[4]/RM_IHPSG13_1P_BITKIT_16x2_SRAM_3[3]/A_LWL<14>
+ RM_IHPSG13_1P_COLUMN_256_0[4]/RM_IHPSG13_1P_BITKIT_16x2_SRAM_2[1]/A_RWL<10> RM_IHPSG13_1P_COLUMN_256_0[4]/RM_IHPSG13_1P_BITKIT_16x2_SRAM_1[0]/A_LWL<5>
+ RM_IHPSG13_1P_COLUMN_256_0[4]/RM_IHPSG13_1P_BITKIT_16x2_SRAM_3[1]/A_RWL<0> RM_IHPSG13_1P_COLUMN_256_0[4]/RM_IHPSG13_1P_BITKIT_16x2_SRAM_2[0]/A_RWL<10>
+ RM_IHPSG13_1P_COLUMN_256_0[4]/RM_IHPSG13_1P_BITKIT_16x2_SRAM_2[0]/A_RWL<12> RM_IHPSG13_1P_COLUMN_256_0[4]/RM_IHPSG13_1P_BITKIT_16x2_SRAM_3[3]/A_RWL<11>
+ RM_IHPSG13_1P_COLUMN_256_0[4]/RM_IHPSG13_1P_BITKIT_16x2_SRAM_0[0]/A_LWL<6> RM_IHPSG13_1P_COLUMN_256_0[4]/RM_IHPSG13_1P_BITKIT_16x2_SRAM_2[1]/A_RWL<1>
+ RM_IHPSG13_1P_COLUMN_256_0[4]/RM_IHPSG13_1P_BITKIT_16x2_SRAM_2[3]/A_RWL<8> RM_IHPSG13_1P_COLUMN_256_0[4]/RM_IHPSG13_1P_BITKIT_16x2_SRAM_1[1]/A_RWL<2>
+ RM_IHPSG13_1P_COLUMN_256_0[4]/RM_IHPSG13_1P_BITKIT_16x2_SRAM_2[0]/A_RWL<14> RM_IHPSG13_1P_COLUMN_256_0[4]/RM_IHPSG13_1P_BITKIT_16x2_SRAM_3[0]/A_LWL<13>
+ RM_IHPSG13_1P_COLUMN_256_0[4]/RM_IHPSG13_1P_BITKIT_16x2_SRAM_3[2]/A_RWL<15> RM_IHPSG13_1P_COLUMN_256_0[4]/RM_IHPSG13_1P_BITKIT_16x2_SRAM_2[1]/A_RWL<11>
+ RM_IHPSG13_1P_COLUMN_256_0[4]/RM_IHPSG13_1P_BITKIT_16x2_SRAM_3[1]/A_LWL<11> RM_IHPSG13_1P_COLUMN_256_0[4]/RM_IHPSG13_1P_BITKIT_16x2_SRAM_3[0]/A_LWL<0>
+ RM_IHPSG13_1P_COLUMN_256_0[4]/RM_IHPSG13_1P_BITKIT_16x2_SRAM_3[3]/A_RWL<12> RM_IHPSG13_1P_COLUMN_256_0[4]/RM_IHPSG13_1P_BITKIT_16x2_SRAM_0[0]/A_LWL<7>
+ RM_IHPSG13_1P_COLUMN_256_0[4]/RM_IHPSG13_1P_BITKIT_16x2_SRAM_1[0]/A_LWL<15> RM_IHPSG13_1P_COLUMN_256_0[4]/RM_IHPSG13_1P_BITKIT_16x2_SRAM_1[1]/A_RWL<3>
+ RM_IHPSG13_1P_COLUMN_256_0[4]/RM_IHPSG13_1P_BITKIT_16x2_SRAM_1[1]/A_LWL<12> RM_IHPSG13_1P_COLUMN_256_0[4]/RM_IHPSG13_1P_BITKIT_16x2_SRAM_0[1]/A_RWL<4>
+ RM_IHPSG13_1P_COLUMN_256_0[4]/RM_IHPSG13_1P_BITKIT_16x2_SRAM_3[0]/A_LWL<5> RM_IHPSG13_1P_COLUMN_256_0[4]/RM_IHPSG13_1P_BITKIT_16x2_SRAM_2[0]/A_LWL<6>
+ RM_IHPSG13_1P_COLUMN_256_0[4]/RM_IHPSG13_1P_BITKIT_16x2_SRAM_3[2]/A_LWL<14> RM_IHPSG13_1P_COLUMN_256_0[4]/RM_IHPSG13_1P_BITKIT_16x2_SRAM_1[0]/A_LWL<7>
+ RM_IHPSG13_1P_COLUMN_256_0[4]/RM_IHPSG13_1P_BITKIT_16x2_SRAM_3[1]/A_RWL<2> RM_IHPSG13_1P_COLUMN_256_0[4]/RM_IHPSG13_1P_BITKIT_16x2_SRAM_3[2]/A_RWL<11>
+ RM_IHPSG13_1P_COLUMN_256_0[4]/RM_IHPSG13_1P_BITKIT_16x2_SRAM_3[3]/A_RWL<13> RM_IHPSG13_1P_COLUMN_256_0[4]/RM_IHPSG13_1P_BITKIT_16x2_SRAM_0[0]/A_LWL<8>
+ RM_IHPSG13_1P_COLUMN_256_0[4]/RM_IHPSG13_1P_BITKIT_16x2_SRAM_2[3]/A_RWL<6> RM_IHPSG13_1P_COLUMN_256_0[4]/RM_IHPSG13_1P_BITKIT_16x2_SRAM_1[1]/A_RWL<4>
+ RM_IHPSG13_1P_COLUMN_256_0[4]/RM_IHPSG13_1P_BITKIT_16x2_SRAM_0[0]/A_RWL<1> RM_IHPSG13_1P_COLUMN_256_0[4]/RM_IHPSG13_1P_BITKIT_16x2_SRAM_1[1]/A_LWL<13>
+ RM_IHPSG13_1P_COLUMN_256_0[4]/RM_IHPSG13_1P_BITKIT_16x2_SRAM_1[0]/A_LWL<13> RM_IHPSG13_1P_COLUMN_256_0[4]/RM_IHPSG13_1P_BITKIT_16x2_SRAM_0[1]/A_RWL<5>
+ RM_IHPSG13_1P_COLUMN_256_0[4]/RM_IHPSG13_1P_BITKIT_16x2_SRAM_3[0]/A_LWL<6> RM_IHPSG13_1P_COLUMN_256_0[4]/RM_IHPSG13_1P_BITKIT_16x2_SRAM_2[3]/A_LWL<12>
+ RM_IHPSG13_1P_COLUMN_256_0[4]/RM_IHPSG13_1P_BITKIT_16x2_SRAM_1[1]/A_LWL<11> RM_IHPSG13_1P_COLUMN_256_0[4]/RM_IHPSG13_1P_BITKIT_16x2_SRAM_0[0]/A_RWL<8>
+ RM_IHPSG13_1P_COLUMN_256_0[4]/RM_IHPSG13_1P_BITKIT_16x2_SRAM_1[0]/A_LWL<0> RM_IHPSG13_1P_COLUMN_256_0[4]/RM_IHPSG13_1P_BITKIT_16x2_SRAM_0[3]/A_LWL<3>
+ RM_IHPSG13_1P_COLUMN_256_0[4]/RM_IHPSG13_1P_BITKIT_16x2_SRAM_2[1]/A_RWL<12> RM_IHPSG13_1P_COLUMN_256_0[4]/RM_IHPSG13_1P_BITKIT_16x2_SRAM_2[0]/A_RWL<9>
+ RM_IHPSG13_1P_COLUMN_256_0[4]/RM_IHPSG13_1P_BITKIT_16x2_SRAM_3[1]/A_RWL<3> RM_IHPSG13_1P_COLUMN_256_0[4]/RM_IHPSG13_1P_BITKIT_16x2_SRAM_2[3]/A_LWL<2>
+ RM_IHPSG13_1P_COLUMN_256_0[4]/RM_IHPSG13_1P_BITKIT_16x2_SRAM_3[3]/A_RWL<14> RM_IHPSG13_1P_COLUMN_256_0[4]/RM_IHPSG13_1P_BITKIT_16x2_SRAM_2[2]/A_RWL<10>
+ RM_IHPSG13_1P_COLUMN_256_0[4]/RM_IHPSG13_1P_BITKIT_16x2_SRAM_2[0]/A_LWL<5> RM_IHPSG13_1P_COLUMN_256_0[4]/RM_IHPSG13_1P_BITKIT_16x2_SRAM_3[3]/A_LWL<4>
+ RM_IHPSG13_1P_COLUMN_256_0[4]/RM_IHPSG13_1P_BITKIT_16x2_SRAM_2[1]/A_RWL<3> RM_IHPSG13_1P_COLUMN_256_0[4]/RM_IHPSG13_1P_BITKIT_16x2_SRAM_3[0]/A_LWL<7>
+ RM_IHPSG13_1P_COLUMN_256_0[4]/RM_IHPSG13_1P_BITKIT_16x2_SRAM_0[0]/A_LWL<10> RM_IHPSG13_1P_COLUMN_256_0[4]/RM_IHPSG13_1P_BITKIT_16x2_SRAM_1[1]/A_LWL<0>
+ RM_IHPSG13_1P_COLUMN_256_0[4]/RM_IHPSG13_1P_BITKIT_16x2_SRAM_2[0]/A_LWL<8> RM_IHPSG13_1P_COLUMN_256_0[4]/RM_IHPSG13_1P_BITKIT_16x2_SRAM_3[1]/A_LWL<14>
+ RM_IHPSG13_1P_COLUMN_256_0[4]/RM_IHPSG13_1P_BITKIT_16x2_SRAM_1[2]/A_LWL<11> RM_IHPSG13_1P_COLUMN_256_0[4]/RM_IHPSG13_1P_BITKIT_16x2_SRAM_2[1]/A_RWL<14>
+ RM_IHPSG13_1P_COLUMN_256_0[4]/RM_IHPSG13_1P_BITKIT_16x2_SRAM_0[1]/A_LWL<1> RM_IHPSG13_1P_COLUMN_256_0[4]/RM_IHPSG13_1P_BITKIT_16x2_SRAM_1[0]/A_LWL<9>
+ RM_IHPSG13_1P_COLUMN_256_0[4]/RM_IHPSG13_1P_BITKIT_16x2_SRAM_3[1]/A_RWL<4> RM_IHPSG13_1P_COLUMN_256_0[4]/RM_IHPSG13_1P_BITKIT_16x2_SRAM_1[0]/A_RWL<0>
+ RM_IHPSG13_1P_COLUMN_256_0[4]/RM_IHPSG13_1P_BITKIT_16x2_SRAM_3[1]/A_RWL<11> RM_IHPSG13_1P_COLUMN_256_0[4]/RM_IHPSG13_1P_BITKIT_16x2_SRAM_3[3]/A_RWL<15>
+ RM_IHPSG13_1P_COLUMN_256_0[4]/RM_IHPSG13_1P_BITKIT_16x2_SRAM_0[3]/A_RWL<6> RM_IHPSG13_1P_COLUMN_256_0[4]/RM_IHPSG13_1P_BITKIT_16x2_SRAM_2[1]/A_RWL<5>
+ RM_IHPSG13_1P_COLUMN_256_0[4]/RM_IHPSG13_1P_BITKIT_16x2_SRAM_2[2]/A_RWL<11> RM_IHPSG13_1P_COLUMN_256_0[4]/RM_IHPSG13_1P_BITKIT_16x2_SRAM_3[0]/A_RWL<1>
+ RM_IHPSG13_1P_COLUMN_256_0[4]/RM_IHPSG13_1P_BITKIT_16x2_SRAM_3[3]/A_RWL<5> RM_IHPSG13_1P_COLUMN_256_0[4]/RM_IHPSG13_1P_BITKIT_16x2_SRAM_1[1]/A_RWL<6>
+ RM_IHPSG13_1P_COLUMN_256_0[4]/RM_IHPSG13_1P_BITKIT_16x2_SRAM_3[0]/A_RWL<8> RM_IHPSG13_1P_COLUMN_256_0[4]/RM_IHPSG13_1P_BITKIT_16x2_SRAM_1[1]/A_LWL<15>
+ RM_IHPSG13_1P_COLUMN_256_0[4]/RM_IHPSG13_1P_BITKIT_16x2_SRAM_0[1]/A_RWL<7> RM_IHPSG13_1P_COLUMN_256_0[4]/RM_IHPSG13_1P_BITKIT_16x2_SRAM_3[3]/A_LWL<3>
+ RM_IHPSG13_1P_COLUMN_256_0[4]/RM_IHPSG13_1P_BITKIT_16x2_SRAM_0[0]/A_LWL<11> RM_IHPSG13_1P_COLUMN_256_0[4]/RM_IHPSG13_1P_BITKIT_16x2_SRAM_2[2]/A_LWL<12>
+ RM_IHPSG13_1P_COLUMN_256_0[4]/RM_IHPSG13_1P_BITKIT_16x2_SRAM_1[0]/A_LWL<11> RM_IHPSG13_1P_COLUMN_256_0[4]/RM_IHPSG13_1P_BITKIT_16x2_SRAM_1[2]/A_LWL<12>
+ RM_IHPSG13_1P_COLUMN_256_0[4]/RM_IHPSG13_1P_BITKIT_16x2_SRAM_3[2]/A_RWL<14> RM_IHPSG13_1P_COLUMN_256_0[4]/RM_IHPSG13_1P_BITKIT_16x2_SRAM_3[1]/A_RWL<5>
+ RM_IHPSG13_1P_COLUMN_256_0[4]/RM_IHPSG13_1P_BITKIT_16x2_SRAM_0[0]/A_LWL<5> RM_IHPSG13_1P_COLUMN_256_0[4]/RM_IHPSG13_1P_BITKIT_16x2_SRAM_1[3]/A_LWL<4>
+ RM_IHPSG13_1P_COLUMN_256_0[4]/RM_IHPSG13_1P_BITKIT_16x2_SRAM_0[1]/A_RWL<1> RM_IHPSG13_1P_COLUMN_256_0[4]/RM_IHPSG13_1P_BITKIT_16x2_SRAM_0[1]/A_RWL<3>
+ RM_IHPSG13_1P_COLUMN_256_0[4]/RM_IHPSG13_1P_BITKIT_16x2_SRAM_3[1]/A_LWL<0> RM_IHPSG13_1P_COLUMN_256_0[4]/RM_IHPSG13_1P_BITKIT_16x2_SRAM_2[0]/A_RWL<3>
+ RM_IHPSG13_1P_COLUMN_256_0[4]/RM_IHPSG13_1P_BITKIT_16x2_SRAM_2[3]/A_LWL<9> RM_IHPSG13_1P_COLUMN_256_0[4]/RM_IHPSG13_1P_BITKIT_16x2_SRAM_2[1]/A_LWL<1>
+ RM_IHPSG13_1P_COLUMN_256_0[4]/RM_IHPSG13_1P_BITKIT_16x2_SRAM_3[0]/A_LWL<9> RM_IHPSG13_1P_COLUMN_256_0[4]/RM_IHPSG13_1P_BITKIT_16x2_SRAM_0[1]/A_RWL<8>
+ RM_IHPSG13_1P_COLUMN_256_0[4]/RM_IHPSG13_1P_BITKIT_16x2_SRAM_1[1]/A_LWL<14> RM_IHPSG13_1P_COLUMN_256_0[4]/RM_IHPSG13_1P_BITKIT_16x2_SRAM_0[0]/A_LWL<2>
+ RM_IHPSG13_1P_COLUMN_256_0[4]/RM_IHPSG13_1P_BITKIT_16x2_SRAM_2[2]/A_RWL<12> RM_IHPSG13_1P_COLUMN_256_0[4]/RM_IHPSG13_1P_BITKIT_16x2_SRAM_1[1]/A_LWL<2>
+ RM_IHPSG13_1P_COLUMN_256_0[4]/RM_IHPSG13_1P_BITKIT_16x2_SRAM_0[3]/A_LWL<6> RM_IHPSG13_1P_COLUMN_256_0[4]/RM_IHPSG13_1P_BITKIT_16x2_SRAM_3[0]/A_LWL<14>
+ RM_IHPSG13_1P_COLUMN_256_0[4]/RM_IHPSG13_1P_BITKIT_16x2_SRAM_1[2]/A_LWL<13> RM_IHPSG13_1P_COLUMN_256_0[4]/RM_IHPSG13_1P_BITKIT_16x2_SRAM_0[1]/A_LWL<3>
+ RM_IHPSG13_1P_COLUMN_256_0[4]/RM_IHPSG13_1P_BITKIT_16x2_SRAM_1[0]/A_RWL<12> RM_IHPSG13_1P_COLUMN_256_0[4]/RM_IHPSG13_1P_BITKIT_16x2_SRAM_3[1]/A_RWL<6>
+ RM_IHPSG13_1P_COLUMN_256_0[4]/RM_IHPSG13_1P_BITKIT_16x2_SRAM_3[0]/A_RWL<11> RM_IHPSG13_1P_COLUMN_256_0[4]/RM_IHPSG13_1P_BITKIT_16x2_SRAM_3[3]/A_LWL<1>
+ RM_IHPSG13_1P_COLUMN_256_0[4]/RM_IHPSG13_1P_BITKIT_16x2_SRAM_2[1]/A_RWL<7> RM_IHPSG13_1P_COLUMN_256_0[4]/RM_IHPSG13_1P_BITKIT_16x2_SRAM_2[1]/A_RWL<6>
+ RM_IHPSG13_1P_COLUMN_256_0[4]/RM_IHPSG13_1P_BITKIT_16x2_SRAM_0[2]/A_RWL<0> RM_IHPSG13_1P_COLUMN_256_0[4]/RM_IHPSG13_1P_BITKIT_16x2_SRAM_2[3]/A_RWL<10>
+ RM_IHPSG13_1P_COLUMN_256_0[4]/RM_IHPSG13_1P_BITKIT_16x2_SRAM_2[1]/A_LWL<2> RM_IHPSG13_1P_COLUMN_256_0[4]/RM_IHPSG13_1P_BITKIT_16x2_SRAM_0[0]/A_LWL<13>
+ RM_IHPSG13_1P_COLUMN_256_0[4]/RM_IHPSG13_1P_BITKIT_16x2_SRAM_2[1]/A_LWL<12> RM_IHPSG13_1P_COLUMN_256_0[4]/RM_IHPSG13_1P_BITKIT_16x2_SRAM_1[1]/A_RWL<0>
+ RM_IHPSG13_1P_COLUMN_256_0[4]/RM_IHPSG13_1P_BITKIT_16x2_SRAM_1[2]/A_LWL<14> RM_IHPSG13_1P_COLUMN_256_0[4]/RM_IHPSG13_1P_BITKIT_16x2_SRAM_1[0]/A_RWL<5>
+ RM_IHPSG13_1P_COLUMN_256_0[4]/RM_IHPSG13_1P_BITKIT_16x2_SRAM_0[1]/A_LWL<10> RM_IHPSG13_1P_COLUMN_256_0[4]/RM_IHPSG13_1P_BITKIT_16x2_SRAM_0[1]/A_LWL<4>
+ RM_IHPSG13_1P_COLUMN_256_0[4]/RM_IHPSG13_1P_BITKIT_16x2_SRAM_3[1]/A_RWL<14> RM_IHPSG13_1P_COLUMN_256_0[4]/RM_IHPSG13_1P_BITKIT_16x2_SRAM_3[1]/A_RWL<1>
+ RM_IHPSG13_1P_COLUMN_256_0[4]/RM_IHPSG13_1P_BITKIT_16x2_SRAM_1[0]/A_RWL<13> RM_IHPSG13_1P_COLUMN_256_0[4]/RM_IHPSG13_1P_BITKIT_16x2_SRAM_1[3]/A_LWL<11>
+ RM_IHPSG13_1P_COLUMN_256_0[4]/RM_IHPSG13_1P_BITKIT_16x2_SRAM_2[1]/A_RWL<8> RM_IHPSG13_1P_COLUMN_256_0[4]/RM_IHPSG13_1P_BITKIT_16x2_SRAM_1[0]/A_LWL<3>
+ RM_IHPSG13_1P_COLUMN_256_0[4]/RM_IHPSG13_1P_BITKIT_16x2_SRAM_2[2]/A_RWL<14> RM_IHPSG13_1P_COLUMN_256_0[4]/RM_IHPSG13_1P_BITKIT_16x2_SRAM_1[3]/A_LWL<7>
+ RM_IHPSG13_1P_COLUMN_256_0[4]/RM_IHPSG13_1P_BITKIT_16x2_SRAM_0[0]/A_RWL<3> RM_IHPSG13_1P_COLUMN_256_0[4]/RM_IHPSG13_1P_BITKIT_16x2_SRAM_0[3]/A_LWL<9>
+ RM_IHPSG13_1P_COLUMN_256_0[4]/RM_IHPSG13_1P_BITKIT_16x2_SRAM_3[0]/A_LWL<2> RM_IHPSG13_1P_COLUMN_256_0[4]/RM_IHPSG13_1P_BITKIT_16x2_SRAM_1[1]/A_RWL<9>
+ RM_IHPSG13_1P_COLUMN_256_0[4]/RM_IHPSG13_1P_BITKIT_16x2_SRAM_3[3]/A_LWL<6> RM_IHPSG13_1P_COLUMN_256_0[4]/RM_IHPSG13_1P_BITKIT_16x2_SRAM_2[2]/A_LWL<9>
+ RM_IHPSG13_1P_COLUMN_256_0[4]/RM_IHPSG13_1P_BITKIT_16x2_SRAM_2[1]/A_LWL<3> RM_IHPSG13_1P_COLUMN_256_0[4]/RM_IHPSG13_1P_BITKIT_16x2_SRAM_0[0]/A_LWL<14>
+ RM_IHPSG13_1P_COLUMN_256_0[4]/RM_IHPSG13_1P_BITKIT_16x2_SRAM_1[0]/A_LWL<14> RM_IHPSG13_1P_COLUMN_256_0[4]/RM_IHPSG13_1P_BITKIT_16x2_SRAM_2[3]/A_LWL<15>
+ RM_IHPSG13_1P_COLUMN_256_0[4]/RM_IHPSG13_1P_BITKIT_16x2_SRAM_1[2]/A_LWL<15> RM_IHPSG13_1P_COLUMN_256_0[4]/RM_IHPSG13_1P_BITKIT_16x2_SRAM_0[1]/A_LWL<11>
+ RM_IHPSG13_1P_COLUMN_256_0[4]/RM_IHPSG13_1P_BITKIT_16x2_SRAM_0[1]/A_LWL<5> RM_IHPSG13_1P_COLUMN_256_0[4]/RM_IHPSG13_1P_BITKIT_16x2_SRAM_1[0]/A_RWL<11>
+ RM_IHPSG13_1P_COLUMN_256_0[4]/RM_IHPSG13_1P_BITKIT_16x2_SRAM_2[2]/A_RWL<0> RM_IHPSG13_1P_COLUMN_256_0[4]/RM_IHPSG13_1P_BITKIT_16x2_SRAM_1[3]/A_LWL<1>
+ RM_IHPSG13_1P_COLUMN_256_0[4]/RM_IHPSG13_1P_BITKIT_16x2_SRAM_3[1]/A_RWL<8> RM_IHPSG13_1P_COLUMN_256_0[4]/RM_IHPSG13_1P_BITKIT_16x2_SRAM_0[2]/A_RWL<1>
+ RM_IHPSG13_1P_COLUMN_256_0[4]/RM_IHPSG13_1P_BITKIT_16x2_SRAM_3[3]/A_LWL<10> RM_IHPSG13_1P_COLUMN_256_0[4]/RM_IHPSG13_1P_BITKIT_16x2_SRAM_1[3]/A_LWL<12>
+ RM_IHPSG13_1P_COLUMN_256_0[4]/RM_IHPSG13_1P_BITKIT_16x2_SRAM_1[2]/A_RWL<1> RM_IHPSG13_1P_COLUMN_256_0[4]/RM_IHPSG13_1P_BITKIT_16x2_SRAM_0[1]/A_RWL<6>
+ RM_IHPSG13_1P_COLUMN_256_0[4]/RM_IHPSG13_1P_BITKIT_16x2_SRAM_2[1]/A_RWL<9> RM_IHPSG13_1P_COLUMN_256_0[4]/RM_IHPSG13_1P_BITKIT_16x2_SRAM_1[1]/A_RWL<11>
+ RM_IHPSG13_1P_COLUMN_256_0[4]/RM_IHPSG13_1P_BITKIT_16x2_SRAM_2[0]/A_RWL<6> RM_IHPSG13_1P_COLUMN_256_0[4]/RM_IHPSG13_1P_BITKIT_16x2_SRAM_3[1]/A_LWL<3>
+ RM_IHPSG13_1P_COLUMN_256_0[4]/RM_IHPSG13_1P_BITKIT_16x2_SRAM_2[0]/A_RWL<4> RM_IHPSG13_1P_COLUMN_256_0[4]/RM_IHPSG13_1P_BITKIT_16x2_SRAM_3[3]/A_RWL<7>
+ RM_IHPSG13_1P_COLUMN_256_0[4]/RM_IHPSG13_1P_BITKIT_16x2_SRAM_0[1]/A_LWL<2> RM_IHPSG13_1P_COLUMN_256_0[4]/RM_IHPSG13_1P_BITKIT_16x2_SRAM_2[3]/A_RWL<12>
+ RM_IHPSG13_1P_COLUMN_256_0[4]/RM_IHPSG13_1P_BITKIT_16x2_SRAM_2[1]/A_LWL<4> RM_IHPSG13_1P_COLUMN_256_0[4]/RM_IHPSG13_1P_BITKIT_16x2_SRAM_2[0]/A_LWL<12>
+ RM_IHPSG13_1P_COLUMN_256_0[4]/RM_IHPSG13_1P_BITKIT_16x2_SRAM_1[1]/A_LWL<5> RM_IHPSG13_1P_COLUMN_256_0[4]/RM_IHPSG13_1P_BITKIT_16x2_SRAM_3[2]/A_RWL<0>
+ RM_IHPSG13_1P_COLUMN_256_0[4]/RM_IHPSG13_1P_BITKIT_16x2_SRAM_0[1]/A_LWL<12> RM_IHPSG13_1P_COLUMN_256_0[4]/RM_IHPSG13_1P_BITKIT_16x2_SRAM_0[1]/A_LWL<6>
+ RM_IHPSG13_1P_COLUMN_256_0[4]/RM_IHPSG13_1P_BITKIT_16x2_SRAM_2[2]/A_RWL<1> RM_IHPSG13_1P_COLUMN_256_0[4]/RM_IHPSG13_1P_BITKIT_16x2_SRAM_3[0]/A_RWL<14>
+ RM_IHPSG13_1P_COLUMN_256_0[4]/RM_IHPSG13_1P_BITKIT_16x2_SRAM_1[0]/A_RWL<15> RM_IHPSG13_1P_COLUMN_256_0[4]/RM_IHPSG13_1P_BITKIT_16x2_SRAM_1[1]/A_LWL<4>
+ RM_IHPSG13_1P_COLUMN_256_0[4]/RM_IHPSG13_1P_BITKIT_16x2_SRAM_1[3]/A_LWL<13> RM_IHPSG13_1P_COLUMN_256_0[4]/RM_IHPSG13_1P_BITKIT_16x2_SRAM_1[2]/A_RWL<2>
+ RM_IHPSG13_1P_COLUMN_256_0[4]/RM_IHPSG13_1P_BITKIT_16x2_SRAM_1[1]/A_RWL<12> RM_IHPSG13_1P_COLUMN_256_0[4]/RM_IHPSG13_1P_BITKIT_16x2_SRAM_3[0]/A_LWL<4>
+ RM_IHPSG13_1P_COLUMN_256_0[4]/RM_IHPSG13_1P_BITKIT_16x2_SRAM_0[2]/A_LWL<9> RM_IHPSG13_1P_COLUMN_256_0[4]/RM_IHPSG13_1P_BITKIT_16x2_SRAM_0[2]/A_RWL<3>
+ RM_IHPSG13_1P_COLUMN_256_0[4]/RM_IHPSG13_1P_BITKIT_16x2_SRAM_3[1]/A_LWL<4> RM_IHPSG13_1P_COLUMN_256_0[4]/RM_IHPSG13_1P_BITKIT_16x2_SRAM_2[1]/A_LWL<5>
+ RM_IHPSG13_1P_COLUMN_256_0[4]/RM_IHPSG13_1P_BITKIT_16x2_SRAM_1[2]/A_RWL<0> RM_IHPSG13_1P_COLUMN_256_0[4]/RM_IHPSG13_1P_BITKIT_16x2_SRAM_1[1]/A_RWL<5>
+ RM_IHPSG13_1P_COLUMN_256_0[4]/RM_IHPSG13_1P_BITKIT_16x2_SRAM_2[2]/A_LWL<15> RM_IHPSG13_1P_COLUMN_256_0[4]/RM_IHPSG13_1P_BITKIT_16x2_SRAM_3[2]/A_RWL<1>
+ RM_IHPSG13_1P_COLUMN_256_0[4]/RM_IHPSG13_1P_BITKIT_16x2_SRAM_1[3]/A_LWL<10> RM_IHPSG13_1P_COLUMN_256_0[4]/RM_IHPSG13_1P_BITKIT_16x2_SRAM_0[1]/A_LWL<7>
+ RM_IHPSG13_1P_COLUMN_256_0[4]/RM_IHPSG13_1P_BITKIT_16x2_SRAM_1[1]/A_LWL<3> RM_IHPSG13_1P_COLUMN_256_0[4]/RM_IHPSG13_1P_BITKIT_16x2_SRAM_1[0]/A_LWL<6>
+ RM_IHPSG13_1P_COLUMN_256_0[4]/RM_IHPSG13_1P_BITKIT_16x2_SRAM_3[2]/A_LWL<10> RM_IHPSG13_1P_COLUMN_256_0[4]/RM_IHPSG13_1P_BITKIT_16x2_SRAM_1[3]/A_LWL<14>
+ RM_IHPSG13_1P_COLUMN_256_0[4]/RM_IHPSG13_1P_BITKIT_16x2_SRAM_3[1]/A_LWL<1> RM_IHPSG13_1P_COLUMN_256_0[4]/RM_IHPSG13_1P_BITKIT_16x2_SRAM_3[1]/A_LWL<2>
+ RM_IHPSG13_1P_COLUMN_256_0[4]/RM_IHPSG13_1P_BITKIT_16x2_SRAM_0[0]/A_RWL<6> RM_IHPSG13_1P_COLUMN_256_0[4]/RM_IHPSG13_1P_BITKIT_16x2_SRAM_1[2]/A_RWL<3>
+ RM_IHPSG13_1P_COLUMN_256_0[4]/RM_IHPSG13_1P_BITKIT_16x2_SRAM_0[2]/A_LWL<10> RM_IHPSG13_1P_COLUMN_256_0[4]/RM_IHPSG13_1P_BITKIT_16x2_SRAM_1[3]/A_RWL<7>
+ RM_IHPSG13_1P_COLUMN_256_0[4]/RM_IHPSG13_1P_BITKIT_16x2_SRAM_1[1]/A_RWL<13> RM_IHPSG13_1P_COLUMN_256_0[4]/RM_IHPSG13_1P_BITKIT_16x2_SRAM_0[2]/A_RWL<4>
+ RM_IHPSG13_1P_COLUMN_256_0[4]/RM_IHPSG13_1P_BITKIT_16x2_SRAM_0[0]/A_LWL<12> RM_IHPSG13_1P_COLUMN_256_0[4]/RM_IHPSG13_1P_BITKIT_16x2_SRAM_2[3]/A_RWL<14>
+ RM_IHPSG13_1P_COLUMN_256_0[4]/RM_IHPSG13_1P_BITKIT_16x2_SRAM_2[1]/A_LWL<6> RM_IHPSG13_1P_COLUMN_256_0[4]/RM_IHPSG13_1P_BITKIT_16x2_SRAM_1[1]/A_LWL<7>
+ RM_IHPSG13_1P_COLUMN_256_0[4]/RM_IHPSG13_1P_BITKIT_16x2_SRAM_3[2]/A_RWL<2> RM_IHPSG13_1P_COLUMN_256_0[4]/RM_IHPSG13_1P_BITKIT_16x2_SRAM_1[0]/A_RWL<14>
+ RM_IHPSG13_1P_COLUMN_256_0[4]/RM_IHPSG13_1P_BITKIT_16x2_SRAM_0[1]/A_LWL<14> RM_IHPSG13_1P_COLUMN_256_0[4]/RM_IHPSG13_1P_BITKIT_16x2_SRAM_0[1]/A_LWL<8>
+ RM_IHPSG13_1P_COLUMN_256_0[4]/RM_IHPSG13_1P_BITKIT_16x2_SRAM_2[2]/A_RWL<3> RM_IHPSG13_1P_COLUMN_256_0[4]/RM_IHPSG13_1P_BITKIT_16x2_SRAM_1[3]/A_LWL<15>
+ RM_IHPSG13_1P_COLUMN_256_0[4]/RM_IHPSG13_1P_BITKIT_16x2_SRAM_1[0]/A_LWL<4> RM_IHPSG13_1P_COLUMN_256_0[4]/RM_IHPSG13_1P_BITKIT_16x2_SRAM_1[2]/A_RWL<4>
+ RM_IHPSG13_1P_COLUMN_256_0[4]/RM_IHPSG13_1P_BITKIT_16x2_SRAM_0[3]/A_RWL<8> RM_IHPSG13_1P_COLUMN_256_0[4]/RM_IHPSG13_1P_BITKIT_16x2_SRAM_2[1]/A_RWL<4>
+ RM_IHPSG13_1P_COLUMN_256_0[4]/RM_IHPSG13_1P_BITKIT_16x2_SRAM_2[0]/A_RWL<13> RM_IHPSG13_1P_COLUMN_256_0[4]/RM_IHPSG13_1P_BITKIT_16x2_SRAM_3[3]/A_RWL<10>
+ RM_IHPSG13_1P_COLUMN_256_0[4]/RM_IHPSG13_1P_BITKIT_16x2_SRAM_1[1]/A_RWL<14> RM_IHPSG13_1P_COLUMN_256_0[4]/RM_IHPSG13_1P_BITKIT_16x2_SRAM_0[2]/A_RWL<5>
+ RM_IHPSG13_1P_COLUMN_256_0[4]/RM_IHPSG13_1P_BITKIT_16x2_SRAM_0[0]/A_RWL<10> RM_IHPSG13_1P_COLUMN_256_0[4]/RM_IHPSG13_1P_BITKIT_16x2_SRAM_2[3]/A_RWL<9>
+ RM_IHPSG13_1P_COLUMN_256_0[4]/RM_IHPSG13_1P_BITKIT_16x2_SRAM_3[1]/A_LWL<6> RM_IHPSG13_1P_COLUMN_256_0[4]/RM_IHPSG13_1P_BITKIT_16x2_SRAM_2[0]/A_LWL<9>
+ RM_IHPSG13_1P_COLUMN_256_0[4]/RM_IHPSG13_1P_BITKIT_16x2_SRAM_2[3]/A_RWL<15> RM_IHPSG13_1P_COLUMN_256_0[4]/RM_IHPSG13_1P_BITKIT_16x2_SRAM_1[2]/A_RWL<11>
+ RM_IHPSG13_1P_COLUMN_256_0[4]/RM_IHPSG13_1P_BITKIT_16x2_SRAM_2[0]/A_LWL<7> RM_IHPSG13_1P_COLUMN_256_0[4]/RM_IHPSG13_1P_BITKIT_16x2_SRAM_3[3]/A_LWL<8>
+ RM_IHPSG13_1P_COLUMN_256_0[4]/RM_IHPSG13_1P_BITKIT_16x2_SRAM_2[1]/A_LWL<15> RM_IHPSG13_1P_COLUMN_256_0[4]/RM_IHPSG13_1P_BITKIT_16x2_SRAM_1[2]/A_LWL<10>
+ RM_IHPSG13_1P_COLUMN_256_0[4]/RM_IHPSG13_1P_BITKIT_16x2_SRAM_0[1]/A_LWL<9> RM_IHPSG13_1P_COLUMN_256_0[4]/RM_IHPSG13_1P_BITKIT_16x2_SRAM_1[1]/A_LWL<1>
+ RM_IHPSG13_1P_COLUMN_256_0[4]/RM_IHPSG13_1P_BITKIT_16x2_SRAM_3[1]/A_LWL<10> RM_IHPSG13_1P_COLUMN_256_0[4]/RM_IHPSG13_1P_BITKIT_16x2_SRAM_3[0]/A_LWL<1>
+ RM_IHPSG13_1P_COLUMN_256_0[4]/RM_IHPSG13_1P_BITKIT_16x2_SRAM_0[2]/A_LWL<12> RM_IHPSG13_1P_COLUMN_256_0[4]/RM_IHPSG13_1P_BITKIT_16x2_SRAM_1[1]/A_RWL<15>
+ RM_IHPSG13_1P_COLUMN_256_0[4]/RM_IHPSG13_1P_BITKIT_16x2_SRAM_0[2]/A_RWL<6> RM_IHPSG13_1P_COLUMN_256_0[4]/RM_IHPSG13_1P_BITKIT_16x2_SRAM_0[0]/A_RWL<11>
+ RM_IHPSG13_1P_COLUMN_256_0[4]/RM_IHPSG13_1P_BITKIT_16x2_SRAM_3[1]/A_LWL<7> RM_IHPSG13_1P_COLUMN_256_0[4]/RM_IHPSG13_1P_BITKIT_16x2_SRAM_3[1]/A_RWL<7>
+ RM_IHPSG13_1P_COLUMN_256_0[4]/RM_IHPSG13_1P_BITKIT_16x2_SRAM_1[2]/A_RWL<5> RM_IHPSG13_1P_COLUMN_256_0[4]/RM_IHPSG13_1P_BITKIT_16x2_SRAM_1[2]/A_LWL<0>
+ RM_IHPSG13_1P_COLUMN_256_0[4]/RM_IHPSG13_1P_BITKIT_16x2_SRAM_1[2]/A_RWL<12> RM_IHPSG13_1P_COLUMN_256_0[4]/RM_IHPSG13_1P_BITKIT_16x2_SRAM_2[1]/A_LWL<8>
+ RM_IHPSG13_1P_COLUMN_256_0[4]/RM_IHPSG13_1P_BITKIT_16x2_SRAM_2[2]/A_RWL<2> RM_IHPSG13_1P_COLUMN_256_0[4]/RM_IHPSG13_1P_BITKIT_16x2_SRAM_0[2]/A_LWL<1>
+ RM_IHPSG13_1P_COLUMN_256_0[4]/RM_IHPSG13_1P_BITKIT_16x2_SRAM_0[3]/A_RWL<15> RM_IHPSG13_1P_COLUMN_256_0[4]/RM_IHPSG13_1P_BITKIT_16x2_SRAM_1[1]/A_LWL<9>
+ RM_IHPSG13_1P_COLUMN_256_0[4]/RM_IHPSG13_1P_BITKIT_16x2_SRAM_3[2]/A_RWL<4> RM_IHPSG13_1P_COLUMN_256_0[4]/RM_IHPSG13_1P_BITKIT_16x2_SRAM_3[0]/A_RWL<12>
+ RM_IHPSG13_1P_COLUMN_256_0[4]/RM_IHPSG13_1P_BITKIT_16x2_SRAM_1[1]/A_LWL<6> RM_IHPSG13_1P_COLUMN_256_0[4]/RM_IHPSG13_1P_BITKIT_16x2_SRAM_3[3]/A_RWL<8>
+ RM_IHPSG13_1P_COLUMN_256_0[4]/RM_IHPSG13_1P_BITKIT_16x2_SRAM_2[2]/A_RWL<15> RM_IHPSG13_1P_COLUMN_256_0[4]/RM_IHPSG13_1P_BITKIT_16x2_SRAM_2[2]/A_RWL<5>
+ RM_IHPSG13_1P_COLUMN_256_0[4]/RM_IHPSG13_1P_BITKIT_16x2_SRAM_1[2]/A_RWL<6> RM_IHPSG13_1P_COLUMN_256_0[4]/RM_IHPSG13_1P_BITKIT_16x2_SRAM_3[2]/A_RWL<10>
+ RM_IHPSG13_1P_COLUMN_256_0[4]/RM_IHPSG13_1P_BITKIT_16x2_SRAM_0[0]/A_LWL<9> RM_IHPSG13_1P_COLUMN_256_0[4]/RM_IHPSG13_1P_BITKIT_16x2_SRAM_0[0]/A_RWL<12>
+ RM_IHPSG13_1P_COLUMN_256_0[4]/RM_IHPSG13_1P_BITKIT_16x2_SRAM_0[2]/A_RWL<7> RM_IHPSG13_1P_COLUMN_256_0[4]/RM_IHPSG13_1P_BITKIT_16x2_SRAM_1[3]/A_LWL<8>
+ RM_IHPSG13_1P_COLUMN_256_0[4]/RM_IHPSG13_1P_BITKIT_16x2_SRAM_0[3]/A_LWL<10> RM_IHPSG13_1P_COLUMN_256_0[4]/RM_IHPSG13_1P_BITKIT_16x2_SRAM_1[2]/A_LWL<1>
+ RM_IHPSG13_1P_COLUMN_256_0[4]/RM_IHPSG13_1P_BITKIT_16x2_SRAM_2[1]/A_LWL<9> RM_IHPSG13_1P_COLUMN_256_0[4]/RM_IHPSG13_1P_BITKIT_16x2_SRAM_1[2]/A_RWL<13>
+ RM_IHPSG13_1P_COLUMN_256_0[4]/RM_IHPSG13_1P_BITKIT_16x2_SRAM_0[1]/A_LWL<15> RM_IHPSG13_1P_COLUMN_256_0[4]/RM_IHPSG13_1P_BITKIT_16x2_SRAM_3[2]/A_LWL<8>
+ RM_IHPSG13_1P_COLUMN_256_0[4]/RM_IHPSG13_1P_BITKIT_16x2_SRAM_0[2]/A_LWL<2> RM_IHPSG13_1P_COLUMN_256_0[4]/RM_IHPSG13_1P_BITKIT_16x2_SRAM_2[0]/A_LWL<15>
+ RM_IHPSG13_1P_COLUMN_256_0[4]/RM_IHPSG13_1P_BITKIT_16x2_SRAM_2[3]/A_LWL<13> RM_IHPSG13_1P_COLUMN_256_0[4]/RM_IHPSG13_1P_BITKIT_16x2_SRAM_3[2]/A_RWL<5>
+ RM_IHPSG13_1P_COLUMN_256_0[4]/RM_IHPSG13_1P_BITKIT_16x2_SRAM_1[3]/A_RWL<10> RM_IHPSG13_1P_COLUMN_256_0[4]/RM_IHPSG13_1P_BITKIT_16x2_SRAM_1[1]/A_LWL<10>
+ RM_IHPSG13_1P_COLUMN_256_0[4]/RM_IHPSG13_1P_BITKIT_16x2_SRAM_0[0]/A_RWL<9> RM_IHPSG13_1P_COLUMN_256_0[4]/RM_IHPSG13_1P_BITKIT_16x2_SRAM_1[0]/A_LWL<1>
+ RM_IHPSG13_1P_COLUMN_256_0[4]/RM_IHPSG13_1P_BITKIT_16x2_SRAM_2[2]/A_RWL<6> RM_IHPSG13_1P_COLUMN_256_0[4]/RM_IHPSG13_1P_BITKIT_16x2_SRAM_2[2]/A_RWL<4>
+ RM_IHPSG13_1P_COLUMN_256_0[4]/RM_IHPSG13_1P_BITKIT_16x2_SRAM_2[1]/A_RWL<13> RM_IHPSG13_1P_COLUMN_256_0[4]/RM_IHPSG13_1P_BITKIT_16x2_SRAM_0[3]/A_LWL<2>
+ RM_IHPSG13_1P_COLUMN_256_0[4]/RM_IHPSG13_1P_BITKIT_16x2_SRAM_2[3]/A_LWL<0> RM_IHPSG13_1P_COLUMN_256_0[4]/RM_IHPSG13_1P_BITKIT_16x2_SRAM_3[2]/A_LWL<0>
+ RM_IHPSG13_1P_COLUMN_256_0[4]/RM_IHPSG13_1P_BITKIT_16x2_SRAM_1[2]/A_RWL<7> RM_IHPSG13_1P_COLUMN_256_0[4]/RM_IHPSG13_1P_BITKIT_16x2_SRAM_0[2]/A_LWL<14>
+ RM_IHPSG13_1P_COLUMN_256_0[4]/RM_IHPSG13_1P_BITKIT_16x2_SRAM_1[1]/A_RWL<7> RM_IHPSG13_1P_COLUMN_256_0[4]/RM_IHPSG13_1P_BITKIT_16x2_SRAM_2[2]/A_LWL<1>
+ RM_IHPSG13_1P_COLUMN_256_0[4]/RM_IHPSG13_1P_BITKIT_16x2_SRAM_0[0]/A_RWL<13> RM_IHPSG13_1P_COLUMN_256_0[4]/RM_IHPSG13_1P_BITKIT_16x2_SRAM_2[1]/A_LWL<7>
+ RM_IHPSG13_1P_COLUMN_256_0[4]/RM_IHPSG13_1P_BITKIT_16x2_SRAM_0[2]/A_RWL<8> RM_IHPSG13_1P_COLUMN_256_0[4]/RM_IHPSG13_1P_BITKIT_16x2_SRAM_3[0]/A_RWL<7>
+ RM_IHPSG13_1P_COLUMN_256_0[4]/RM_IHPSG13_1P_BITKIT_16x2_SRAM_3[1]/A_LWL<9> RM_IHPSG13_1P_COLUMN_256_0[4]/RM_IHPSG13_1P_BITKIT_16x2_SRAM_3[3]/A_LWL<5>
+ RM_IHPSG13_1P_COLUMN_256_0[4]/RM_IHPSG13_1P_BITKIT_16x2_SRAM_0[2]/A_RWL<2> RM_IHPSG13_1P_COLUMN_256_0[4]/RM_IHPSG13_1P_BITKIT_16x2_SRAM_1[2]/A_LWL<2>
+ RM_IHPSG13_1P_COLUMN_256_0[4]/RM_IHPSG13_1P_BITKIT_16x2_SRAM_1[2]/A_RWL<14> RM_IHPSG13_1P_COLUMN_256_0[4]/RM_IHPSG13_1P_BITKIT_16x2_SRAM_2[1]/A_RWL<2>
+ RM_IHPSG13_1P_COLUMN_256_0[4]/RM_IHPSG13_1P_BITKIT_16x2_SRAM_0[1]/A_RWL<10> RM_IHPSG13_1P_COLUMN_256_0[4]/RM_IHPSG13_1P_BITKIT_16x2_SRAM_0[2]/A_LWL<3>
+ RM_IHPSG13_1P_COLUMN_256_0[4]/RM_IHPSG13_1P_BITKIT_16x2_SRAM_0[2]/A_RWL<15> RM_IHPSG13_1P_COLUMN_256_0[4]/RM_IHPSG13_1P_BITKIT_16x2_SRAM_3[2]/A_RWL<6>
+ RM_IHPSG13_1P_COLUMN_256_0[4]/RM_IHPSG13_1P_BITKIT_16x2_SRAM_1[3]/A_RWL<11> RM_IHPSG13_1P_COLUMN_256_0[4]/RM_IHPSG13_1P_BITKIT_16x2_SRAM_2[1]/A_RWL<15>
+ RM_IHPSG13_1P_COLUMN_256_0[4]/RM_IHPSG13_1P_BITKIT_16x2_SRAM_2[2]/A_RWL<7> RM_IHPSG13_1P_COLUMN_256_0[4]/RM_IHPSG13_1P_BITKIT_16x2_SRAM_1[2]/A_RWL<10>
+ RM_IHPSG13_1P_COLUMN_256_0[4]/RM_IHPSG13_1P_BITKIT_16x2_SRAM_0[3]/A_RWL<0> RM_IHPSG13_1P_COLUMN_256_0[4]/RM_IHPSG13_1P_BITKIT_16x2_SRAM_1[0]/A_RWL<1>
+ RM_IHPSG13_1P_COLUMN_256_0[4]/RM_IHPSG13_1P_BITKIT_16x2_SRAM_3[2]/A_LWL<1> RM_IHPSG13_1P_COLUMN_256_0[4]/RM_IHPSG13_1P_BITKIT_16x2_SRAM_1[2]/A_RWL<8>
+ RM_IHPSG13_1P_COLUMN_256_0[4]/RM_IHPSG13_1P_BITKIT_16x2_SRAM_0[2]/A_LWL<15> RM_IHPSG13_1P_COLUMN_256_0[4]/RM_IHPSG13_1P_BITKIT_16x2_SRAM_1[3]/A_RWL<5>
+ RM_IHPSG13_1P_COLUMN_256_0[4]/RM_IHPSG13_1P_BITKIT_16x2_SRAM_3[1]/A_RWL<10> RM_IHPSG13_1P_COLUMN_256_0[4]/RM_IHPSG13_1P_BITKIT_16x2_SRAM_0[0]/A_RWL<14>
+ RM_IHPSG13_1P_COLUMN_256_0[4]/RM_IHPSG13_1P_BITKIT_16x2_SRAM_2[2]/A_LWL<2> RM_IHPSG13_1P_COLUMN_256_0[4]/RM_IHPSG13_1P_BITKIT_16x2_SRAM_1[2]/A_LWL<8>
+ RM_IHPSG13_1P_COLUMN_256_0[4]/RM_IHPSG13_1P_BITKIT_16x2_SRAM_1[0]/A_RWL<8> RM_IHPSG13_1P_COLUMN_256_0[4]/RM_IHPSG13_1P_BITKIT_16x2_SRAM_0[3]/A_LWL<12>
+ RM_IHPSG13_1P_COLUMN_256_0[4]/RM_IHPSG13_1P_BITKIT_16x2_SRAM_1[2]/A_LWL<3> RM_IHPSG13_1P_COLUMN_256_0[4]/RM_IHPSG13_1P_BITKIT_16x2_SRAM_3[1]/A_LWL<8>
+ RM_IHPSG13_1P_COLUMN_256_0[4]/RM_IHPSG13_1P_BITKIT_16x2_SRAM_3[1]/A_RWL<12> RM_IHPSG13_1P_COLUMN_256_0[4]/RM_IHPSG13_1P_BITKIT_16x2_SRAM_1[3]/A_LWL<3>
+ RM_IHPSG13_1P_COLUMN_256_0[4]/RM_IHPSG13_1P_BITKIT_16x2_SRAM_1[2]/A_RWL<15> RM_IHPSG13_1P_COLUMN_256_0[4]/RM_IHPSG13_1P_BITKIT_16x2_SRAM_0[0]/A_LWL<15>
+ RM_IHPSG13_1P_COLUMN_256_0[4]/RM_IHPSG13_1P_BITKIT_16x2_SRAM_3[0]/A_RWL<9> RM_IHPSG13_1P_COLUMN_256_0[4]/RM_IHPSG13_1P_BITKIT_16x2_SRAM_0[1]/A_RWL<11>
+ RM_IHPSG13_1P_COLUMN_256_0[4]/RM_IHPSG13_1P_BITKIT_16x2_SRAM_3[3]/A_LWL<2> RM_IHPSG13_1P_COLUMN_256_0[4]/RM_IHPSG13_1P_BITKIT_16x2_SRAM_0[2]/A_LWL<4>
+ RM_IHPSG13_1P_COLUMN_256_0[4]/RM_IHPSG13_1P_BITKIT_16x2_SRAM_2[2]/A_LWL<13> RM_IHPSG13_1P_COLUMN_256_0[4]/RM_IHPSG13_1P_BITKIT_16x2_SRAM_3[2]/A_RWL<7>
+ RM_IHPSG13_1P_COLUMN_256_0[4]/RM_IHPSG13_1P_BITKIT_16x2_SRAM_1[3]/A_RWL<12> RM_IHPSG13_1P_COLUMN_256_0[4]/RM_IHPSG13_1P_BITKIT_16x2_SRAM_0[3]/A_LWL<0>
+ RM_IHPSG13_1P_COLUMN_256_0[4]/RM_IHPSG13_1P_BITKIT_16x2_SRAM_1[0]/A_LWL<10> RM_IHPSG13_1P_COLUMN_256_0[4]/RM_IHPSG13_1P_BITKIT_16x2_SRAM_1[3]/A_RWL<0>
+ RM_IHPSG13_1P_COLUMN_256_0[4]/RM_IHPSG13_1P_BITKIT_16x2_SRAM_2[2]/A_RWL<8> RM_IHPSG13_1P_COLUMN_256_0[4]/RM_IHPSG13_1P_BITKIT_16x2_SRAM_2[3]/A_LWL<11>
+ RM_IHPSG13_1P_COLUMN_256_0[4]/RM_IHPSG13_1P_BITKIT_16x2_SRAM_2[2]/A_LWL<0> RM_IHPSG13_1P_COLUMN_256_0[4]/RM_IHPSG13_1P_BITKIT_16x2_SRAM_0[3]/A_RWL<1>
+ RM_IHPSG13_1P_COLUMN_256_0[4]/RM_IHPSG13_1P_BITKIT_16x2_SRAM_3[2]/A_LWL<2> RM_IHPSG13_1P_COLUMN_256_0[4]/RM_IHPSG13_1P_BITKIT_16x2_SRAM_1[2]/A_RWL<9>
+ RM_IHPSG13_1P_COLUMN_256_0[4]/RM_IHPSG13_1P_BITKIT_16x2_SRAM_1[0]/A_RWL<7> RM_IHPSG13_1P_COLUMN_256_0[4]/RM_IHPSG13_1P_BITKIT_16x2_SRAM_1[3]/A_LWL<5>
+ RM_IHPSG13_1P_COLUMN_256_0[4]/RM_IHPSG13_1P_BITKIT_16x2_SRAM_2[2]/A_LWL<3> RM_IHPSG13_1P_COLUMN_256_0[4]/RM_IHPSG13_1P_BITKIT_16x2_SRAM_0[1]/A_RWL<2>
+ RM_IHPSG13_1P_COLUMN_256_0[4]/RM_IHPSG13_1P_BITKIT_16x2_SRAM_0[3]/A_LWL<13> RM_IHPSG13_1P_COLUMN_256_0[4]/RM_IHPSG13_1P_BITKIT_16x2_SRAM_1[2]/A_LWL<4>
+ RM_IHPSG13_1P_COLUMN_256_0[4]/RM_IHPSG13_1P_BITKIT_16x2_SRAM_2[0]/A_RWL<2> RM_IHPSG13_1P_COLUMN_256_0[4]/RM_IHPSG13_1P_BITKIT_16x2_SRAM_0[1]/A_RWL<12>
+ RM_IHPSG13_1P_COLUMN_256_0[4]/RM_IHPSG13_1P_BITKIT_16x2_SRAM_2[0]/A_RWL<0> RM_IHPSG13_1P_COLUMN_256_0[4]/RM_IHPSG13_1P_BITKIT_16x2_SRAM_3[3]/A_RWL<3>
+ RM_IHPSG13_1P_COLUMN_256_0[4]/RM_IHPSG13_1P_BITKIT_16x2_SRAM_0[1]/A_RWL<9> RM_IHPSG13_1P_COLUMN_256_0[4]/RM_IHPSG13_1P_BITKIT_16x2_SRAM_0[2]/A_LWL<5>
+ RM_IHPSG13_1P_COLUMN_256_0[4]/RM_IHPSG13_1P_BITKIT_16x2_SRAM_2[3]/A_RWL<4> RM_IHPSG13_1P_COLUMN_256_0[4]/RM_IHPSG13_1P_BITKIT_16x2_SRAM_2[3]/A_RWL<0>
+ RM_IHPSG13_1P_COLUMN_256_0[4]/RM_IHPSG13_1P_BITKIT_16x2_SRAM_3[2]/A_RWL<8> RM_IHPSG13_1P_COLUMN_256_0[4]/RM_IHPSG13_1P_BITKIT_16x2_SRAM_2[2]/A_RWL<13>
+ RM_IHPSG13_1P_COLUMN_256_0[4]/RM_IHPSG13_1P_BITKIT_16x2_SRAM_1[3]/A_RWL<13> RM_IHPSG13_1P_COLUMN_256_0[4]/RM_IHPSG13_1P_BITKIT_16x2_SRAM_2[0]/A_RWL<15>
+ RM_IHPSG13_1P_COLUMN_256_0[4]/RM_IHPSG13_1P_BITKIT_16x2_SRAM_1[3]/A_RWL<1> RM_IHPSG13_1P_COLUMN_256_0[4]/RM_IHPSG13_1P_BITKIT_16x2_SRAM_2[2]/A_RWL<9>
+ RM_IHPSG13_1P_COLUMN_256_0[4]/RM_IHPSG13_1P_BITKIT_16x2_SRAM_1[1]/A_RWL<10> RM_IHPSG13_1P_COLUMN_256_0[4]/RM_IHPSG13_1P_BITKIT_16x2_SRAM_2[2]/A_LWL<7>
+ RM_IHPSG13_1P_COLUMN_256_0[4]/RM_IHPSG13_1P_BITKIT_16x2_SRAM_0[3]/A_RWL<2> RM_IHPSG13_1P_COLUMN_256_0[4]/RM_IHPSG13_1P_BITKIT_16x2_SRAM_3[2]/A_LWL<3>
+ RM_IHPSG13_1P_COLUMN_256_0[4]/RM_IHPSG13_1P_BITKIT_16x2_SRAM_3[0]/A_RWL<10> RM_IHPSG13_1P_COLUMN_256_0[4]/RM_IHPSG13_1P_BITKIT_16x2_SRAM_2[2]/A_LWL<4>
+ RM_IHPSG13_1P_COLUMN_256_0[4]/RM_IHPSG13_1P_BITKIT_16x2_SRAM_1[1]/A_LWL<8> RM_IHPSG13_1P_COLUMN_256_0[4]/RM_IHPSG13_1P_BITKIT_16x2_SRAM_0[3]/A_LWL<14>
+ RM_IHPSG13_1P_COLUMN_256_0[4]/RM_IHPSG13_1P_BITKIT_16x2_SRAM_3[0]/A_LWL<8> RM_IHPSG13_1P_COLUMN_256_0[4]/RM_IHPSG13_1P_BITKIT_16x2_SRAM_3[3]/A_RWL<0>
+ RM_IHPSG13_1P_COLUMN_256_0[4]/RM_IHPSG13_1P_BITKIT_16x2_SRAM_0[2]/A_LWL<13> RM_IHPSG13_1P_COLUMN_256_0[4]/RM_IHPSG13_1P_BITKIT_16x2_SRAM_0[1]/A_RWL<13>
+ RM_IHPSG13_1P_COLUMN_256_0[4]/RM_IHPSG13_1P_BITKIT_16x2_SRAM_3[0]/A_LWL<10> RM_IHPSG13_1P_COLUMN_256_0[4]/RM_IHPSG13_1P_BITKIT_16x2_SRAM_2[1]/A_LWL<13>
+ RM_IHPSG13_1P_COLUMN_256_0[4]/RM_IHPSG13_1P_BITKIT_16x2_SRAM_0[2]/A_LWL<6> RM_IHPSG13_1P_COLUMN_256_0[4]/RM_IHPSG13_1P_BITKIT_16x2_SRAM_2[3]/A_RWL<1>
+ RM_IHPSG13_1P_COLUMN_256_0[4]/RM_IHPSG13_1P_BITKIT_16x2_SRAM_3[2]/A_RWL<9> RM_IHPSG13_1P_COLUMN_256_0[4]/RM_IHPSG13_1P_BITKIT_16x2_SRAM_0[3]/A_LWL<11>
+ RM_IHPSG13_1P_COLUMN_256_0[4]/RM_IHPSG13_1P_BITKIT_16x2_SRAM_1[3]/A_RWL<14> RM_IHPSG13_1P_COLUMN_256_0[4]/RM_IHPSG13_1P_BITKIT_16x2_SRAM_0[2]/A_LWL<0>
+ RM_IHPSG13_1P_COLUMN_256_0[4]/RM_IHPSG13_1P_BITKIT_16x2_SRAM_1[1]/A_RWL<1> RM_IHPSG13_1P_COLUMN_256_0[4]/RM_IHPSG13_1P_BITKIT_16x2_SRAM_0[2]/A_RWL<10>
+ RM_IHPSG13_1P_COLUMN_256_0[4]/RM_IHPSG13_1P_BITKIT_16x2_SRAM_1[3]/A_RWL<2> RM_IHPSG13_1P_COLUMN_256_0[4]/RM_IHPSG13_1P_BITKIT_16x2_SRAM_2[2]/A_LWL<11>
+ RM_IHPSG13_1P_COLUMN_256_0[4]/RM_IHPSG13_1P_BITKIT_16x2_SRAM_2[1]/A_LWL<0> RM_IHPSG13_1P_COLUMN_256_0[4]/RM_IHPSG13_1P_BITKIT_16x2_SRAM_0[3]/A_RWL<3>
+ RM_IHPSG13_1P_COLUMN_256_0[4]/RM_IHPSG13_1P_BITKIT_16x2_SRAM_3[2]/A_LWL<4> RM_IHPSG13_1P_COLUMN_256_0[4]/RM_IHPSG13_1P_BITKIT_16x2_SRAM_1[1]/A_RWL<8>
+ RM_IHPSG13_1P_COLUMN_256_0[4]/RM_IHPSG13_1P_BITKIT_16x2_SRAM_1[2]/A_LWL<5> RM_IHPSG13_1P_COLUMN_256_0[4]/RM_IHPSG13_1P_BITKIT_16x2_SRAM_1[0]/A_LWL<2>
+ RM_IHPSG13_1P_COLUMN_256_0[4]/RM_IHPSG13_1P_BITKIT_16x2_SRAM_3[2]/A_RWL<12> RM_IHPSG13_1P_COLUMN_256_0[4]/RM_IHPSG13_1P_BITKIT_16x2_SRAM_2[2]/A_LWL<5>
+ RM_IHPSG13_1P_COLUMN_256_0[4]/RM_IHPSG13_1P_BITKIT_16x2_SRAM_1[3]/A_LWL<6> RM_IHPSG13_1P_COLUMN_256_0[4]/RM_IHPSG13_1P_BITKIT_16x2_SRAM_3[1]/A_RWL<9>
+ RM_IHPSG13_1P_COLUMN_256_0[4]/RM_IHPSG13_1P_BITKIT_16x2_SRAM_3[1]/A_LWL<5> RM_IHPSG13_1P_COLUMN_256_0[4]/RM_IHPSG13_1P_BITKIT_16x2_SRAM_0[0]/A_RWL<2>
+ RM_IHPSG13_1P_COLUMN_256_0[4]/RM_IHPSG13_1P_BITKIT_16x2_SRAM_0[3]/A_LWL<15> RM_IHPSG13_1P_COLUMN_256_0[4]/RM_IHPSG13_1P_BITKIT_16x2_SRAM_1[2]/A_LWL<6>
+ RM_IHPSG13_1P_COLUMN_256_0[4]/RM_IHPSG13_1P_BITKIT_16x2_SRAM_3[3]/A_RWL<1> RM_IHPSG13_1P_COLUMN_256_0[4]/RM_IHPSG13_1P_BITKIT_16x2_SRAM_0[1]/A_RWL<14>
+ RM_IHPSG13_1P_COLUMN_256_0[4]/RM_IHPSG13_1P_BITKIT_16x2_SRAM_3[2]/A_RWL<3> RM_IHPSG13_1P_COLUMN_256_0[4]/RM_IHPSG13_1P_BITKIT_16x2_SRAM_3[0]/A_LWL<11>
+ RM_IHPSG13_1P_COLUMN_256_0[4]/RM_IHPSG13_1P_BITKIT_16x2_SRAM_0[2]/A_LWL<7> RM_IHPSG13_1P_COLUMN_256_0[4]/RM_IHPSG13_1P_BITKIT_16x2_SRAM_0[0]/A_RWL<15>
+ RM_IHPSG13_1P_COLUMN_256_0[4]/RM_IHPSG13_1P_BITKIT_16x2_SRAM_2[3]/A_RWL<2> RM_IHPSG13_1P_COLUMN_256_0[4]/RM_IHPSG13_1P_BITKIT_16x2_SRAM_2[3]/A_LWL<14>
+ RM_IHPSG13_1P_COLUMN_256_0[4]/RM_IHPSG13_1P_BITKIT_16x2_SRAM_1[3]/A_RWL<15> RM_IHPSG13_1P_COLUMN_256_0[4]/RM_IHPSG13_1P_BITKIT_16x2_SRAM_0[2]/A_RWL<11>
+ RM_IHPSG13_1P_COLUMN_256_0[4]/RM_IHPSG13_1P_BITKIT_16x2_SRAM_1[3]/A_RWL<3> RM_IHPSG13_1P_COLUMN_256_0[4]/RM_IHPSG13_1P_BITKIT_16x2_SRAM_1[0]/A_RWL<10>
+ RM_IHPSG13_1P_COLUMN_256_0[4]/RM_IHPSG13_1P_BITKIT_16x2_SRAM_0[3]/A_RWL<4> RM_IHPSG13_1P_COLUMN_256_0[4]/RM_IHPSG13_1P_BITKIT_16x2_SRAM_2[3]/A_RWL<11>
+ RM_IHPSG13_1P_COLUMN_256_0[4]/RM_IHPSG13_1P_BITKIT_16x2_SRAM_3[2]/A_LWL<5> RM_IHPSG13_1P_COLUMN_256_0[4]/RM_IHPSG13_1P_BITKIT_16x2_SRAM_0[0]/A_RWL<4>
+ RM_IHPSG13_1P_COLUMN_256_0[4]/RM_IHPSG13_1P_BITKIT_16x2_SRAM_2[2]/A_LWL<6> RM_IHPSG13_1P_COLUMN_256_0[4]/RM_IHPSG13_1P_BITKIT_16x2_SRAM_1[0]/A_LWL<8>
+ RM_IHPSG13_1P_COLUMN_256_0[4]/RM_IHPSG13_1P_BITKIT_16x2_SRAM_0[3]/A_RWL<12> RM_IHPSG13_1P_COLUMN_256_0[4]/RM_IHPSG13_1P_BITKIT_16x2_SRAM_2[1]/A_RWL<0>
+ RM_IHPSG13_1P_COLUMN_256_0[4]/RM_IHPSG13_1P_BITKIT_16x2_SRAM_3[3]/A_RWL<6> RM_IHPSG13_1P_COLUMN_256_0[4]/RM_IHPSG13_1P_BITKIT_16x2_SRAM_2[0]/A_RWL<5>
+ RM_IHPSG13_1P_COLUMN_256_0[4]/RM_IHPSG13_1P_BITKIT_16x2_SRAM_0[2]/A_RWL<9> RM_IHPSG13_1P_COLUMN_256_0[4]/RM_IHPSG13_1P_BITKIT_16x2_SRAM_1[2]/A_LWL<7>
+ RM_IHPSG13_1P_COLUMN_256_0[4]/RM_IHPSG13_1P_BITKIT_16x2_SRAM_0[1]/A_LWL<13> RM_IHPSG13_1P_COLUMN_256_0[4]/RM_IHPSG13_1P_BITKIT_16x2_SRAM_3[3]/A_RWL<2>
+ RM_IHPSG13_1P_COLUMN_256_0[4]/RM_IHPSG13_1P_BITKIT_16x2_SRAM_2[3]/A_RWL<13> RM_IHPSG13_1P_COLUMN_256_0[4]/RM_IHPSG13_1P_BITKIT_16x2_SRAM_0[1]/A_RWL<15>
+ RM_IHPSG13_1P_COLUMN_256_0[4]/RM_IHPSG13_1P_BITKIT_16x2_SRAM_3[0]/A_LWL<12> RM_IHPSG13_1P_COLUMN_256_0[4]/RM_IHPSG13_1P_BITKIT_16x2_SRAM_0[2]/A_LWL<8>
+ RM_IHPSG13_1P_COLUMN_256_0[4]/RM_IHPSG13_1P_BITKIT_16x2_SRAM_2[0]/A_LWL<13> RM_IHPSG13_1P_COLUMN_256_0[4]/RM_IHPSG13_1P_BITKIT_16x2_SRAM_2[3]/A_RWL<3>
+ RM_IHPSG13_1P_COLUMN_256_0[4]/RM_IHPSG13_1P_BITKIT_16x2_SRAM_0[2]/A_LWL<11> RM_IHPSG13_1P_COLUMN_256_0[4]/RM_IHPSG13_1P_BITKIT_16x2_SRAM_3[3]/A_LWL<12>
+ RM_IHPSG13_1P_COLUMN_256_0[4]/RM_IHPSG13_1P_BITKIT_16x2_SRAM_2[0]/A_LWL<3> RM_IHPSG13_1P_COLUMN_256_0[4]/RM_IHPSG13_1P_BITKIT_16x2_SRAM_0[1]/A_LWL<0>
+ RM_IHPSG13_1P_COLUMN_256_0[4]/RM_IHPSG13_1P_BITKIT_16x2_SRAM_2[3]/A_LWL<7> RM_IHPSG13_1P_COLUMN_256_0[4]/RM_IHPSG13_1P_BITKIT_16x2_SRAM_0[2]/A_RWL<12>
+ RM_IHPSG13_1P_COLUMN_256_0[4]/RM_IHPSG13_1P_BITKIT_16x2_SRAM_1[3]/A_RWL<4> RM_IHPSG13_1P_COLUMN_256_0[4]/RM_IHPSG13_1P_BITKIT_16x2_SRAM_2[1]/A_LWL<11>
+ RM_IHPSG13_1P_COLUMN_256_0[4]/RM_IHPSG13_1P_BITKIT_16x2_SRAM_2[0]/A_LWL<0> RM_IHPSG13_1P_COLUMN_256_0[7]/RM_IHPSG13_1P_BITKIT_16x2_SRAM_3[3]/VSS
+ RM_IHPSG13_1P_COLUMN_256_0[4]/RM_IHPSG13_1P_BITKIT_16x2_SRAM_0[3]/A_RWL<5> RM_IHPSG13_1P_COLUMN_256_0[7]/RM_IHPSG13_1P_BITKIT_16x2_SRAM_3[3]/VDD
+ RM_IHPSG13_1P_COLUMN_256_0[4]/RM_IHPSG13_1P_BITKIT_16x2_SRAM_3[2]/A_LWL<6> RM_IHPSG13_1P_COLUMN_256
XRM_IHPSG13_1P_COLUMN_256_0[5] RM_IHPSG13_1P_COLUMN_256_0[5]/RM_IHPSG13_1P_BITKIT_16x2_SRAM_0[0]/A_BLT_BOT<0>
+ RM_IHPSG13_1P_COLUMN_256_0[5]/RM_IHPSG13_1P_BITKIT_16x2_SRAM_0[0]/A_BLT_BOT<1> RM_IHPSG13_1P_COLUMN_256_0[5]/RM_IHPSG13_1P_BITKIT_16x2_SRAM_0[0]/A_BLC_BOT<0>
+ RM_IHPSG13_1P_COLUMN_256_0[5]/RM_IHPSG13_1P_BITKIT_16x2_SRAM_1[3]/A_RWL<6> RM_IHPSG13_1P_COLUMN_256_0[5]/RM_IHPSG13_1P_BITKIT_16x2_SRAM_0[3]/A_RWL<11>
+ RM_IHPSG13_1P_COLUMN_256_0[5]/RM_IHPSG13_1P_BITKIT_16x2_SRAM_0[0]/A_BLC_BOT<1> RM_IHPSG13_1P_COLUMN_256_0[5]/RM_IHPSG13_1P_BITKIT_16x2_SRAM_3[1]/A_LWL<12>
+ RM_IHPSG13_1P_COLUMN_256_0[5]/RM_IHPSG13_1P_BITKIT_16x2_SRAM_1[3]/A_RWL<8> RM_IHPSG13_1P_COLUMN_256_0[5]/RM_IHPSG13_1P_BITKIT_16x2_SRAM_0[3]/A_RWL<9>
+ RM_IHPSG13_1P_COLUMN_256_0[5]/RM_IHPSG13_1P_BITKIT_16x2_SRAM_0[3]/A_LWL<4> RM_IHPSG13_1P_COLUMN_256_0[5]/RM_IHPSG13_1P_BITKIT_16x2_SRAM_3[2]/A_LWL<9>
+ RM_IHPSG13_1P_COLUMN_256_0[5]/RM_IHPSG13_1P_BITKIT_16x2_SRAM_2[3]/A_LWL<1> RM_IHPSG13_1P_COLUMN_256_0[5]/RM_IHPSG13_1P_BITKIT_16x2_SRAM_0[3]/A_RWL<14>
+ RM_IHPSG13_1P_COLUMN_256_0[5]/RM_IHPSG13_1P_BITKIT_16x2_SRAM_0[2]/A_RWL<14> RM_IHPSG13_1P_COLUMN_256_0[5]/RM_IHPSG13_1P_BITKIT_16x2_SRAM_2[0]/A_LWL<11>
+ RM_IHPSG13_1P_COLUMN_256_0[5]/RM_IHPSG13_1P_BITKIT_16x2_SRAM_2[3]/A_LWL<4> RM_IHPSG13_1P_COLUMN_256_0[5]/RM_IHPSG13_1P_BITKIT_16x2_SRAM_3[2]/A_LWL<12>
+ RM_IHPSG13_1P_COLUMN_256_0[5]/RM_IHPSG13_1P_BITKIT_16x2_SRAM_1[2]/A_LWL<9> RM_IHPSG13_1P_COLUMN_256_0[5]/RM_IHPSG13_1P_BITKIT_16x2_SRAM_3[3]/A_RWL<9>
+ RM_IHPSG13_1P_COLUMN_256_0[5]/RM_IHPSG13_1P_BITKIT_16x2_SRAM_1[3]/A_LWL<2> RM_IHPSG13_1P_COLUMN_256_0[5]/RM_IHPSG13_1P_BITKIT_16x2_SRAM_0[3]/A_LWL<1>
+ RM_IHPSG13_1P_COLUMN_256_0[5]/RM_IHPSG13_1P_BITKIT_16x2_SRAM_2[3]/A_RWL<7> RM_IHPSG13_1P_COLUMN_256_0[5]/RM_IHPSG13_1P_BITKIT_16x2_SRAM_0[0]/A_RWL<0>
+ RM_IHPSG13_1P_COLUMN_256_0[5]/RM_IHPSG13_1P_BITKIT_16x2_SRAM_2[0]/A_RWL<1> RM_IHPSG13_1P_COLUMN_256_0[5]/RM_IHPSG13_1P_BITKIT_16x2_SRAM_0[2]/A_RWL<13>
+ RM_IHPSG13_1P_COLUMN_256_0[5]/RM_IHPSG13_1P_BITKIT_16x2_SRAM_2[3]/A_RWL<5> RM_IHPSG13_1P_COLUMN_256_0[5]/RM_IHPSG13_1P_BITKIT_16x2_SRAM_2[3]/A_LWL<3>
+ RM_IHPSG13_1P_COLUMN_256_0[5]/RM_IHPSG13_1P_BITKIT_16x2_SRAM_3[0]/A_RWL<13> RM_IHPSG13_1P_COLUMN_256_0[5]/RM_IHPSG13_1P_BITKIT_16x2_SRAM_1[0]/A_RWL<3>
+ RM_IHPSG13_1P_COLUMN_256_0[5]/RM_IHPSG13_1P_BITKIT_16x2_SRAM_3[1]/A_LWL<15> RM_IHPSG13_1P_COLUMN_256_0[5]/RM_IHPSG13_1P_BITKIT_16x2_SRAM_2[0]/A_LWL<14>
+ RM_IHPSG13_1P_COLUMN_256_0[5]/RM_IHPSG13_1P_BITKIT_16x2_SRAM_0[3]/A_RWL<7> RM_IHPSG13_1P_COLUMN_256_0[5]/RM_IHPSG13_1P_BITKIT_16x2_SRAM_3[0]/A_RWL<0>
+ RM_IHPSG13_1P_COLUMN_256_0[5]/RM_IHPSG13_1P_BITKIT_16x2_SRAM_3[2]/A_LWL<15> RM_IHPSG13_1P_COLUMN_256_0[5]/RM_IHPSG13_1P_BITKIT_16x2_SRAM_3[3]/A_RWL<4>
+ RM_IHPSG13_1P_COLUMN_256_0[5]/RM_IHPSG13_1P_BITKIT_16x2_SRAM_3[2]/A_LWL<7> RM_IHPSG13_1P_COLUMN_256_0[5]/RM_IHPSG13_1P_BITKIT_16x2_SRAM_0[0]/A_LWL<0>
+ RM_IHPSG13_1P_COLUMN_256_0[5]/RM_IHPSG13_1P_BITKIT_16x2_SRAM_1[3]/A_LWL<9> RM_IHPSG13_1P_COLUMN_256_0[5]/RM_IHPSG13_1P_BITKIT_16x2_SRAM_3[0]/A_RWL<3>
+ RM_IHPSG13_1P_COLUMN_256_0[5]/RM_IHPSG13_1P_BITKIT_16x2_SRAM_0[0]/A_RWL<5> RM_IHPSG13_1P_COLUMN_256_0[5]/RM_IHPSG13_1P_BITKIT_16x2_SRAM_0[3]/A_RWL<13>
+ RM_IHPSG13_1P_COLUMN_256_0[5]/RM_IHPSG13_1P_BITKIT_16x2_SRAM_2[3]/A_LWL<8> RM_IHPSG13_1P_COLUMN_256_0[5]/RM_IHPSG13_1P_BITKIT_16x2_SRAM_0[3]/A_LWL<7>
+ RM_IHPSG13_1P_COLUMN_256_0[5]/RM_IHPSG13_1P_BITKIT_16x2_SRAM_3[0]/A_LWL<15> RM_IHPSG13_1P_COLUMN_256_0[5]/RM_IHPSG13_1P_BITKIT_16x2_SRAM_3[3]/A_LWL<13>
+ RM_IHPSG13_1P_COLUMN_256_0[5]/RM_IHPSG13_1P_BITKIT_16x2_SRAM_2[3]/A_LWL<6> RM_IHPSG13_1P_COLUMN_256_0[5]/RM_IHPSG13_1P_BITKIT_16x2_SRAM_2[1]/A_LWL<10>
+ RM_IHPSG13_1P_COLUMN_256_0[5]/RM_IHPSG13_1P_BITKIT_16x2_SRAM_3[3]/A_LWL<0> RM_IHPSG13_1P_COLUMN_256_0[5]/RM_IHPSG13_1P_BITKIT_16x2_SRAM_3[0]/A_RWL<4>
+ RM_IHPSG13_1P_COLUMN_256_0[5]/RM_IHPSG13_1P_BITKIT_16x2_SRAM_2[2]/A_LWL<10> RM_IHPSG13_1P_COLUMN_256_0[5]/RM_IHPSG13_1P_BITKIT_16x2_SRAM_3[1]/A_RWL<13>
+ RM_IHPSG13_1P_COLUMN_256_0[5]/RM_IHPSG13_1P_BITKIT_16x2_SRAM_1[0]/A_RWL<6> RM_IHPSG13_1P_COLUMN_256_0[5]/RM_IHPSG13_1P_BITKIT_16x2_SRAM_3[3]/A_LWL<9>
+ RM_IHPSG13_1P_COLUMN_256_0[5]/RM_IHPSG13_1P_BITKIT_16x2_SRAM_1[0]/A_RWL<4> RM_IHPSG13_1P_COLUMN_256_0[5]/RM_IHPSG13_1P_BITKIT_16x2_SRAM_0[3]/A_RWL<10>
+ RM_IHPSG13_1P_COLUMN_256_0[5]/RM_IHPSG13_1P_BITKIT_16x2_SRAM_2[1]/A_LWL<14> RM_IHPSG13_1P_COLUMN_256_0[5]/RM_IHPSG13_1P_BITKIT_16x2_SRAM_3[0]/A_RWL<5>
+ RM_IHPSG13_1P_COLUMN_256_0[5]/RM_IHPSG13_1P_BITKIT_16x2_SRAM_0[3]/A_LWL<8> RM_IHPSG13_1P_COLUMN_256_0[5]/RM_IHPSG13_1P_BITKIT_16x2_SRAM_3[3]/A_LWL<7>
+ RM_IHPSG13_1P_COLUMN_256_0[5]/RM_IHPSG13_1P_BITKIT_16x2_SRAM_2[2]/A_LWL<8> RM_IHPSG13_1P_COLUMN_256_0[5]/RM_IHPSG13_1P_BITKIT_16x2_SRAM_3[3]/A_LWL<15>
+ RM_IHPSG13_1P_COLUMN_256_0[5]/RM_IHPSG13_1P_BITKIT_16x2_SRAM_3[2]/A_LWL<13> RM_IHPSG13_1P_COLUMN_256_0[5]/RM_IHPSG13_1P_BITKIT_16x2_SRAM_2[0]/A_LWL<1>
+ RM_IHPSG13_1P_COLUMN_256_0[5]/RM_IHPSG13_1P_BITKIT_16x2_SRAM_0[0]/A_LWL<1> RM_IHPSG13_1P_COLUMN_256_0[5]/RM_IHPSG13_1P_BITKIT_16x2_SRAM_1[3]/A_LWL<0>
+ RM_IHPSG13_1P_COLUMN_256_0[5]/RM_IHPSG13_1P_BITKIT_16x2_SRAM_2[0]/A_LWL<10> RM_IHPSG13_1P_COLUMN_256_0[5]/RM_IHPSG13_1P_BITKIT_16x2_SRAM_3[3]/A_LWL<11>
+ RM_IHPSG13_1P_COLUMN_256_0[5]/RM_IHPSG13_1P_BITKIT_16x2_SRAM_0[0]/A_LWL<3> RM_IHPSG13_1P_COLUMN_256_0[5]/RM_IHPSG13_1P_BITKIT_16x2_SRAM_3[0]/A_RWL<6>
+ RM_IHPSG13_1P_COLUMN_256_0[5]/RM_IHPSG13_1P_BITKIT_16x2_SRAM_2[3]/A_LWL<5> RM_IHPSG13_1P_COLUMN_256_0[5]/RM_IHPSG13_1P_BITKIT_16x2_SRAM_2[0]/A_RWL<7>
+ RM_IHPSG13_1P_COLUMN_256_0[5]/RM_IHPSG13_1P_BITKIT_16x2_SRAM_3[1]/A_RWL<15> RM_IHPSG13_1P_COLUMN_256_0[5]/RM_IHPSG13_1P_BITKIT_16x2_SRAM_0[1]/A_RWL<0>
+ RM_IHPSG13_1P_COLUMN_256_0[5]/RM_IHPSG13_1P_BITKIT_16x2_SRAM_3[0]/A_RWL<2> RM_IHPSG13_1P_COLUMN_256_0[5]/RM_IHPSG13_1P_BITKIT_16x2_SRAM_2[0]/A_RWL<11>
+ RM_IHPSG13_1P_COLUMN_256_0[5]/RM_IHPSG13_1P_BITKIT_16x2_SRAM_2[0]/A_LWL<2> RM_IHPSG13_1P_COLUMN_256_0[5]/RM_IHPSG13_1P_BITKIT_16x2_SRAM_3[0]/A_RWL<15>
+ RM_IHPSG13_1P_COLUMN_256_0[5]/RM_IHPSG13_1P_BITKIT_16x2_SRAM_0[0]/A_LWL<4> RM_IHPSG13_1P_COLUMN_256_0[5]/RM_IHPSG13_1P_BITKIT_16x2_SRAM_1[0]/A_LWL<12>
+ RM_IHPSG13_1P_COLUMN_256_0[5]/RM_IHPSG13_1P_BITKIT_16x2_SRAM_2[0]/A_RWL<8> RM_IHPSG13_1P_COLUMN_256_0[5]/RM_IHPSG13_1P_BITKIT_16x2_SRAM_1[0]/A_RWL<9>
+ RM_IHPSG13_1P_COLUMN_256_0[5]/RM_IHPSG13_1P_BITKIT_16x2_SRAM_3[1]/A_LWL<13> RM_IHPSG13_1P_COLUMN_256_0[5]/RM_IHPSG13_1P_BITKIT_16x2_SRAM_1[3]/A_RWL<9>
+ RM_IHPSG13_1P_COLUMN_256_0[5]/RM_IHPSG13_1P_BITKIT_16x2_SRAM_2[3]/A_LWL<10> RM_IHPSG13_1P_COLUMN_256_0[5]/RM_IHPSG13_1P_BITKIT_16x2_SRAM_3[2]/A_RWL<13>
+ RM_IHPSG13_1P_COLUMN_256_0[5]/RM_IHPSG13_1P_BITKIT_16x2_SRAM_3[2]/A_LWL<11> RM_IHPSG13_1P_COLUMN_256_0[5]/RM_IHPSG13_1P_BITKIT_16x2_SRAM_0[0]/A_RWL<7>
+ RM_IHPSG13_1P_COLUMN_256_0[5]/RM_IHPSG13_1P_BITKIT_16x2_SRAM_0[3]/A_LWL<5> RM_IHPSG13_1P_COLUMN_256_0[5]/RM_IHPSG13_1P_BITKIT_16x2_SRAM_1[0]/A_RWL<2>
+ RM_IHPSG13_1P_COLUMN_256_0[5]/RM_IHPSG13_1P_BITKIT_16x2_SRAM_2[2]/A_LWL<14> RM_IHPSG13_1P_COLUMN_256_0[5]/RM_IHPSG13_1P_BITKIT_16x2_SRAM_3[0]/A_LWL<3>
+ RM_IHPSG13_1P_COLUMN_256_0[5]/RM_IHPSG13_1P_BITKIT_16x2_SRAM_2[0]/A_LWL<4> RM_IHPSG13_1P_COLUMN_256_0[5]/RM_IHPSG13_1P_BITKIT_16x2_SRAM_3[3]/A_LWL<14>
+ RM_IHPSG13_1P_COLUMN_256_0[5]/RM_IHPSG13_1P_BITKIT_16x2_SRAM_2[1]/A_RWL<10> RM_IHPSG13_1P_COLUMN_256_0[5]/RM_IHPSG13_1P_BITKIT_16x2_SRAM_1[0]/A_LWL<5>
+ RM_IHPSG13_1P_COLUMN_256_0[5]/RM_IHPSG13_1P_BITKIT_16x2_SRAM_3[1]/A_RWL<0> RM_IHPSG13_1P_COLUMN_256_0[5]/RM_IHPSG13_1P_BITKIT_16x2_SRAM_2[0]/A_RWL<10>
+ RM_IHPSG13_1P_COLUMN_256_0[5]/RM_IHPSG13_1P_BITKIT_16x2_SRAM_2[0]/A_RWL<12> RM_IHPSG13_1P_COLUMN_256_0[5]/RM_IHPSG13_1P_BITKIT_16x2_SRAM_3[3]/A_RWL<11>
+ RM_IHPSG13_1P_COLUMN_256_0[5]/RM_IHPSG13_1P_BITKIT_16x2_SRAM_0[0]/A_LWL<6> RM_IHPSG13_1P_COLUMN_256_0[5]/RM_IHPSG13_1P_BITKIT_16x2_SRAM_2[1]/A_RWL<1>
+ RM_IHPSG13_1P_COLUMN_256_0[5]/RM_IHPSG13_1P_BITKIT_16x2_SRAM_2[3]/A_RWL<8> RM_IHPSG13_1P_COLUMN_256_0[5]/RM_IHPSG13_1P_BITKIT_16x2_SRAM_1[1]/A_RWL<2>
+ RM_IHPSG13_1P_COLUMN_256_0[5]/RM_IHPSG13_1P_BITKIT_16x2_SRAM_2[0]/A_RWL<14> RM_IHPSG13_1P_COLUMN_256_0[5]/RM_IHPSG13_1P_BITKIT_16x2_SRAM_3[0]/A_LWL<13>
+ RM_IHPSG13_1P_COLUMN_256_0[5]/RM_IHPSG13_1P_BITKIT_16x2_SRAM_3[2]/A_RWL<15> RM_IHPSG13_1P_COLUMN_256_0[5]/RM_IHPSG13_1P_BITKIT_16x2_SRAM_2[1]/A_RWL<11>
+ RM_IHPSG13_1P_COLUMN_256_0[5]/RM_IHPSG13_1P_BITKIT_16x2_SRAM_3[1]/A_LWL<11> RM_IHPSG13_1P_COLUMN_256_0[5]/RM_IHPSG13_1P_BITKIT_16x2_SRAM_3[0]/A_LWL<0>
+ RM_IHPSG13_1P_COLUMN_256_0[5]/RM_IHPSG13_1P_BITKIT_16x2_SRAM_3[3]/A_RWL<12> RM_IHPSG13_1P_COLUMN_256_0[5]/RM_IHPSG13_1P_BITKIT_16x2_SRAM_0[0]/A_LWL<7>
+ RM_IHPSG13_1P_COLUMN_256_0[5]/RM_IHPSG13_1P_BITKIT_16x2_SRAM_1[0]/A_LWL<15> RM_IHPSG13_1P_COLUMN_256_0[5]/RM_IHPSG13_1P_BITKIT_16x2_SRAM_1[1]/A_RWL<3>
+ RM_IHPSG13_1P_COLUMN_256_0[5]/RM_IHPSG13_1P_BITKIT_16x2_SRAM_1[1]/A_LWL<12> RM_IHPSG13_1P_COLUMN_256_0[5]/RM_IHPSG13_1P_BITKIT_16x2_SRAM_0[1]/A_RWL<4>
+ RM_IHPSG13_1P_COLUMN_256_0[5]/RM_IHPSG13_1P_BITKIT_16x2_SRAM_3[0]/A_LWL<5> RM_IHPSG13_1P_COLUMN_256_0[5]/RM_IHPSG13_1P_BITKIT_16x2_SRAM_2[0]/A_LWL<6>
+ RM_IHPSG13_1P_COLUMN_256_0[5]/RM_IHPSG13_1P_BITKIT_16x2_SRAM_3[2]/A_LWL<14> RM_IHPSG13_1P_COLUMN_256_0[5]/RM_IHPSG13_1P_BITKIT_16x2_SRAM_1[0]/A_LWL<7>
+ RM_IHPSG13_1P_COLUMN_256_0[5]/RM_IHPSG13_1P_BITKIT_16x2_SRAM_3[1]/A_RWL<2> RM_IHPSG13_1P_COLUMN_256_0[5]/RM_IHPSG13_1P_BITKIT_16x2_SRAM_3[2]/A_RWL<11>
+ RM_IHPSG13_1P_COLUMN_256_0[5]/RM_IHPSG13_1P_BITKIT_16x2_SRAM_3[3]/A_RWL<13> RM_IHPSG13_1P_COLUMN_256_0[5]/RM_IHPSG13_1P_BITKIT_16x2_SRAM_0[0]/A_LWL<8>
+ RM_IHPSG13_1P_COLUMN_256_0[5]/RM_IHPSG13_1P_BITKIT_16x2_SRAM_2[3]/A_RWL<6> RM_IHPSG13_1P_COLUMN_256_0[5]/RM_IHPSG13_1P_BITKIT_16x2_SRAM_1[1]/A_RWL<4>
+ RM_IHPSG13_1P_COLUMN_256_0[5]/RM_IHPSG13_1P_BITKIT_16x2_SRAM_0[0]/A_RWL<1> RM_IHPSG13_1P_COLUMN_256_0[5]/RM_IHPSG13_1P_BITKIT_16x2_SRAM_1[1]/A_LWL<13>
+ RM_IHPSG13_1P_COLUMN_256_0[5]/RM_IHPSG13_1P_BITKIT_16x2_SRAM_1[0]/A_LWL<13> RM_IHPSG13_1P_COLUMN_256_0[5]/RM_IHPSG13_1P_BITKIT_16x2_SRAM_0[1]/A_RWL<5>
+ RM_IHPSG13_1P_COLUMN_256_0[5]/RM_IHPSG13_1P_BITKIT_16x2_SRAM_3[0]/A_LWL<6> RM_IHPSG13_1P_COLUMN_256_0[5]/RM_IHPSG13_1P_BITKIT_16x2_SRAM_2[3]/A_LWL<12>
+ RM_IHPSG13_1P_COLUMN_256_0[5]/RM_IHPSG13_1P_BITKIT_16x2_SRAM_1[1]/A_LWL<11> RM_IHPSG13_1P_COLUMN_256_0[5]/RM_IHPSG13_1P_BITKIT_16x2_SRAM_0[0]/A_RWL<8>
+ RM_IHPSG13_1P_COLUMN_256_0[5]/RM_IHPSG13_1P_BITKIT_16x2_SRAM_1[0]/A_LWL<0> RM_IHPSG13_1P_COLUMN_256_0[5]/RM_IHPSG13_1P_BITKIT_16x2_SRAM_0[3]/A_LWL<3>
+ RM_IHPSG13_1P_COLUMN_256_0[5]/RM_IHPSG13_1P_BITKIT_16x2_SRAM_2[1]/A_RWL<12> RM_IHPSG13_1P_COLUMN_256_0[5]/RM_IHPSG13_1P_BITKIT_16x2_SRAM_2[0]/A_RWL<9>
+ RM_IHPSG13_1P_COLUMN_256_0[5]/RM_IHPSG13_1P_BITKIT_16x2_SRAM_3[1]/A_RWL<3> RM_IHPSG13_1P_COLUMN_256_0[5]/RM_IHPSG13_1P_BITKIT_16x2_SRAM_2[3]/A_LWL<2>
+ RM_IHPSG13_1P_COLUMN_256_0[5]/RM_IHPSG13_1P_BITKIT_16x2_SRAM_3[3]/A_RWL<14> RM_IHPSG13_1P_COLUMN_256_0[5]/RM_IHPSG13_1P_BITKIT_16x2_SRAM_2[2]/A_RWL<10>
+ RM_IHPSG13_1P_COLUMN_256_0[5]/RM_IHPSG13_1P_BITKIT_16x2_SRAM_2[0]/A_LWL<5> RM_IHPSG13_1P_COLUMN_256_0[5]/RM_IHPSG13_1P_BITKIT_16x2_SRAM_3[3]/A_LWL<4>
+ RM_IHPSG13_1P_COLUMN_256_0[5]/RM_IHPSG13_1P_BITKIT_16x2_SRAM_2[1]/A_RWL<3> RM_IHPSG13_1P_COLUMN_256_0[5]/RM_IHPSG13_1P_BITKIT_16x2_SRAM_3[0]/A_LWL<7>
+ RM_IHPSG13_1P_COLUMN_256_0[5]/RM_IHPSG13_1P_BITKIT_16x2_SRAM_0[0]/A_LWL<10> RM_IHPSG13_1P_COLUMN_256_0[5]/RM_IHPSG13_1P_BITKIT_16x2_SRAM_1[1]/A_LWL<0>
+ RM_IHPSG13_1P_COLUMN_256_0[5]/RM_IHPSG13_1P_BITKIT_16x2_SRAM_2[0]/A_LWL<8> RM_IHPSG13_1P_COLUMN_256_0[5]/RM_IHPSG13_1P_BITKIT_16x2_SRAM_3[1]/A_LWL<14>
+ RM_IHPSG13_1P_COLUMN_256_0[5]/RM_IHPSG13_1P_BITKIT_16x2_SRAM_1[2]/A_LWL<11> RM_IHPSG13_1P_COLUMN_256_0[5]/RM_IHPSG13_1P_BITKIT_16x2_SRAM_2[1]/A_RWL<14>
+ RM_IHPSG13_1P_COLUMN_256_0[5]/RM_IHPSG13_1P_BITKIT_16x2_SRAM_0[1]/A_LWL<1> RM_IHPSG13_1P_COLUMN_256_0[5]/RM_IHPSG13_1P_BITKIT_16x2_SRAM_1[0]/A_LWL<9>
+ RM_IHPSG13_1P_COLUMN_256_0[5]/RM_IHPSG13_1P_BITKIT_16x2_SRAM_3[1]/A_RWL<4> RM_IHPSG13_1P_COLUMN_256_0[5]/RM_IHPSG13_1P_BITKIT_16x2_SRAM_1[0]/A_RWL<0>
+ RM_IHPSG13_1P_COLUMN_256_0[5]/RM_IHPSG13_1P_BITKIT_16x2_SRAM_3[1]/A_RWL<11> RM_IHPSG13_1P_COLUMN_256_0[5]/RM_IHPSG13_1P_BITKIT_16x2_SRAM_3[3]/A_RWL<15>
+ RM_IHPSG13_1P_COLUMN_256_0[5]/RM_IHPSG13_1P_BITKIT_16x2_SRAM_0[3]/A_RWL<6> RM_IHPSG13_1P_COLUMN_256_0[5]/RM_IHPSG13_1P_BITKIT_16x2_SRAM_2[1]/A_RWL<5>
+ RM_IHPSG13_1P_COLUMN_256_0[5]/RM_IHPSG13_1P_BITKIT_16x2_SRAM_2[2]/A_RWL<11> RM_IHPSG13_1P_COLUMN_256_0[5]/RM_IHPSG13_1P_BITKIT_16x2_SRAM_3[0]/A_RWL<1>
+ RM_IHPSG13_1P_COLUMN_256_0[5]/RM_IHPSG13_1P_BITKIT_16x2_SRAM_3[3]/A_RWL<5> RM_IHPSG13_1P_COLUMN_256_0[5]/RM_IHPSG13_1P_BITKIT_16x2_SRAM_1[1]/A_RWL<6>
+ RM_IHPSG13_1P_COLUMN_256_0[5]/RM_IHPSG13_1P_BITKIT_16x2_SRAM_3[0]/A_RWL<8> RM_IHPSG13_1P_COLUMN_256_0[5]/RM_IHPSG13_1P_BITKIT_16x2_SRAM_1[1]/A_LWL<15>
+ RM_IHPSG13_1P_COLUMN_256_0[5]/RM_IHPSG13_1P_BITKIT_16x2_SRAM_0[1]/A_RWL<7> RM_IHPSG13_1P_COLUMN_256_0[5]/RM_IHPSG13_1P_BITKIT_16x2_SRAM_3[3]/A_LWL<3>
+ RM_IHPSG13_1P_COLUMN_256_0[5]/RM_IHPSG13_1P_BITKIT_16x2_SRAM_0[0]/A_LWL<11> RM_IHPSG13_1P_COLUMN_256_0[5]/RM_IHPSG13_1P_BITKIT_16x2_SRAM_2[2]/A_LWL<12>
+ RM_IHPSG13_1P_COLUMN_256_0[5]/RM_IHPSG13_1P_BITKIT_16x2_SRAM_1[0]/A_LWL<11> RM_IHPSG13_1P_COLUMN_256_0[5]/RM_IHPSG13_1P_BITKIT_16x2_SRAM_1[2]/A_LWL<12>
+ RM_IHPSG13_1P_COLUMN_256_0[5]/RM_IHPSG13_1P_BITKIT_16x2_SRAM_3[2]/A_RWL<14> RM_IHPSG13_1P_COLUMN_256_0[5]/RM_IHPSG13_1P_BITKIT_16x2_SRAM_3[1]/A_RWL<5>
+ RM_IHPSG13_1P_COLUMN_256_0[5]/RM_IHPSG13_1P_BITKIT_16x2_SRAM_0[0]/A_LWL<5> RM_IHPSG13_1P_COLUMN_256_0[5]/RM_IHPSG13_1P_BITKIT_16x2_SRAM_1[3]/A_LWL<4>
+ RM_IHPSG13_1P_COLUMN_256_0[5]/RM_IHPSG13_1P_BITKIT_16x2_SRAM_0[1]/A_RWL<1> RM_IHPSG13_1P_COLUMN_256_0[5]/RM_IHPSG13_1P_BITKIT_16x2_SRAM_0[1]/A_RWL<3>
+ RM_IHPSG13_1P_COLUMN_256_0[5]/RM_IHPSG13_1P_BITKIT_16x2_SRAM_3[1]/A_LWL<0> RM_IHPSG13_1P_COLUMN_256_0[5]/RM_IHPSG13_1P_BITKIT_16x2_SRAM_2[0]/A_RWL<3>
+ RM_IHPSG13_1P_COLUMN_256_0[5]/RM_IHPSG13_1P_BITKIT_16x2_SRAM_2[3]/A_LWL<9> RM_IHPSG13_1P_COLUMN_256_0[5]/RM_IHPSG13_1P_BITKIT_16x2_SRAM_2[1]/A_LWL<1>
+ RM_IHPSG13_1P_COLUMN_256_0[5]/RM_IHPSG13_1P_BITKIT_16x2_SRAM_3[0]/A_LWL<9> RM_IHPSG13_1P_COLUMN_256_0[5]/RM_IHPSG13_1P_BITKIT_16x2_SRAM_0[1]/A_RWL<8>
+ RM_IHPSG13_1P_COLUMN_256_0[5]/RM_IHPSG13_1P_BITKIT_16x2_SRAM_1[1]/A_LWL<14> RM_IHPSG13_1P_COLUMN_256_0[5]/RM_IHPSG13_1P_BITKIT_16x2_SRAM_0[0]/A_LWL<2>
+ RM_IHPSG13_1P_COLUMN_256_0[5]/RM_IHPSG13_1P_BITKIT_16x2_SRAM_2[2]/A_RWL<12> RM_IHPSG13_1P_COLUMN_256_0[5]/RM_IHPSG13_1P_BITKIT_16x2_SRAM_1[1]/A_LWL<2>
+ RM_IHPSG13_1P_COLUMN_256_0[5]/RM_IHPSG13_1P_BITKIT_16x2_SRAM_0[3]/A_LWL<6> RM_IHPSG13_1P_COLUMN_256_0[5]/RM_IHPSG13_1P_BITKIT_16x2_SRAM_3[0]/A_LWL<14>
+ RM_IHPSG13_1P_COLUMN_256_0[5]/RM_IHPSG13_1P_BITKIT_16x2_SRAM_1[2]/A_LWL<13> RM_IHPSG13_1P_COLUMN_256_0[5]/RM_IHPSG13_1P_BITKIT_16x2_SRAM_0[1]/A_LWL<3>
+ RM_IHPSG13_1P_COLUMN_256_0[5]/RM_IHPSG13_1P_BITKIT_16x2_SRAM_1[0]/A_RWL<12> RM_IHPSG13_1P_COLUMN_256_0[5]/RM_IHPSG13_1P_BITKIT_16x2_SRAM_3[1]/A_RWL<6>
+ RM_IHPSG13_1P_COLUMN_256_0[5]/RM_IHPSG13_1P_BITKIT_16x2_SRAM_3[0]/A_RWL<11> RM_IHPSG13_1P_COLUMN_256_0[5]/RM_IHPSG13_1P_BITKIT_16x2_SRAM_3[3]/A_LWL<1>
+ RM_IHPSG13_1P_COLUMN_256_0[5]/RM_IHPSG13_1P_BITKIT_16x2_SRAM_2[1]/A_RWL<7> RM_IHPSG13_1P_COLUMN_256_0[5]/RM_IHPSG13_1P_BITKIT_16x2_SRAM_2[1]/A_RWL<6>
+ RM_IHPSG13_1P_COLUMN_256_0[5]/RM_IHPSG13_1P_BITKIT_16x2_SRAM_0[2]/A_RWL<0> RM_IHPSG13_1P_COLUMN_256_0[5]/RM_IHPSG13_1P_BITKIT_16x2_SRAM_2[3]/A_RWL<10>
+ RM_IHPSG13_1P_COLUMN_256_0[5]/RM_IHPSG13_1P_BITKIT_16x2_SRAM_2[1]/A_LWL<2> RM_IHPSG13_1P_COLUMN_256_0[5]/RM_IHPSG13_1P_BITKIT_16x2_SRAM_0[0]/A_LWL<13>
+ RM_IHPSG13_1P_COLUMN_256_0[5]/RM_IHPSG13_1P_BITKIT_16x2_SRAM_2[1]/A_LWL<12> RM_IHPSG13_1P_COLUMN_256_0[5]/RM_IHPSG13_1P_BITKIT_16x2_SRAM_1[1]/A_RWL<0>
+ RM_IHPSG13_1P_COLUMN_256_0[5]/RM_IHPSG13_1P_BITKIT_16x2_SRAM_1[2]/A_LWL<14> RM_IHPSG13_1P_COLUMN_256_0[5]/RM_IHPSG13_1P_BITKIT_16x2_SRAM_1[0]/A_RWL<5>
+ RM_IHPSG13_1P_COLUMN_256_0[5]/RM_IHPSG13_1P_BITKIT_16x2_SRAM_0[1]/A_LWL<10> RM_IHPSG13_1P_COLUMN_256_0[5]/RM_IHPSG13_1P_BITKIT_16x2_SRAM_0[1]/A_LWL<4>
+ RM_IHPSG13_1P_COLUMN_256_0[5]/RM_IHPSG13_1P_BITKIT_16x2_SRAM_3[1]/A_RWL<14> RM_IHPSG13_1P_COLUMN_256_0[5]/RM_IHPSG13_1P_BITKIT_16x2_SRAM_3[1]/A_RWL<1>
+ RM_IHPSG13_1P_COLUMN_256_0[5]/RM_IHPSG13_1P_BITKIT_16x2_SRAM_1[0]/A_RWL<13> RM_IHPSG13_1P_COLUMN_256_0[5]/RM_IHPSG13_1P_BITKIT_16x2_SRAM_1[3]/A_LWL<11>
+ RM_IHPSG13_1P_COLUMN_256_0[5]/RM_IHPSG13_1P_BITKIT_16x2_SRAM_2[1]/A_RWL<8> RM_IHPSG13_1P_COLUMN_256_0[5]/RM_IHPSG13_1P_BITKIT_16x2_SRAM_1[0]/A_LWL<3>
+ RM_IHPSG13_1P_COLUMN_256_0[5]/RM_IHPSG13_1P_BITKIT_16x2_SRAM_2[2]/A_RWL<14> RM_IHPSG13_1P_COLUMN_256_0[5]/RM_IHPSG13_1P_BITKIT_16x2_SRAM_1[3]/A_LWL<7>
+ RM_IHPSG13_1P_COLUMN_256_0[5]/RM_IHPSG13_1P_BITKIT_16x2_SRAM_0[0]/A_RWL<3> RM_IHPSG13_1P_COLUMN_256_0[5]/RM_IHPSG13_1P_BITKIT_16x2_SRAM_0[3]/A_LWL<9>
+ RM_IHPSG13_1P_COLUMN_256_0[5]/RM_IHPSG13_1P_BITKIT_16x2_SRAM_3[0]/A_LWL<2> RM_IHPSG13_1P_COLUMN_256_0[5]/RM_IHPSG13_1P_BITKIT_16x2_SRAM_1[1]/A_RWL<9>
+ RM_IHPSG13_1P_COLUMN_256_0[5]/RM_IHPSG13_1P_BITKIT_16x2_SRAM_3[3]/A_LWL<6> RM_IHPSG13_1P_COLUMN_256_0[5]/RM_IHPSG13_1P_BITKIT_16x2_SRAM_2[2]/A_LWL<9>
+ RM_IHPSG13_1P_COLUMN_256_0[5]/RM_IHPSG13_1P_BITKIT_16x2_SRAM_2[1]/A_LWL<3> RM_IHPSG13_1P_COLUMN_256_0[5]/RM_IHPSG13_1P_BITKIT_16x2_SRAM_0[0]/A_LWL<14>
+ RM_IHPSG13_1P_COLUMN_256_0[5]/RM_IHPSG13_1P_BITKIT_16x2_SRAM_1[0]/A_LWL<14> RM_IHPSG13_1P_COLUMN_256_0[5]/RM_IHPSG13_1P_BITKIT_16x2_SRAM_2[3]/A_LWL<15>
+ RM_IHPSG13_1P_COLUMN_256_0[5]/RM_IHPSG13_1P_BITKIT_16x2_SRAM_1[2]/A_LWL<15> RM_IHPSG13_1P_COLUMN_256_0[5]/RM_IHPSG13_1P_BITKIT_16x2_SRAM_0[1]/A_LWL<11>
+ RM_IHPSG13_1P_COLUMN_256_0[5]/RM_IHPSG13_1P_BITKIT_16x2_SRAM_0[1]/A_LWL<5> RM_IHPSG13_1P_COLUMN_256_0[5]/RM_IHPSG13_1P_BITKIT_16x2_SRAM_1[0]/A_RWL<11>
+ RM_IHPSG13_1P_COLUMN_256_0[5]/RM_IHPSG13_1P_BITKIT_16x2_SRAM_2[2]/A_RWL<0> RM_IHPSG13_1P_COLUMN_256_0[5]/RM_IHPSG13_1P_BITKIT_16x2_SRAM_1[3]/A_LWL<1>
+ RM_IHPSG13_1P_COLUMN_256_0[5]/RM_IHPSG13_1P_BITKIT_16x2_SRAM_3[1]/A_RWL<8> RM_IHPSG13_1P_COLUMN_256_0[5]/RM_IHPSG13_1P_BITKIT_16x2_SRAM_0[2]/A_RWL<1>
+ RM_IHPSG13_1P_COLUMN_256_0[5]/RM_IHPSG13_1P_BITKIT_16x2_SRAM_3[3]/A_LWL<10> RM_IHPSG13_1P_COLUMN_256_0[5]/RM_IHPSG13_1P_BITKIT_16x2_SRAM_1[3]/A_LWL<12>
+ RM_IHPSG13_1P_COLUMN_256_0[5]/RM_IHPSG13_1P_BITKIT_16x2_SRAM_1[2]/A_RWL<1> RM_IHPSG13_1P_COLUMN_256_0[5]/RM_IHPSG13_1P_BITKIT_16x2_SRAM_0[1]/A_RWL<6>
+ RM_IHPSG13_1P_COLUMN_256_0[5]/RM_IHPSG13_1P_BITKIT_16x2_SRAM_2[1]/A_RWL<9> RM_IHPSG13_1P_COLUMN_256_0[5]/RM_IHPSG13_1P_BITKIT_16x2_SRAM_1[1]/A_RWL<11>
+ RM_IHPSG13_1P_COLUMN_256_0[5]/RM_IHPSG13_1P_BITKIT_16x2_SRAM_2[0]/A_RWL<6> RM_IHPSG13_1P_COLUMN_256_0[5]/RM_IHPSG13_1P_BITKIT_16x2_SRAM_3[1]/A_LWL<3>
+ RM_IHPSG13_1P_COLUMN_256_0[5]/RM_IHPSG13_1P_BITKIT_16x2_SRAM_2[0]/A_RWL<4> RM_IHPSG13_1P_COLUMN_256_0[5]/RM_IHPSG13_1P_BITKIT_16x2_SRAM_3[3]/A_RWL<7>
+ RM_IHPSG13_1P_COLUMN_256_0[5]/RM_IHPSG13_1P_BITKIT_16x2_SRAM_0[1]/A_LWL<2> RM_IHPSG13_1P_COLUMN_256_0[5]/RM_IHPSG13_1P_BITKIT_16x2_SRAM_2[3]/A_RWL<12>
+ RM_IHPSG13_1P_COLUMN_256_0[5]/RM_IHPSG13_1P_BITKIT_16x2_SRAM_2[1]/A_LWL<4> RM_IHPSG13_1P_COLUMN_256_0[5]/RM_IHPSG13_1P_BITKIT_16x2_SRAM_2[0]/A_LWL<12>
+ RM_IHPSG13_1P_COLUMN_256_0[5]/RM_IHPSG13_1P_BITKIT_16x2_SRAM_1[1]/A_LWL<5> RM_IHPSG13_1P_COLUMN_256_0[5]/RM_IHPSG13_1P_BITKIT_16x2_SRAM_3[2]/A_RWL<0>
+ RM_IHPSG13_1P_COLUMN_256_0[5]/RM_IHPSG13_1P_BITKIT_16x2_SRAM_0[1]/A_LWL<12> RM_IHPSG13_1P_COLUMN_256_0[5]/RM_IHPSG13_1P_BITKIT_16x2_SRAM_0[1]/A_LWL<6>
+ RM_IHPSG13_1P_COLUMN_256_0[5]/RM_IHPSG13_1P_BITKIT_16x2_SRAM_2[2]/A_RWL<1> RM_IHPSG13_1P_COLUMN_256_0[5]/RM_IHPSG13_1P_BITKIT_16x2_SRAM_3[0]/A_RWL<14>
+ RM_IHPSG13_1P_COLUMN_256_0[5]/RM_IHPSG13_1P_BITKIT_16x2_SRAM_1[0]/A_RWL<15> RM_IHPSG13_1P_COLUMN_256_0[5]/RM_IHPSG13_1P_BITKIT_16x2_SRAM_1[1]/A_LWL<4>
+ RM_IHPSG13_1P_COLUMN_256_0[5]/RM_IHPSG13_1P_BITKIT_16x2_SRAM_1[3]/A_LWL<13> RM_IHPSG13_1P_COLUMN_256_0[5]/RM_IHPSG13_1P_BITKIT_16x2_SRAM_1[2]/A_RWL<2>
+ RM_IHPSG13_1P_COLUMN_256_0[5]/RM_IHPSG13_1P_BITKIT_16x2_SRAM_1[1]/A_RWL<12> RM_IHPSG13_1P_COLUMN_256_0[5]/RM_IHPSG13_1P_BITKIT_16x2_SRAM_3[0]/A_LWL<4>
+ RM_IHPSG13_1P_COLUMN_256_0[5]/RM_IHPSG13_1P_BITKIT_16x2_SRAM_0[2]/A_LWL<9> RM_IHPSG13_1P_COLUMN_256_0[5]/RM_IHPSG13_1P_BITKIT_16x2_SRAM_0[2]/A_RWL<3>
+ RM_IHPSG13_1P_COLUMN_256_0[5]/RM_IHPSG13_1P_BITKIT_16x2_SRAM_3[1]/A_LWL<4> RM_IHPSG13_1P_COLUMN_256_0[5]/RM_IHPSG13_1P_BITKIT_16x2_SRAM_2[1]/A_LWL<5>
+ RM_IHPSG13_1P_COLUMN_256_0[5]/RM_IHPSG13_1P_BITKIT_16x2_SRAM_1[2]/A_RWL<0> RM_IHPSG13_1P_COLUMN_256_0[5]/RM_IHPSG13_1P_BITKIT_16x2_SRAM_1[1]/A_RWL<5>
+ RM_IHPSG13_1P_COLUMN_256_0[5]/RM_IHPSG13_1P_BITKIT_16x2_SRAM_2[2]/A_LWL<15> RM_IHPSG13_1P_COLUMN_256_0[5]/RM_IHPSG13_1P_BITKIT_16x2_SRAM_3[2]/A_RWL<1>
+ RM_IHPSG13_1P_COLUMN_256_0[5]/RM_IHPSG13_1P_BITKIT_16x2_SRAM_1[3]/A_LWL<10> RM_IHPSG13_1P_COLUMN_256_0[5]/RM_IHPSG13_1P_BITKIT_16x2_SRAM_0[1]/A_LWL<7>
+ RM_IHPSG13_1P_COLUMN_256_0[5]/RM_IHPSG13_1P_BITKIT_16x2_SRAM_1[1]/A_LWL<3> RM_IHPSG13_1P_COLUMN_256_0[5]/RM_IHPSG13_1P_BITKIT_16x2_SRAM_1[0]/A_LWL<6>
+ RM_IHPSG13_1P_COLUMN_256_0[5]/RM_IHPSG13_1P_BITKIT_16x2_SRAM_3[2]/A_LWL<10> RM_IHPSG13_1P_COLUMN_256_0[5]/RM_IHPSG13_1P_BITKIT_16x2_SRAM_1[3]/A_LWL<14>
+ RM_IHPSG13_1P_COLUMN_256_0[5]/RM_IHPSG13_1P_BITKIT_16x2_SRAM_3[1]/A_LWL<1> RM_IHPSG13_1P_COLUMN_256_0[5]/RM_IHPSG13_1P_BITKIT_16x2_SRAM_3[1]/A_LWL<2>
+ RM_IHPSG13_1P_COLUMN_256_0[5]/RM_IHPSG13_1P_BITKIT_16x2_SRAM_0[0]/A_RWL<6> RM_IHPSG13_1P_COLUMN_256_0[5]/RM_IHPSG13_1P_BITKIT_16x2_SRAM_1[2]/A_RWL<3>
+ RM_IHPSG13_1P_COLUMN_256_0[5]/RM_IHPSG13_1P_BITKIT_16x2_SRAM_0[2]/A_LWL<10> RM_IHPSG13_1P_COLUMN_256_0[5]/RM_IHPSG13_1P_BITKIT_16x2_SRAM_1[3]/A_RWL<7>
+ RM_IHPSG13_1P_COLUMN_256_0[5]/RM_IHPSG13_1P_BITKIT_16x2_SRAM_1[1]/A_RWL<13> RM_IHPSG13_1P_COLUMN_256_0[5]/RM_IHPSG13_1P_BITKIT_16x2_SRAM_0[2]/A_RWL<4>
+ RM_IHPSG13_1P_COLUMN_256_0[5]/RM_IHPSG13_1P_BITKIT_16x2_SRAM_0[0]/A_LWL<12> RM_IHPSG13_1P_COLUMN_256_0[5]/RM_IHPSG13_1P_BITKIT_16x2_SRAM_2[3]/A_RWL<14>
+ RM_IHPSG13_1P_COLUMN_256_0[5]/RM_IHPSG13_1P_BITKIT_16x2_SRAM_2[1]/A_LWL<6> RM_IHPSG13_1P_COLUMN_256_0[5]/RM_IHPSG13_1P_BITKIT_16x2_SRAM_1[1]/A_LWL<7>
+ RM_IHPSG13_1P_COLUMN_256_0[5]/RM_IHPSG13_1P_BITKIT_16x2_SRAM_3[2]/A_RWL<2> RM_IHPSG13_1P_COLUMN_256_0[5]/RM_IHPSG13_1P_BITKIT_16x2_SRAM_1[0]/A_RWL<14>
+ RM_IHPSG13_1P_COLUMN_256_0[5]/RM_IHPSG13_1P_BITKIT_16x2_SRAM_0[1]/A_LWL<14> RM_IHPSG13_1P_COLUMN_256_0[5]/RM_IHPSG13_1P_BITKIT_16x2_SRAM_0[1]/A_LWL<8>
+ RM_IHPSG13_1P_COLUMN_256_0[5]/RM_IHPSG13_1P_BITKIT_16x2_SRAM_2[2]/A_RWL<3> RM_IHPSG13_1P_COLUMN_256_0[5]/RM_IHPSG13_1P_BITKIT_16x2_SRAM_1[3]/A_LWL<15>
+ RM_IHPSG13_1P_COLUMN_256_0[5]/RM_IHPSG13_1P_BITKIT_16x2_SRAM_1[0]/A_LWL<4> RM_IHPSG13_1P_COLUMN_256_0[5]/RM_IHPSG13_1P_BITKIT_16x2_SRAM_1[2]/A_RWL<4>
+ RM_IHPSG13_1P_COLUMN_256_0[5]/RM_IHPSG13_1P_BITKIT_16x2_SRAM_0[3]/A_RWL<8> RM_IHPSG13_1P_COLUMN_256_0[5]/RM_IHPSG13_1P_BITKIT_16x2_SRAM_2[1]/A_RWL<4>
+ RM_IHPSG13_1P_COLUMN_256_0[5]/RM_IHPSG13_1P_BITKIT_16x2_SRAM_2[0]/A_RWL<13> RM_IHPSG13_1P_COLUMN_256_0[5]/RM_IHPSG13_1P_BITKIT_16x2_SRAM_3[3]/A_RWL<10>
+ RM_IHPSG13_1P_COLUMN_256_0[5]/RM_IHPSG13_1P_BITKIT_16x2_SRAM_1[1]/A_RWL<14> RM_IHPSG13_1P_COLUMN_256_0[5]/RM_IHPSG13_1P_BITKIT_16x2_SRAM_0[2]/A_RWL<5>
+ RM_IHPSG13_1P_COLUMN_256_0[5]/RM_IHPSG13_1P_BITKIT_16x2_SRAM_0[0]/A_RWL<10> RM_IHPSG13_1P_COLUMN_256_0[5]/RM_IHPSG13_1P_BITKIT_16x2_SRAM_2[3]/A_RWL<9>
+ RM_IHPSG13_1P_COLUMN_256_0[5]/RM_IHPSG13_1P_BITKIT_16x2_SRAM_3[1]/A_LWL<6> RM_IHPSG13_1P_COLUMN_256_0[5]/RM_IHPSG13_1P_BITKIT_16x2_SRAM_2[0]/A_LWL<9>
+ RM_IHPSG13_1P_COLUMN_256_0[5]/RM_IHPSG13_1P_BITKIT_16x2_SRAM_2[3]/A_RWL<15> RM_IHPSG13_1P_COLUMN_256_0[5]/RM_IHPSG13_1P_BITKIT_16x2_SRAM_1[2]/A_RWL<11>
+ RM_IHPSG13_1P_COLUMN_256_0[5]/RM_IHPSG13_1P_BITKIT_16x2_SRAM_2[0]/A_LWL<7> RM_IHPSG13_1P_COLUMN_256_0[5]/RM_IHPSG13_1P_BITKIT_16x2_SRAM_3[3]/A_LWL<8>
+ RM_IHPSG13_1P_COLUMN_256_0[5]/RM_IHPSG13_1P_BITKIT_16x2_SRAM_2[1]/A_LWL<15> RM_IHPSG13_1P_COLUMN_256_0[5]/RM_IHPSG13_1P_BITKIT_16x2_SRAM_1[2]/A_LWL<10>
+ RM_IHPSG13_1P_COLUMN_256_0[5]/RM_IHPSG13_1P_BITKIT_16x2_SRAM_0[1]/A_LWL<9> RM_IHPSG13_1P_COLUMN_256_0[5]/RM_IHPSG13_1P_BITKIT_16x2_SRAM_1[1]/A_LWL<1>
+ RM_IHPSG13_1P_COLUMN_256_0[5]/RM_IHPSG13_1P_BITKIT_16x2_SRAM_3[1]/A_LWL<10> RM_IHPSG13_1P_COLUMN_256_0[5]/RM_IHPSG13_1P_BITKIT_16x2_SRAM_3[0]/A_LWL<1>
+ RM_IHPSG13_1P_COLUMN_256_0[5]/RM_IHPSG13_1P_BITKIT_16x2_SRAM_0[2]/A_LWL<12> RM_IHPSG13_1P_COLUMN_256_0[5]/RM_IHPSG13_1P_BITKIT_16x2_SRAM_1[1]/A_RWL<15>
+ RM_IHPSG13_1P_COLUMN_256_0[5]/RM_IHPSG13_1P_BITKIT_16x2_SRAM_0[2]/A_RWL<6> RM_IHPSG13_1P_COLUMN_256_0[5]/RM_IHPSG13_1P_BITKIT_16x2_SRAM_0[0]/A_RWL<11>
+ RM_IHPSG13_1P_COLUMN_256_0[5]/RM_IHPSG13_1P_BITKIT_16x2_SRAM_3[1]/A_LWL<7> RM_IHPSG13_1P_COLUMN_256_0[5]/RM_IHPSG13_1P_BITKIT_16x2_SRAM_3[1]/A_RWL<7>
+ RM_IHPSG13_1P_COLUMN_256_0[5]/RM_IHPSG13_1P_BITKIT_16x2_SRAM_1[2]/A_RWL<5> RM_IHPSG13_1P_COLUMN_256_0[5]/RM_IHPSG13_1P_BITKIT_16x2_SRAM_1[2]/A_LWL<0>
+ RM_IHPSG13_1P_COLUMN_256_0[5]/RM_IHPSG13_1P_BITKIT_16x2_SRAM_1[2]/A_RWL<12> RM_IHPSG13_1P_COLUMN_256_0[5]/RM_IHPSG13_1P_BITKIT_16x2_SRAM_2[1]/A_LWL<8>
+ RM_IHPSG13_1P_COLUMN_256_0[5]/RM_IHPSG13_1P_BITKIT_16x2_SRAM_2[2]/A_RWL<2> RM_IHPSG13_1P_COLUMN_256_0[5]/RM_IHPSG13_1P_BITKIT_16x2_SRAM_0[2]/A_LWL<1>
+ RM_IHPSG13_1P_COLUMN_256_0[5]/RM_IHPSG13_1P_BITKIT_16x2_SRAM_0[3]/A_RWL<15> RM_IHPSG13_1P_COLUMN_256_0[5]/RM_IHPSG13_1P_BITKIT_16x2_SRAM_1[1]/A_LWL<9>
+ RM_IHPSG13_1P_COLUMN_256_0[5]/RM_IHPSG13_1P_BITKIT_16x2_SRAM_3[2]/A_RWL<4> RM_IHPSG13_1P_COLUMN_256_0[5]/RM_IHPSG13_1P_BITKIT_16x2_SRAM_3[0]/A_RWL<12>
+ RM_IHPSG13_1P_COLUMN_256_0[5]/RM_IHPSG13_1P_BITKIT_16x2_SRAM_1[1]/A_LWL<6> RM_IHPSG13_1P_COLUMN_256_0[5]/RM_IHPSG13_1P_BITKIT_16x2_SRAM_3[3]/A_RWL<8>
+ RM_IHPSG13_1P_COLUMN_256_0[5]/RM_IHPSG13_1P_BITKIT_16x2_SRAM_2[2]/A_RWL<15> RM_IHPSG13_1P_COLUMN_256_0[5]/RM_IHPSG13_1P_BITKIT_16x2_SRAM_2[2]/A_RWL<5>
+ RM_IHPSG13_1P_COLUMN_256_0[5]/RM_IHPSG13_1P_BITKIT_16x2_SRAM_1[2]/A_RWL<6> RM_IHPSG13_1P_COLUMN_256_0[5]/RM_IHPSG13_1P_BITKIT_16x2_SRAM_3[2]/A_RWL<10>
+ RM_IHPSG13_1P_COLUMN_256_0[5]/RM_IHPSG13_1P_BITKIT_16x2_SRAM_0[0]/A_LWL<9> RM_IHPSG13_1P_COLUMN_256_0[5]/RM_IHPSG13_1P_BITKIT_16x2_SRAM_0[0]/A_RWL<12>
+ RM_IHPSG13_1P_COLUMN_256_0[5]/RM_IHPSG13_1P_BITKIT_16x2_SRAM_0[2]/A_RWL<7> RM_IHPSG13_1P_COLUMN_256_0[5]/RM_IHPSG13_1P_BITKIT_16x2_SRAM_1[3]/A_LWL<8>
+ RM_IHPSG13_1P_COLUMN_256_0[5]/RM_IHPSG13_1P_BITKIT_16x2_SRAM_0[3]/A_LWL<10> RM_IHPSG13_1P_COLUMN_256_0[5]/RM_IHPSG13_1P_BITKIT_16x2_SRAM_1[2]/A_LWL<1>
+ RM_IHPSG13_1P_COLUMN_256_0[5]/RM_IHPSG13_1P_BITKIT_16x2_SRAM_2[1]/A_LWL<9> RM_IHPSG13_1P_COLUMN_256_0[5]/RM_IHPSG13_1P_BITKIT_16x2_SRAM_1[2]/A_RWL<13>
+ RM_IHPSG13_1P_COLUMN_256_0[5]/RM_IHPSG13_1P_BITKIT_16x2_SRAM_0[1]/A_LWL<15> RM_IHPSG13_1P_COLUMN_256_0[5]/RM_IHPSG13_1P_BITKIT_16x2_SRAM_3[2]/A_LWL<8>
+ RM_IHPSG13_1P_COLUMN_256_0[5]/RM_IHPSG13_1P_BITKIT_16x2_SRAM_0[2]/A_LWL<2> RM_IHPSG13_1P_COLUMN_256_0[5]/RM_IHPSG13_1P_BITKIT_16x2_SRAM_2[0]/A_LWL<15>
+ RM_IHPSG13_1P_COLUMN_256_0[5]/RM_IHPSG13_1P_BITKIT_16x2_SRAM_2[3]/A_LWL<13> RM_IHPSG13_1P_COLUMN_256_0[5]/RM_IHPSG13_1P_BITKIT_16x2_SRAM_3[2]/A_RWL<5>
+ RM_IHPSG13_1P_COLUMN_256_0[5]/RM_IHPSG13_1P_BITKIT_16x2_SRAM_1[3]/A_RWL<10> RM_IHPSG13_1P_COLUMN_256_0[5]/RM_IHPSG13_1P_BITKIT_16x2_SRAM_1[1]/A_LWL<10>
+ RM_IHPSG13_1P_COLUMN_256_0[5]/RM_IHPSG13_1P_BITKIT_16x2_SRAM_0[0]/A_RWL<9> RM_IHPSG13_1P_COLUMN_256_0[5]/RM_IHPSG13_1P_BITKIT_16x2_SRAM_1[0]/A_LWL<1>
+ RM_IHPSG13_1P_COLUMN_256_0[5]/RM_IHPSG13_1P_BITKIT_16x2_SRAM_2[2]/A_RWL<6> RM_IHPSG13_1P_COLUMN_256_0[5]/RM_IHPSG13_1P_BITKIT_16x2_SRAM_2[2]/A_RWL<4>
+ RM_IHPSG13_1P_COLUMN_256_0[5]/RM_IHPSG13_1P_BITKIT_16x2_SRAM_2[1]/A_RWL<13> RM_IHPSG13_1P_COLUMN_256_0[5]/RM_IHPSG13_1P_BITKIT_16x2_SRAM_0[3]/A_LWL<2>
+ RM_IHPSG13_1P_COLUMN_256_0[5]/RM_IHPSG13_1P_BITKIT_16x2_SRAM_2[3]/A_LWL<0> RM_IHPSG13_1P_COLUMN_256_0[5]/RM_IHPSG13_1P_BITKIT_16x2_SRAM_3[2]/A_LWL<0>
+ RM_IHPSG13_1P_COLUMN_256_0[5]/RM_IHPSG13_1P_BITKIT_16x2_SRAM_1[2]/A_RWL<7> RM_IHPSG13_1P_COLUMN_256_0[5]/RM_IHPSG13_1P_BITKIT_16x2_SRAM_0[2]/A_LWL<14>
+ RM_IHPSG13_1P_COLUMN_256_0[5]/RM_IHPSG13_1P_BITKIT_16x2_SRAM_1[1]/A_RWL<7> RM_IHPSG13_1P_COLUMN_256_0[5]/RM_IHPSG13_1P_BITKIT_16x2_SRAM_2[2]/A_LWL<1>
+ RM_IHPSG13_1P_COLUMN_256_0[5]/RM_IHPSG13_1P_BITKIT_16x2_SRAM_0[0]/A_RWL<13> RM_IHPSG13_1P_COLUMN_256_0[5]/RM_IHPSG13_1P_BITKIT_16x2_SRAM_2[1]/A_LWL<7>
+ RM_IHPSG13_1P_COLUMN_256_0[5]/RM_IHPSG13_1P_BITKIT_16x2_SRAM_0[2]/A_RWL<8> RM_IHPSG13_1P_COLUMN_256_0[5]/RM_IHPSG13_1P_BITKIT_16x2_SRAM_3[0]/A_RWL<7>
+ RM_IHPSG13_1P_COLUMN_256_0[5]/RM_IHPSG13_1P_BITKIT_16x2_SRAM_3[1]/A_LWL<9> RM_IHPSG13_1P_COLUMN_256_0[5]/RM_IHPSG13_1P_BITKIT_16x2_SRAM_3[3]/A_LWL<5>
+ RM_IHPSG13_1P_COLUMN_256_0[5]/RM_IHPSG13_1P_BITKIT_16x2_SRAM_0[2]/A_RWL<2> RM_IHPSG13_1P_COLUMN_256_0[5]/RM_IHPSG13_1P_BITKIT_16x2_SRAM_1[2]/A_LWL<2>
+ RM_IHPSG13_1P_COLUMN_256_0[5]/RM_IHPSG13_1P_BITKIT_16x2_SRAM_1[2]/A_RWL<14> RM_IHPSG13_1P_COLUMN_256_0[5]/RM_IHPSG13_1P_BITKIT_16x2_SRAM_2[1]/A_RWL<2>
+ RM_IHPSG13_1P_COLUMN_256_0[5]/RM_IHPSG13_1P_BITKIT_16x2_SRAM_0[1]/A_RWL<10> RM_IHPSG13_1P_COLUMN_256_0[5]/RM_IHPSG13_1P_BITKIT_16x2_SRAM_0[2]/A_LWL<3>
+ RM_IHPSG13_1P_COLUMN_256_0[5]/RM_IHPSG13_1P_BITKIT_16x2_SRAM_0[2]/A_RWL<15> RM_IHPSG13_1P_COLUMN_256_0[5]/RM_IHPSG13_1P_BITKIT_16x2_SRAM_3[2]/A_RWL<6>
+ RM_IHPSG13_1P_COLUMN_256_0[5]/RM_IHPSG13_1P_BITKIT_16x2_SRAM_1[3]/A_RWL<11> RM_IHPSG13_1P_COLUMN_256_0[5]/RM_IHPSG13_1P_BITKIT_16x2_SRAM_2[1]/A_RWL<15>
+ RM_IHPSG13_1P_COLUMN_256_0[5]/RM_IHPSG13_1P_BITKIT_16x2_SRAM_2[2]/A_RWL<7> RM_IHPSG13_1P_COLUMN_256_0[5]/RM_IHPSG13_1P_BITKIT_16x2_SRAM_1[2]/A_RWL<10>
+ RM_IHPSG13_1P_COLUMN_256_0[5]/RM_IHPSG13_1P_BITKIT_16x2_SRAM_0[3]/A_RWL<0> RM_IHPSG13_1P_COLUMN_256_0[5]/RM_IHPSG13_1P_BITKIT_16x2_SRAM_1[0]/A_RWL<1>
+ RM_IHPSG13_1P_COLUMN_256_0[5]/RM_IHPSG13_1P_BITKIT_16x2_SRAM_3[2]/A_LWL<1> RM_IHPSG13_1P_COLUMN_256_0[5]/RM_IHPSG13_1P_BITKIT_16x2_SRAM_1[2]/A_RWL<8>
+ RM_IHPSG13_1P_COLUMN_256_0[5]/RM_IHPSG13_1P_BITKIT_16x2_SRAM_0[2]/A_LWL<15> RM_IHPSG13_1P_COLUMN_256_0[5]/RM_IHPSG13_1P_BITKIT_16x2_SRAM_1[3]/A_RWL<5>
+ RM_IHPSG13_1P_COLUMN_256_0[5]/RM_IHPSG13_1P_BITKIT_16x2_SRAM_3[1]/A_RWL<10> RM_IHPSG13_1P_COLUMN_256_0[5]/RM_IHPSG13_1P_BITKIT_16x2_SRAM_0[0]/A_RWL<14>
+ RM_IHPSG13_1P_COLUMN_256_0[5]/RM_IHPSG13_1P_BITKIT_16x2_SRAM_2[2]/A_LWL<2> RM_IHPSG13_1P_COLUMN_256_0[5]/RM_IHPSG13_1P_BITKIT_16x2_SRAM_1[2]/A_LWL<8>
+ RM_IHPSG13_1P_COLUMN_256_0[5]/RM_IHPSG13_1P_BITKIT_16x2_SRAM_1[0]/A_RWL<8> RM_IHPSG13_1P_COLUMN_256_0[5]/RM_IHPSG13_1P_BITKIT_16x2_SRAM_0[3]/A_LWL<12>
+ RM_IHPSG13_1P_COLUMN_256_0[5]/RM_IHPSG13_1P_BITKIT_16x2_SRAM_1[2]/A_LWL<3> RM_IHPSG13_1P_COLUMN_256_0[5]/RM_IHPSG13_1P_BITKIT_16x2_SRAM_3[1]/A_LWL<8>
+ RM_IHPSG13_1P_COLUMN_256_0[5]/RM_IHPSG13_1P_BITKIT_16x2_SRAM_3[1]/A_RWL<12> RM_IHPSG13_1P_COLUMN_256_0[5]/RM_IHPSG13_1P_BITKIT_16x2_SRAM_1[3]/A_LWL<3>
+ RM_IHPSG13_1P_COLUMN_256_0[5]/RM_IHPSG13_1P_BITKIT_16x2_SRAM_1[2]/A_RWL<15> RM_IHPSG13_1P_COLUMN_256_0[5]/RM_IHPSG13_1P_BITKIT_16x2_SRAM_0[0]/A_LWL<15>
+ RM_IHPSG13_1P_COLUMN_256_0[5]/RM_IHPSG13_1P_BITKIT_16x2_SRAM_3[0]/A_RWL<9> RM_IHPSG13_1P_COLUMN_256_0[5]/RM_IHPSG13_1P_BITKIT_16x2_SRAM_0[1]/A_RWL<11>
+ RM_IHPSG13_1P_COLUMN_256_0[5]/RM_IHPSG13_1P_BITKIT_16x2_SRAM_3[3]/A_LWL<2> RM_IHPSG13_1P_COLUMN_256_0[5]/RM_IHPSG13_1P_BITKIT_16x2_SRAM_0[2]/A_LWL<4>
+ RM_IHPSG13_1P_COLUMN_256_0[5]/RM_IHPSG13_1P_BITKIT_16x2_SRAM_2[2]/A_LWL<13> RM_IHPSG13_1P_COLUMN_256_0[5]/RM_IHPSG13_1P_BITKIT_16x2_SRAM_3[2]/A_RWL<7>
+ RM_IHPSG13_1P_COLUMN_256_0[5]/RM_IHPSG13_1P_BITKIT_16x2_SRAM_1[3]/A_RWL<12> RM_IHPSG13_1P_COLUMN_256_0[5]/RM_IHPSG13_1P_BITKIT_16x2_SRAM_0[3]/A_LWL<0>
+ RM_IHPSG13_1P_COLUMN_256_0[5]/RM_IHPSG13_1P_BITKIT_16x2_SRAM_1[0]/A_LWL<10> RM_IHPSG13_1P_COLUMN_256_0[5]/RM_IHPSG13_1P_BITKIT_16x2_SRAM_1[3]/A_RWL<0>
+ RM_IHPSG13_1P_COLUMN_256_0[5]/RM_IHPSG13_1P_BITKIT_16x2_SRAM_2[2]/A_RWL<8> RM_IHPSG13_1P_COLUMN_256_0[5]/RM_IHPSG13_1P_BITKIT_16x2_SRAM_2[3]/A_LWL<11>
+ RM_IHPSG13_1P_COLUMN_256_0[5]/RM_IHPSG13_1P_BITKIT_16x2_SRAM_2[2]/A_LWL<0> RM_IHPSG13_1P_COLUMN_256_0[5]/RM_IHPSG13_1P_BITKIT_16x2_SRAM_0[3]/A_RWL<1>
+ RM_IHPSG13_1P_COLUMN_256_0[5]/RM_IHPSG13_1P_BITKIT_16x2_SRAM_3[2]/A_LWL<2> RM_IHPSG13_1P_COLUMN_256_0[5]/RM_IHPSG13_1P_BITKIT_16x2_SRAM_1[2]/A_RWL<9>
+ RM_IHPSG13_1P_COLUMN_256_0[5]/RM_IHPSG13_1P_BITKIT_16x2_SRAM_1[0]/A_RWL<7> RM_IHPSG13_1P_COLUMN_256_0[5]/RM_IHPSG13_1P_BITKIT_16x2_SRAM_1[3]/A_LWL<5>
+ RM_IHPSG13_1P_COLUMN_256_0[5]/RM_IHPSG13_1P_BITKIT_16x2_SRAM_2[2]/A_LWL<3> RM_IHPSG13_1P_COLUMN_256_0[5]/RM_IHPSG13_1P_BITKIT_16x2_SRAM_0[1]/A_RWL<2>
+ RM_IHPSG13_1P_COLUMN_256_0[5]/RM_IHPSG13_1P_BITKIT_16x2_SRAM_0[3]/A_LWL<13> RM_IHPSG13_1P_COLUMN_256_0[5]/RM_IHPSG13_1P_BITKIT_16x2_SRAM_1[2]/A_LWL<4>
+ RM_IHPSG13_1P_COLUMN_256_0[5]/RM_IHPSG13_1P_BITKIT_16x2_SRAM_2[0]/A_RWL<2> RM_IHPSG13_1P_COLUMN_256_0[5]/RM_IHPSG13_1P_BITKIT_16x2_SRAM_0[1]/A_RWL<12>
+ RM_IHPSG13_1P_COLUMN_256_0[5]/RM_IHPSG13_1P_BITKIT_16x2_SRAM_2[0]/A_RWL<0> RM_IHPSG13_1P_COLUMN_256_0[5]/RM_IHPSG13_1P_BITKIT_16x2_SRAM_3[3]/A_RWL<3>
+ RM_IHPSG13_1P_COLUMN_256_0[5]/RM_IHPSG13_1P_BITKIT_16x2_SRAM_0[1]/A_RWL<9> RM_IHPSG13_1P_COLUMN_256_0[5]/RM_IHPSG13_1P_BITKIT_16x2_SRAM_0[2]/A_LWL<5>
+ RM_IHPSG13_1P_COLUMN_256_0[5]/RM_IHPSG13_1P_BITKIT_16x2_SRAM_2[3]/A_RWL<4> RM_IHPSG13_1P_COLUMN_256_0[5]/RM_IHPSG13_1P_BITKIT_16x2_SRAM_2[3]/A_RWL<0>
+ RM_IHPSG13_1P_COLUMN_256_0[5]/RM_IHPSG13_1P_BITKIT_16x2_SRAM_3[2]/A_RWL<8> RM_IHPSG13_1P_COLUMN_256_0[5]/RM_IHPSG13_1P_BITKIT_16x2_SRAM_2[2]/A_RWL<13>
+ RM_IHPSG13_1P_COLUMN_256_0[5]/RM_IHPSG13_1P_BITKIT_16x2_SRAM_1[3]/A_RWL<13> RM_IHPSG13_1P_COLUMN_256_0[5]/RM_IHPSG13_1P_BITKIT_16x2_SRAM_2[0]/A_RWL<15>
+ RM_IHPSG13_1P_COLUMN_256_0[5]/RM_IHPSG13_1P_BITKIT_16x2_SRAM_1[3]/A_RWL<1> RM_IHPSG13_1P_COLUMN_256_0[5]/RM_IHPSG13_1P_BITKIT_16x2_SRAM_2[2]/A_RWL<9>
+ RM_IHPSG13_1P_COLUMN_256_0[5]/RM_IHPSG13_1P_BITKIT_16x2_SRAM_1[1]/A_RWL<10> RM_IHPSG13_1P_COLUMN_256_0[5]/RM_IHPSG13_1P_BITKIT_16x2_SRAM_2[2]/A_LWL<7>
+ RM_IHPSG13_1P_COLUMN_256_0[5]/RM_IHPSG13_1P_BITKIT_16x2_SRAM_0[3]/A_RWL<2> RM_IHPSG13_1P_COLUMN_256_0[5]/RM_IHPSG13_1P_BITKIT_16x2_SRAM_3[2]/A_LWL<3>
+ RM_IHPSG13_1P_COLUMN_256_0[5]/RM_IHPSG13_1P_BITKIT_16x2_SRAM_3[0]/A_RWL<10> RM_IHPSG13_1P_COLUMN_256_0[5]/RM_IHPSG13_1P_BITKIT_16x2_SRAM_2[2]/A_LWL<4>
+ RM_IHPSG13_1P_COLUMN_256_0[5]/RM_IHPSG13_1P_BITKIT_16x2_SRAM_1[1]/A_LWL<8> RM_IHPSG13_1P_COLUMN_256_0[5]/RM_IHPSG13_1P_BITKIT_16x2_SRAM_0[3]/A_LWL<14>
+ RM_IHPSG13_1P_COLUMN_256_0[5]/RM_IHPSG13_1P_BITKIT_16x2_SRAM_3[0]/A_LWL<8> RM_IHPSG13_1P_COLUMN_256_0[5]/RM_IHPSG13_1P_BITKIT_16x2_SRAM_3[3]/A_RWL<0>
+ RM_IHPSG13_1P_COLUMN_256_0[5]/RM_IHPSG13_1P_BITKIT_16x2_SRAM_0[2]/A_LWL<13> RM_IHPSG13_1P_COLUMN_256_0[5]/RM_IHPSG13_1P_BITKIT_16x2_SRAM_0[1]/A_RWL<13>
+ RM_IHPSG13_1P_COLUMN_256_0[5]/RM_IHPSG13_1P_BITKIT_16x2_SRAM_3[0]/A_LWL<10> RM_IHPSG13_1P_COLUMN_256_0[5]/RM_IHPSG13_1P_BITKIT_16x2_SRAM_2[1]/A_LWL<13>
+ RM_IHPSG13_1P_COLUMN_256_0[5]/RM_IHPSG13_1P_BITKIT_16x2_SRAM_0[2]/A_LWL<6> RM_IHPSG13_1P_COLUMN_256_0[5]/RM_IHPSG13_1P_BITKIT_16x2_SRAM_2[3]/A_RWL<1>
+ RM_IHPSG13_1P_COLUMN_256_0[5]/RM_IHPSG13_1P_BITKIT_16x2_SRAM_3[2]/A_RWL<9> RM_IHPSG13_1P_COLUMN_256_0[5]/RM_IHPSG13_1P_BITKIT_16x2_SRAM_0[3]/A_LWL<11>
+ RM_IHPSG13_1P_COLUMN_256_0[5]/RM_IHPSG13_1P_BITKIT_16x2_SRAM_1[3]/A_RWL<14> RM_IHPSG13_1P_COLUMN_256_0[5]/RM_IHPSG13_1P_BITKIT_16x2_SRAM_0[2]/A_LWL<0>
+ RM_IHPSG13_1P_COLUMN_256_0[5]/RM_IHPSG13_1P_BITKIT_16x2_SRAM_1[1]/A_RWL<1> RM_IHPSG13_1P_COLUMN_256_0[5]/RM_IHPSG13_1P_BITKIT_16x2_SRAM_0[2]/A_RWL<10>
+ RM_IHPSG13_1P_COLUMN_256_0[5]/RM_IHPSG13_1P_BITKIT_16x2_SRAM_1[3]/A_RWL<2> RM_IHPSG13_1P_COLUMN_256_0[5]/RM_IHPSG13_1P_BITKIT_16x2_SRAM_2[2]/A_LWL<11>
+ RM_IHPSG13_1P_COLUMN_256_0[5]/RM_IHPSG13_1P_BITKIT_16x2_SRAM_2[1]/A_LWL<0> RM_IHPSG13_1P_COLUMN_256_0[5]/RM_IHPSG13_1P_BITKIT_16x2_SRAM_0[3]/A_RWL<3>
+ RM_IHPSG13_1P_COLUMN_256_0[5]/RM_IHPSG13_1P_BITKIT_16x2_SRAM_3[2]/A_LWL<4> RM_IHPSG13_1P_COLUMN_256_0[5]/RM_IHPSG13_1P_BITKIT_16x2_SRAM_1[1]/A_RWL<8>
+ RM_IHPSG13_1P_COLUMN_256_0[5]/RM_IHPSG13_1P_BITKIT_16x2_SRAM_1[2]/A_LWL<5> RM_IHPSG13_1P_COLUMN_256_0[5]/RM_IHPSG13_1P_BITKIT_16x2_SRAM_1[0]/A_LWL<2>
+ RM_IHPSG13_1P_COLUMN_256_0[5]/RM_IHPSG13_1P_BITKIT_16x2_SRAM_3[2]/A_RWL<12> RM_IHPSG13_1P_COLUMN_256_0[5]/RM_IHPSG13_1P_BITKIT_16x2_SRAM_2[2]/A_LWL<5>
+ RM_IHPSG13_1P_COLUMN_256_0[5]/RM_IHPSG13_1P_BITKIT_16x2_SRAM_1[3]/A_LWL<6> RM_IHPSG13_1P_COLUMN_256_0[5]/RM_IHPSG13_1P_BITKIT_16x2_SRAM_3[1]/A_RWL<9>
+ RM_IHPSG13_1P_COLUMN_256_0[5]/RM_IHPSG13_1P_BITKIT_16x2_SRAM_3[1]/A_LWL<5> RM_IHPSG13_1P_COLUMN_256_0[5]/RM_IHPSG13_1P_BITKIT_16x2_SRAM_0[0]/A_RWL<2>
+ RM_IHPSG13_1P_COLUMN_256_0[5]/RM_IHPSG13_1P_BITKIT_16x2_SRAM_0[3]/A_LWL<15> RM_IHPSG13_1P_COLUMN_256_0[5]/RM_IHPSG13_1P_BITKIT_16x2_SRAM_1[2]/A_LWL<6>
+ RM_IHPSG13_1P_COLUMN_256_0[5]/RM_IHPSG13_1P_BITKIT_16x2_SRAM_3[3]/A_RWL<1> RM_IHPSG13_1P_COLUMN_256_0[5]/RM_IHPSG13_1P_BITKIT_16x2_SRAM_0[1]/A_RWL<14>
+ RM_IHPSG13_1P_COLUMN_256_0[5]/RM_IHPSG13_1P_BITKIT_16x2_SRAM_3[2]/A_RWL<3> RM_IHPSG13_1P_COLUMN_256_0[5]/RM_IHPSG13_1P_BITKIT_16x2_SRAM_3[0]/A_LWL<11>
+ RM_IHPSG13_1P_COLUMN_256_0[5]/RM_IHPSG13_1P_BITKIT_16x2_SRAM_0[2]/A_LWL<7> RM_IHPSG13_1P_COLUMN_256_0[5]/RM_IHPSG13_1P_BITKIT_16x2_SRAM_0[0]/A_RWL<15>
+ RM_IHPSG13_1P_COLUMN_256_0[5]/RM_IHPSG13_1P_BITKIT_16x2_SRAM_2[3]/A_RWL<2> RM_IHPSG13_1P_COLUMN_256_0[5]/RM_IHPSG13_1P_BITKIT_16x2_SRAM_2[3]/A_LWL<14>
+ RM_IHPSG13_1P_COLUMN_256_0[5]/RM_IHPSG13_1P_BITKIT_16x2_SRAM_1[3]/A_RWL<15> RM_IHPSG13_1P_COLUMN_256_0[5]/RM_IHPSG13_1P_BITKIT_16x2_SRAM_0[2]/A_RWL<11>
+ RM_IHPSG13_1P_COLUMN_256_0[5]/RM_IHPSG13_1P_BITKIT_16x2_SRAM_1[3]/A_RWL<3> RM_IHPSG13_1P_COLUMN_256_0[5]/RM_IHPSG13_1P_BITKIT_16x2_SRAM_1[0]/A_RWL<10>
+ RM_IHPSG13_1P_COLUMN_256_0[5]/RM_IHPSG13_1P_BITKIT_16x2_SRAM_0[3]/A_RWL<4> RM_IHPSG13_1P_COLUMN_256_0[5]/RM_IHPSG13_1P_BITKIT_16x2_SRAM_2[3]/A_RWL<11>
+ RM_IHPSG13_1P_COLUMN_256_0[5]/RM_IHPSG13_1P_BITKIT_16x2_SRAM_3[2]/A_LWL<5> RM_IHPSG13_1P_COLUMN_256_0[5]/RM_IHPSG13_1P_BITKIT_16x2_SRAM_0[0]/A_RWL<4>
+ RM_IHPSG13_1P_COLUMN_256_0[5]/RM_IHPSG13_1P_BITKIT_16x2_SRAM_2[2]/A_LWL<6> RM_IHPSG13_1P_COLUMN_256_0[5]/RM_IHPSG13_1P_BITKIT_16x2_SRAM_1[0]/A_LWL<8>
+ RM_IHPSG13_1P_COLUMN_256_0[5]/RM_IHPSG13_1P_BITKIT_16x2_SRAM_0[3]/A_RWL<12> RM_IHPSG13_1P_COLUMN_256_0[5]/RM_IHPSG13_1P_BITKIT_16x2_SRAM_2[1]/A_RWL<0>
+ RM_IHPSG13_1P_COLUMN_256_0[5]/RM_IHPSG13_1P_BITKIT_16x2_SRAM_3[3]/A_RWL<6> RM_IHPSG13_1P_COLUMN_256_0[5]/RM_IHPSG13_1P_BITKIT_16x2_SRAM_2[0]/A_RWL<5>
+ RM_IHPSG13_1P_COLUMN_256_0[5]/RM_IHPSG13_1P_BITKIT_16x2_SRAM_0[2]/A_RWL<9> RM_IHPSG13_1P_COLUMN_256_0[5]/RM_IHPSG13_1P_BITKIT_16x2_SRAM_1[2]/A_LWL<7>
+ RM_IHPSG13_1P_COLUMN_256_0[5]/RM_IHPSG13_1P_BITKIT_16x2_SRAM_0[1]/A_LWL<13> RM_IHPSG13_1P_COLUMN_256_0[5]/RM_IHPSG13_1P_BITKIT_16x2_SRAM_3[3]/A_RWL<2>
+ RM_IHPSG13_1P_COLUMN_256_0[5]/RM_IHPSG13_1P_BITKIT_16x2_SRAM_2[3]/A_RWL<13> RM_IHPSG13_1P_COLUMN_256_0[5]/RM_IHPSG13_1P_BITKIT_16x2_SRAM_0[1]/A_RWL<15>
+ RM_IHPSG13_1P_COLUMN_256_0[5]/RM_IHPSG13_1P_BITKIT_16x2_SRAM_3[0]/A_LWL<12> RM_IHPSG13_1P_COLUMN_256_0[5]/RM_IHPSG13_1P_BITKIT_16x2_SRAM_0[2]/A_LWL<8>
+ RM_IHPSG13_1P_COLUMN_256_0[5]/RM_IHPSG13_1P_BITKIT_16x2_SRAM_2[0]/A_LWL<13> RM_IHPSG13_1P_COLUMN_256_0[5]/RM_IHPSG13_1P_BITKIT_16x2_SRAM_2[3]/A_RWL<3>
+ RM_IHPSG13_1P_COLUMN_256_0[5]/RM_IHPSG13_1P_BITKIT_16x2_SRAM_0[2]/A_LWL<11> RM_IHPSG13_1P_COLUMN_256_0[5]/RM_IHPSG13_1P_BITKIT_16x2_SRAM_3[3]/A_LWL<12>
+ RM_IHPSG13_1P_COLUMN_256_0[5]/RM_IHPSG13_1P_BITKIT_16x2_SRAM_2[0]/A_LWL<3> RM_IHPSG13_1P_COLUMN_256_0[5]/RM_IHPSG13_1P_BITKIT_16x2_SRAM_0[1]/A_LWL<0>
+ RM_IHPSG13_1P_COLUMN_256_0[5]/RM_IHPSG13_1P_BITKIT_16x2_SRAM_2[3]/A_LWL<7> RM_IHPSG13_1P_COLUMN_256_0[5]/RM_IHPSG13_1P_BITKIT_16x2_SRAM_0[2]/A_RWL<12>
+ RM_IHPSG13_1P_COLUMN_256_0[5]/RM_IHPSG13_1P_BITKIT_16x2_SRAM_1[3]/A_RWL<4> RM_IHPSG13_1P_COLUMN_256_0[5]/RM_IHPSG13_1P_BITKIT_16x2_SRAM_2[1]/A_LWL<11>
+ RM_IHPSG13_1P_COLUMN_256_0[5]/RM_IHPSG13_1P_BITKIT_16x2_SRAM_2[0]/A_LWL<0> RM_IHPSG13_1P_COLUMN_256_0[7]/RM_IHPSG13_1P_BITKIT_16x2_SRAM_3[3]/VSS
+ RM_IHPSG13_1P_COLUMN_256_0[5]/RM_IHPSG13_1P_BITKIT_16x2_SRAM_0[3]/A_RWL<5> RM_IHPSG13_1P_COLUMN_256_0[7]/RM_IHPSG13_1P_BITKIT_16x2_SRAM_3[3]/VDD
+ RM_IHPSG13_1P_COLUMN_256_0[5]/RM_IHPSG13_1P_BITKIT_16x2_SRAM_3[2]/A_LWL<6> RM_IHPSG13_1P_COLUMN_256
XRM_IHPSG13_1P_COLUMN_256_0[6] RM_IHPSG13_1P_COLUMN_256_0[6]/RM_IHPSG13_1P_BITKIT_16x2_SRAM_0[0]/A_BLT_BOT<0>
+ RM_IHPSG13_1P_COLUMN_256_0[6]/RM_IHPSG13_1P_BITKIT_16x2_SRAM_0[0]/A_BLT_BOT<1> RM_IHPSG13_1P_COLUMN_256_0[6]/RM_IHPSG13_1P_BITKIT_16x2_SRAM_0[0]/A_BLC_BOT<0>
+ RM_IHPSG13_1P_COLUMN_256_0[6]/RM_IHPSG13_1P_BITKIT_16x2_SRAM_1[3]/A_RWL<6> RM_IHPSG13_1P_COLUMN_256_0[6]/RM_IHPSG13_1P_BITKIT_16x2_SRAM_0[3]/A_RWL<11>
+ RM_IHPSG13_1P_COLUMN_256_0[6]/RM_IHPSG13_1P_BITKIT_16x2_SRAM_0[0]/A_BLC_BOT<1> RM_IHPSG13_1P_COLUMN_256_0[6]/RM_IHPSG13_1P_BITKIT_16x2_SRAM_3[1]/A_LWL<12>
+ RM_IHPSG13_1P_COLUMN_256_0[6]/RM_IHPSG13_1P_BITKIT_16x2_SRAM_1[3]/A_RWL<8> RM_IHPSG13_1P_COLUMN_256_0[6]/RM_IHPSG13_1P_BITKIT_16x2_SRAM_0[3]/A_RWL<9>
+ RM_IHPSG13_1P_COLUMN_256_0[6]/RM_IHPSG13_1P_BITKIT_16x2_SRAM_0[3]/A_LWL<4> RM_IHPSG13_1P_COLUMN_256_0[6]/RM_IHPSG13_1P_BITKIT_16x2_SRAM_3[2]/A_LWL<9>
+ RM_IHPSG13_1P_COLUMN_256_0[6]/RM_IHPSG13_1P_BITKIT_16x2_SRAM_2[3]/A_LWL<1> RM_IHPSG13_1P_COLUMN_256_0[6]/RM_IHPSG13_1P_BITKIT_16x2_SRAM_0[3]/A_RWL<14>
+ RM_IHPSG13_1P_COLUMN_256_0[6]/RM_IHPSG13_1P_BITKIT_16x2_SRAM_0[2]/A_RWL<14> RM_IHPSG13_1P_COLUMN_256_0[6]/RM_IHPSG13_1P_BITKIT_16x2_SRAM_2[0]/A_LWL<11>
+ RM_IHPSG13_1P_COLUMN_256_0[6]/RM_IHPSG13_1P_BITKIT_16x2_SRAM_2[3]/A_LWL<4> RM_IHPSG13_1P_COLUMN_256_0[6]/RM_IHPSG13_1P_BITKIT_16x2_SRAM_3[2]/A_LWL<12>
+ RM_IHPSG13_1P_COLUMN_256_0[6]/RM_IHPSG13_1P_BITKIT_16x2_SRAM_1[2]/A_LWL<9> RM_IHPSG13_1P_COLUMN_256_0[6]/RM_IHPSG13_1P_BITKIT_16x2_SRAM_3[3]/A_RWL<9>
+ RM_IHPSG13_1P_COLUMN_256_0[6]/RM_IHPSG13_1P_BITKIT_16x2_SRAM_1[3]/A_LWL<2> RM_IHPSG13_1P_COLUMN_256_0[6]/RM_IHPSG13_1P_BITKIT_16x2_SRAM_0[3]/A_LWL<1>
+ RM_IHPSG13_1P_COLUMN_256_0[6]/RM_IHPSG13_1P_BITKIT_16x2_SRAM_2[3]/A_RWL<7> RM_IHPSG13_1P_COLUMN_256_0[6]/RM_IHPSG13_1P_BITKIT_16x2_SRAM_0[0]/A_RWL<0>
+ RM_IHPSG13_1P_COLUMN_256_0[6]/RM_IHPSG13_1P_BITKIT_16x2_SRAM_2[0]/A_RWL<1> RM_IHPSG13_1P_COLUMN_256_0[6]/RM_IHPSG13_1P_BITKIT_16x2_SRAM_0[2]/A_RWL<13>
+ RM_IHPSG13_1P_COLUMN_256_0[6]/RM_IHPSG13_1P_BITKIT_16x2_SRAM_2[3]/A_RWL<5> RM_IHPSG13_1P_COLUMN_256_0[6]/RM_IHPSG13_1P_BITKIT_16x2_SRAM_2[3]/A_LWL<3>
+ RM_IHPSG13_1P_COLUMN_256_0[6]/RM_IHPSG13_1P_BITKIT_16x2_SRAM_3[0]/A_RWL<13> RM_IHPSG13_1P_COLUMN_256_0[6]/RM_IHPSG13_1P_BITKIT_16x2_SRAM_1[0]/A_RWL<3>
+ RM_IHPSG13_1P_COLUMN_256_0[6]/RM_IHPSG13_1P_BITKIT_16x2_SRAM_3[1]/A_LWL<15> RM_IHPSG13_1P_COLUMN_256_0[6]/RM_IHPSG13_1P_BITKIT_16x2_SRAM_2[0]/A_LWL<14>
+ RM_IHPSG13_1P_COLUMN_256_0[6]/RM_IHPSG13_1P_BITKIT_16x2_SRAM_0[3]/A_RWL<7> RM_IHPSG13_1P_COLUMN_256_0[6]/RM_IHPSG13_1P_BITKIT_16x2_SRAM_3[0]/A_RWL<0>
+ RM_IHPSG13_1P_COLUMN_256_0[6]/RM_IHPSG13_1P_BITKIT_16x2_SRAM_3[2]/A_LWL<15> RM_IHPSG13_1P_COLUMN_256_0[6]/RM_IHPSG13_1P_BITKIT_16x2_SRAM_3[3]/A_RWL<4>
+ RM_IHPSG13_1P_COLUMN_256_0[6]/RM_IHPSG13_1P_BITKIT_16x2_SRAM_3[2]/A_LWL<7> RM_IHPSG13_1P_COLUMN_256_0[6]/RM_IHPSG13_1P_BITKIT_16x2_SRAM_0[0]/A_LWL<0>
+ RM_IHPSG13_1P_COLUMN_256_0[6]/RM_IHPSG13_1P_BITKIT_16x2_SRAM_1[3]/A_LWL<9> RM_IHPSG13_1P_COLUMN_256_0[6]/RM_IHPSG13_1P_BITKIT_16x2_SRAM_3[0]/A_RWL<3>
+ RM_IHPSG13_1P_COLUMN_256_0[6]/RM_IHPSG13_1P_BITKIT_16x2_SRAM_0[0]/A_RWL<5> RM_IHPSG13_1P_COLUMN_256_0[6]/RM_IHPSG13_1P_BITKIT_16x2_SRAM_0[3]/A_RWL<13>
+ RM_IHPSG13_1P_COLUMN_256_0[6]/RM_IHPSG13_1P_BITKIT_16x2_SRAM_2[3]/A_LWL<8> RM_IHPSG13_1P_COLUMN_256_0[6]/RM_IHPSG13_1P_BITKIT_16x2_SRAM_0[3]/A_LWL<7>
+ RM_IHPSG13_1P_COLUMN_256_0[6]/RM_IHPSG13_1P_BITKIT_16x2_SRAM_3[0]/A_LWL<15> RM_IHPSG13_1P_COLUMN_256_0[6]/RM_IHPSG13_1P_BITKIT_16x2_SRAM_3[3]/A_LWL<13>
+ RM_IHPSG13_1P_COLUMN_256_0[6]/RM_IHPSG13_1P_BITKIT_16x2_SRAM_2[3]/A_LWL<6> RM_IHPSG13_1P_COLUMN_256_0[6]/RM_IHPSG13_1P_BITKIT_16x2_SRAM_2[1]/A_LWL<10>
+ RM_IHPSG13_1P_COLUMN_256_0[6]/RM_IHPSG13_1P_BITKIT_16x2_SRAM_3[3]/A_LWL<0> RM_IHPSG13_1P_COLUMN_256_0[6]/RM_IHPSG13_1P_BITKIT_16x2_SRAM_3[0]/A_RWL<4>
+ RM_IHPSG13_1P_COLUMN_256_0[6]/RM_IHPSG13_1P_BITKIT_16x2_SRAM_2[2]/A_LWL<10> RM_IHPSG13_1P_COLUMN_256_0[6]/RM_IHPSG13_1P_BITKIT_16x2_SRAM_3[1]/A_RWL<13>
+ RM_IHPSG13_1P_COLUMN_256_0[6]/RM_IHPSG13_1P_BITKIT_16x2_SRAM_1[0]/A_RWL<6> RM_IHPSG13_1P_COLUMN_256_0[6]/RM_IHPSG13_1P_BITKIT_16x2_SRAM_3[3]/A_LWL<9>
+ RM_IHPSG13_1P_COLUMN_256_0[6]/RM_IHPSG13_1P_BITKIT_16x2_SRAM_1[0]/A_RWL<4> RM_IHPSG13_1P_COLUMN_256_0[6]/RM_IHPSG13_1P_BITKIT_16x2_SRAM_0[3]/A_RWL<10>
+ RM_IHPSG13_1P_COLUMN_256_0[6]/RM_IHPSG13_1P_BITKIT_16x2_SRAM_2[1]/A_LWL<14> RM_IHPSG13_1P_COLUMN_256_0[6]/RM_IHPSG13_1P_BITKIT_16x2_SRAM_3[0]/A_RWL<5>
+ RM_IHPSG13_1P_COLUMN_256_0[6]/RM_IHPSG13_1P_BITKIT_16x2_SRAM_0[3]/A_LWL<8> RM_IHPSG13_1P_COLUMN_256_0[6]/RM_IHPSG13_1P_BITKIT_16x2_SRAM_3[3]/A_LWL<7>
+ RM_IHPSG13_1P_COLUMN_256_0[6]/RM_IHPSG13_1P_BITKIT_16x2_SRAM_2[2]/A_LWL<8> RM_IHPSG13_1P_COLUMN_256_0[6]/RM_IHPSG13_1P_BITKIT_16x2_SRAM_3[3]/A_LWL<15>
+ RM_IHPSG13_1P_COLUMN_256_0[6]/RM_IHPSG13_1P_BITKIT_16x2_SRAM_3[2]/A_LWL<13> RM_IHPSG13_1P_COLUMN_256_0[6]/RM_IHPSG13_1P_BITKIT_16x2_SRAM_2[0]/A_LWL<1>
+ RM_IHPSG13_1P_COLUMN_256_0[6]/RM_IHPSG13_1P_BITKIT_16x2_SRAM_0[0]/A_LWL<1> RM_IHPSG13_1P_COLUMN_256_0[6]/RM_IHPSG13_1P_BITKIT_16x2_SRAM_1[3]/A_LWL<0>
+ RM_IHPSG13_1P_COLUMN_256_0[6]/RM_IHPSG13_1P_BITKIT_16x2_SRAM_2[0]/A_LWL<10> RM_IHPSG13_1P_COLUMN_256_0[6]/RM_IHPSG13_1P_BITKIT_16x2_SRAM_3[3]/A_LWL<11>
+ RM_IHPSG13_1P_COLUMN_256_0[6]/RM_IHPSG13_1P_BITKIT_16x2_SRAM_0[0]/A_LWL<3> RM_IHPSG13_1P_COLUMN_256_0[6]/RM_IHPSG13_1P_BITKIT_16x2_SRAM_3[0]/A_RWL<6>
+ RM_IHPSG13_1P_COLUMN_256_0[6]/RM_IHPSG13_1P_BITKIT_16x2_SRAM_2[3]/A_LWL<5> RM_IHPSG13_1P_COLUMN_256_0[6]/RM_IHPSG13_1P_BITKIT_16x2_SRAM_2[0]/A_RWL<7>
+ RM_IHPSG13_1P_COLUMN_256_0[6]/RM_IHPSG13_1P_BITKIT_16x2_SRAM_3[1]/A_RWL<15> RM_IHPSG13_1P_COLUMN_256_0[6]/RM_IHPSG13_1P_BITKIT_16x2_SRAM_0[1]/A_RWL<0>
+ RM_IHPSG13_1P_COLUMN_256_0[6]/RM_IHPSG13_1P_BITKIT_16x2_SRAM_3[0]/A_RWL<2> RM_IHPSG13_1P_COLUMN_256_0[6]/RM_IHPSG13_1P_BITKIT_16x2_SRAM_2[0]/A_RWL<11>
+ RM_IHPSG13_1P_COLUMN_256_0[6]/RM_IHPSG13_1P_BITKIT_16x2_SRAM_2[0]/A_LWL<2> RM_IHPSG13_1P_COLUMN_256_0[6]/RM_IHPSG13_1P_BITKIT_16x2_SRAM_3[0]/A_RWL<15>
+ RM_IHPSG13_1P_COLUMN_256_0[6]/RM_IHPSG13_1P_BITKIT_16x2_SRAM_0[0]/A_LWL<4> RM_IHPSG13_1P_COLUMN_256_0[6]/RM_IHPSG13_1P_BITKIT_16x2_SRAM_1[0]/A_LWL<12>
+ RM_IHPSG13_1P_COLUMN_256_0[6]/RM_IHPSG13_1P_BITKIT_16x2_SRAM_2[0]/A_RWL<8> RM_IHPSG13_1P_COLUMN_256_0[6]/RM_IHPSG13_1P_BITKIT_16x2_SRAM_1[0]/A_RWL<9>
+ RM_IHPSG13_1P_COLUMN_256_0[6]/RM_IHPSG13_1P_BITKIT_16x2_SRAM_3[1]/A_LWL<13> RM_IHPSG13_1P_COLUMN_256_0[6]/RM_IHPSG13_1P_BITKIT_16x2_SRAM_1[3]/A_RWL<9>
+ RM_IHPSG13_1P_COLUMN_256_0[6]/RM_IHPSG13_1P_BITKIT_16x2_SRAM_2[3]/A_LWL<10> RM_IHPSG13_1P_COLUMN_256_0[6]/RM_IHPSG13_1P_BITKIT_16x2_SRAM_3[2]/A_RWL<13>
+ RM_IHPSG13_1P_COLUMN_256_0[6]/RM_IHPSG13_1P_BITKIT_16x2_SRAM_3[2]/A_LWL<11> RM_IHPSG13_1P_COLUMN_256_0[6]/RM_IHPSG13_1P_BITKIT_16x2_SRAM_0[0]/A_RWL<7>
+ RM_IHPSG13_1P_COLUMN_256_0[6]/RM_IHPSG13_1P_BITKIT_16x2_SRAM_0[3]/A_LWL<5> RM_IHPSG13_1P_COLUMN_256_0[6]/RM_IHPSG13_1P_BITKIT_16x2_SRAM_1[0]/A_RWL<2>
+ RM_IHPSG13_1P_COLUMN_256_0[6]/RM_IHPSG13_1P_BITKIT_16x2_SRAM_2[2]/A_LWL<14> RM_IHPSG13_1P_COLUMN_256_0[6]/RM_IHPSG13_1P_BITKIT_16x2_SRAM_3[0]/A_LWL<3>
+ RM_IHPSG13_1P_COLUMN_256_0[6]/RM_IHPSG13_1P_BITKIT_16x2_SRAM_2[0]/A_LWL<4> RM_IHPSG13_1P_COLUMN_256_0[6]/RM_IHPSG13_1P_BITKIT_16x2_SRAM_3[3]/A_LWL<14>
+ RM_IHPSG13_1P_COLUMN_256_0[6]/RM_IHPSG13_1P_BITKIT_16x2_SRAM_2[1]/A_RWL<10> RM_IHPSG13_1P_COLUMN_256_0[6]/RM_IHPSG13_1P_BITKIT_16x2_SRAM_1[0]/A_LWL<5>
+ RM_IHPSG13_1P_COLUMN_256_0[6]/RM_IHPSG13_1P_BITKIT_16x2_SRAM_3[1]/A_RWL<0> RM_IHPSG13_1P_COLUMN_256_0[6]/RM_IHPSG13_1P_BITKIT_16x2_SRAM_2[0]/A_RWL<10>
+ RM_IHPSG13_1P_COLUMN_256_0[6]/RM_IHPSG13_1P_BITKIT_16x2_SRAM_2[0]/A_RWL<12> RM_IHPSG13_1P_COLUMN_256_0[6]/RM_IHPSG13_1P_BITKIT_16x2_SRAM_3[3]/A_RWL<11>
+ RM_IHPSG13_1P_COLUMN_256_0[6]/RM_IHPSG13_1P_BITKIT_16x2_SRAM_0[0]/A_LWL<6> RM_IHPSG13_1P_COLUMN_256_0[6]/RM_IHPSG13_1P_BITKIT_16x2_SRAM_2[1]/A_RWL<1>
+ RM_IHPSG13_1P_COLUMN_256_0[6]/RM_IHPSG13_1P_BITKIT_16x2_SRAM_2[3]/A_RWL<8> RM_IHPSG13_1P_COLUMN_256_0[6]/RM_IHPSG13_1P_BITKIT_16x2_SRAM_1[1]/A_RWL<2>
+ RM_IHPSG13_1P_COLUMN_256_0[6]/RM_IHPSG13_1P_BITKIT_16x2_SRAM_2[0]/A_RWL<14> RM_IHPSG13_1P_COLUMN_256_0[6]/RM_IHPSG13_1P_BITKIT_16x2_SRAM_3[0]/A_LWL<13>
+ RM_IHPSG13_1P_COLUMN_256_0[6]/RM_IHPSG13_1P_BITKIT_16x2_SRAM_3[2]/A_RWL<15> RM_IHPSG13_1P_COLUMN_256_0[6]/RM_IHPSG13_1P_BITKIT_16x2_SRAM_2[1]/A_RWL<11>
+ RM_IHPSG13_1P_COLUMN_256_0[6]/RM_IHPSG13_1P_BITKIT_16x2_SRAM_3[1]/A_LWL<11> RM_IHPSG13_1P_COLUMN_256_0[6]/RM_IHPSG13_1P_BITKIT_16x2_SRAM_3[0]/A_LWL<0>
+ RM_IHPSG13_1P_COLUMN_256_0[6]/RM_IHPSG13_1P_BITKIT_16x2_SRAM_3[3]/A_RWL<12> RM_IHPSG13_1P_COLUMN_256_0[6]/RM_IHPSG13_1P_BITKIT_16x2_SRAM_0[0]/A_LWL<7>
+ RM_IHPSG13_1P_COLUMN_256_0[6]/RM_IHPSG13_1P_BITKIT_16x2_SRAM_1[0]/A_LWL<15> RM_IHPSG13_1P_COLUMN_256_0[6]/RM_IHPSG13_1P_BITKIT_16x2_SRAM_1[1]/A_RWL<3>
+ RM_IHPSG13_1P_COLUMN_256_0[6]/RM_IHPSG13_1P_BITKIT_16x2_SRAM_1[1]/A_LWL<12> RM_IHPSG13_1P_COLUMN_256_0[6]/RM_IHPSG13_1P_BITKIT_16x2_SRAM_0[1]/A_RWL<4>
+ RM_IHPSG13_1P_COLUMN_256_0[6]/RM_IHPSG13_1P_BITKIT_16x2_SRAM_3[0]/A_LWL<5> RM_IHPSG13_1P_COLUMN_256_0[6]/RM_IHPSG13_1P_BITKIT_16x2_SRAM_2[0]/A_LWL<6>
+ RM_IHPSG13_1P_COLUMN_256_0[6]/RM_IHPSG13_1P_BITKIT_16x2_SRAM_3[2]/A_LWL<14> RM_IHPSG13_1P_COLUMN_256_0[6]/RM_IHPSG13_1P_BITKIT_16x2_SRAM_1[0]/A_LWL<7>
+ RM_IHPSG13_1P_COLUMN_256_0[6]/RM_IHPSG13_1P_BITKIT_16x2_SRAM_3[1]/A_RWL<2> RM_IHPSG13_1P_COLUMN_256_0[6]/RM_IHPSG13_1P_BITKIT_16x2_SRAM_3[2]/A_RWL<11>
+ RM_IHPSG13_1P_COLUMN_256_0[6]/RM_IHPSG13_1P_BITKIT_16x2_SRAM_3[3]/A_RWL<13> RM_IHPSG13_1P_COLUMN_256_0[6]/RM_IHPSG13_1P_BITKIT_16x2_SRAM_0[0]/A_LWL<8>
+ RM_IHPSG13_1P_COLUMN_256_0[6]/RM_IHPSG13_1P_BITKIT_16x2_SRAM_2[3]/A_RWL<6> RM_IHPSG13_1P_COLUMN_256_0[6]/RM_IHPSG13_1P_BITKIT_16x2_SRAM_1[1]/A_RWL<4>
+ RM_IHPSG13_1P_COLUMN_256_0[6]/RM_IHPSG13_1P_BITKIT_16x2_SRAM_0[0]/A_RWL<1> RM_IHPSG13_1P_COLUMN_256_0[6]/RM_IHPSG13_1P_BITKIT_16x2_SRAM_1[1]/A_LWL<13>
+ RM_IHPSG13_1P_COLUMN_256_0[6]/RM_IHPSG13_1P_BITKIT_16x2_SRAM_1[0]/A_LWL<13> RM_IHPSG13_1P_COLUMN_256_0[6]/RM_IHPSG13_1P_BITKIT_16x2_SRAM_0[1]/A_RWL<5>
+ RM_IHPSG13_1P_COLUMN_256_0[6]/RM_IHPSG13_1P_BITKIT_16x2_SRAM_3[0]/A_LWL<6> RM_IHPSG13_1P_COLUMN_256_0[6]/RM_IHPSG13_1P_BITKIT_16x2_SRAM_2[3]/A_LWL<12>
+ RM_IHPSG13_1P_COLUMN_256_0[6]/RM_IHPSG13_1P_BITKIT_16x2_SRAM_1[1]/A_LWL<11> RM_IHPSG13_1P_COLUMN_256_0[6]/RM_IHPSG13_1P_BITKIT_16x2_SRAM_0[0]/A_RWL<8>
+ RM_IHPSG13_1P_COLUMN_256_0[6]/RM_IHPSG13_1P_BITKIT_16x2_SRAM_1[0]/A_LWL<0> RM_IHPSG13_1P_COLUMN_256_0[6]/RM_IHPSG13_1P_BITKIT_16x2_SRAM_0[3]/A_LWL<3>
+ RM_IHPSG13_1P_COLUMN_256_0[6]/RM_IHPSG13_1P_BITKIT_16x2_SRAM_2[1]/A_RWL<12> RM_IHPSG13_1P_COLUMN_256_0[6]/RM_IHPSG13_1P_BITKIT_16x2_SRAM_2[0]/A_RWL<9>
+ RM_IHPSG13_1P_COLUMN_256_0[6]/RM_IHPSG13_1P_BITKIT_16x2_SRAM_3[1]/A_RWL<3> RM_IHPSG13_1P_COLUMN_256_0[6]/RM_IHPSG13_1P_BITKIT_16x2_SRAM_2[3]/A_LWL<2>
+ RM_IHPSG13_1P_COLUMN_256_0[6]/RM_IHPSG13_1P_BITKIT_16x2_SRAM_3[3]/A_RWL<14> RM_IHPSG13_1P_COLUMN_256_0[6]/RM_IHPSG13_1P_BITKIT_16x2_SRAM_2[2]/A_RWL<10>
+ RM_IHPSG13_1P_COLUMN_256_0[6]/RM_IHPSG13_1P_BITKIT_16x2_SRAM_2[0]/A_LWL<5> RM_IHPSG13_1P_COLUMN_256_0[6]/RM_IHPSG13_1P_BITKIT_16x2_SRAM_3[3]/A_LWL<4>
+ RM_IHPSG13_1P_COLUMN_256_0[6]/RM_IHPSG13_1P_BITKIT_16x2_SRAM_2[1]/A_RWL<3> RM_IHPSG13_1P_COLUMN_256_0[6]/RM_IHPSG13_1P_BITKIT_16x2_SRAM_3[0]/A_LWL<7>
+ RM_IHPSG13_1P_COLUMN_256_0[6]/RM_IHPSG13_1P_BITKIT_16x2_SRAM_0[0]/A_LWL<10> RM_IHPSG13_1P_COLUMN_256_0[6]/RM_IHPSG13_1P_BITKIT_16x2_SRAM_1[1]/A_LWL<0>
+ RM_IHPSG13_1P_COLUMN_256_0[6]/RM_IHPSG13_1P_BITKIT_16x2_SRAM_2[0]/A_LWL<8> RM_IHPSG13_1P_COLUMN_256_0[6]/RM_IHPSG13_1P_BITKIT_16x2_SRAM_3[1]/A_LWL<14>
+ RM_IHPSG13_1P_COLUMN_256_0[6]/RM_IHPSG13_1P_BITKIT_16x2_SRAM_1[2]/A_LWL<11> RM_IHPSG13_1P_COLUMN_256_0[6]/RM_IHPSG13_1P_BITKIT_16x2_SRAM_2[1]/A_RWL<14>
+ RM_IHPSG13_1P_COLUMN_256_0[6]/RM_IHPSG13_1P_BITKIT_16x2_SRAM_0[1]/A_LWL<1> RM_IHPSG13_1P_COLUMN_256_0[6]/RM_IHPSG13_1P_BITKIT_16x2_SRAM_1[0]/A_LWL<9>
+ RM_IHPSG13_1P_COLUMN_256_0[6]/RM_IHPSG13_1P_BITKIT_16x2_SRAM_3[1]/A_RWL<4> RM_IHPSG13_1P_COLUMN_256_0[6]/RM_IHPSG13_1P_BITKIT_16x2_SRAM_1[0]/A_RWL<0>
+ RM_IHPSG13_1P_COLUMN_256_0[6]/RM_IHPSG13_1P_BITKIT_16x2_SRAM_3[1]/A_RWL<11> RM_IHPSG13_1P_COLUMN_256_0[6]/RM_IHPSG13_1P_BITKIT_16x2_SRAM_3[3]/A_RWL<15>
+ RM_IHPSG13_1P_COLUMN_256_0[6]/RM_IHPSG13_1P_BITKIT_16x2_SRAM_0[3]/A_RWL<6> RM_IHPSG13_1P_COLUMN_256_0[6]/RM_IHPSG13_1P_BITKIT_16x2_SRAM_2[1]/A_RWL<5>
+ RM_IHPSG13_1P_COLUMN_256_0[6]/RM_IHPSG13_1P_BITKIT_16x2_SRAM_2[2]/A_RWL<11> RM_IHPSG13_1P_COLUMN_256_0[6]/RM_IHPSG13_1P_BITKIT_16x2_SRAM_3[0]/A_RWL<1>
+ RM_IHPSG13_1P_COLUMN_256_0[6]/RM_IHPSG13_1P_BITKIT_16x2_SRAM_3[3]/A_RWL<5> RM_IHPSG13_1P_COLUMN_256_0[6]/RM_IHPSG13_1P_BITKIT_16x2_SRAM_1[1]/A_RWL<6>
+ RM_IHPSG13_1P_COLUMN_256_0[6]/RM_IHPSG13_1P_BITKIT_16x2_SRAM_3[0]/A_RWL<8> RM_IHPSG13_1P_COLUMN_256_0[6]/RM_IHPSG13_1P_BITKIT_16x2_SRAM_1[1]/A_LWL<15>
+ RM_IHPSG13_1P_COLUMN_256_0[6]/RM_IHPSG13_1P_BITKIT_16x2_SRAM_0[1]/A_RWL<7> RM_IHPSG13_1P_COLUMN_256_0[6]/RM_IHPSG13_1P_BITKIT_16x2_SRAM_3[3]/A_LWL<3>
+ RM_IHPSG13_1P_COLUMN_256_0[6]/RM_IHPSG13_1P_BITKIT_16x2_SRAM_0[0]/A_LWL<11> RM_IHPSG13_1P_COLUMN_256_0[6]/RM_IHPSG13_1P_BITKIT_16x2_SRAM_2[2]/A_LWL<12>
+ RM_IHPSG13_1P_COLUMN_256_0[6]/RM_IHPSG13_1P_BITKIT_16x2_SRAM_1[0]/A_LWL<11> RM_IHPSG13_1P_COLUMN_256_0[6]/RM_IHPSG13_1P_BITKIT_16x2_SRAM_1[2]/A_LWL<12>
+ RM_IHPSG13_1P_COLUMN_256_0[6]/RM_IHPSG13_1P_BITKIT_16x2_SRAM_3[2]/A_RWL<14> RM_IHPSG13_1P_COLUMN_256_0[6]/RM_IHPSG13_1P_BITKIT_16x2_SRAM_3[1]/A_RWL<5>
+ RM_IHPSG13_1P_COLUMN_256_0[6]/RM_IHPSG13_1P_BITKIT_16x2_SRAM_0[0]/A_LWL<5> RM_IHPSG13_1P_COLUMN_256_0[6]/RM_IHPSG13_1P_BITKIT_16x2_SRAM_1[3]/A_LWL<4>
+ RM_IHPSG13_1P_COLUMN_256_0[6]/RM_IHPSG13_1P_BITKIT_16x2_SRAM_0[1]/A_RWL<1> RM_IHPSG13_1P_COLUMN_256_0[6]/RM_IHPSG13_1P_BITKIT_16x2_SRAM_0[1]/A_RWL<3>
+ RM_IHPSG13_1P_COLUMN_256_0[6]/RM_IHPSG13_1P_BITKIT_16x2_SRAM_3[1]/A_LWL<0> RM_IHPSG13_1P_COLUMN_256_0[6]/RM_IHPSG13_1P_BITKIT_16x2_SRAM_2[0]/A_RWL<3>
+ RM_IHPSG13_1P_COLUMN_256_0[6]/RM_IHPSG13_1P_BITKIT_16x2_SRAM_2[3]/A_LWL<9> RM_IHPSG13_1P_COLUMN_256_0[6]/RM_IHPSG13_1P_BITKIT_16x2_SRAM_2[1]/A_LWL<1>
+ RM_IHPSG13_1P_COLUMN_256_0[6]/RM_IHPSG13_1P_BITKIT_16x2_SRAM_3[0]/A_LWL<9> RM_IHPSG13_1P_COLUMN_256_0[6]/RM_IHPSG13_1P_BITKIT_16x2_SRAM_0[1]/A_RWL<8>
+ RM_IHPSG13_1P_COLUMN_256_0[6]/RM_IHPSG13_1P_BITKIT_16x2_SRAM_1[1]/A_LWL<14> RM_IHPSG13_1P_COLUMN_256_0[6]/RM_IHPSG13_1P_BITKIT_16x2_SRAM_0[0]/A_LWL<2>
+ RM_IHPSG13_1P_COLUMN_256_0[6]/RM_IHPSG13_1P_BITKIT_16x2_SRAM_2[2]/A_RWL<12> RM_IHPSG13_1P_COLUMN_256_0[6]/RM_IHPSG13_1P_BITKIT_16x2_SRAM_1[1]/A_LWL<2>
+ RM_IHPSG13_1P_COLUMN_256_0[6]/RM_IHPSG13_1P_BITKIT_16x2_SRAM_0[3]/A_LWL<6> RM_IHPSG13_1P_COLUMN_256_0[6]/RM_IHPSG13_1P_BITKIT_16x2_SRAM_3[0]/A_LWL<14>
+ RM_IHPSG13_1P_COLUMN_256_0[6]/RM_IHPSG13_1P_BITKIT_16x2_SRAM_1[2]/A_LWL<13> RM_IHPSG13_1P_COLUMN_256_0[6]/RM_IHPSG13_1P_BITKIT_16x2_SRAM_0[1]/A_LWL<3>
+ RM_IHPSG13_1P_COLUMN_256_0[6]/RM_IHPSG13_1P_BITKIT_16x2_SRAM_1[0]/A_RWL<12> RM_IHPSG13_1P_COLUMN_256_0[6]/RM_IHPSG13_1P_BITKIT_16x2_SRAM_3[1]/A_RWL<6>
+ RM_IHPSG13_1P_COLUMN_256_0[6]/RM_IHPSG13_1P_BITKIT_16x2_SRAM_3[0]/A_RWL<11> RM_IHPSG13_1P_COLUMN_256_0[6]/RM_IHPSG13_1P_BITKIT_16x2_SRAM_3[3]/A_LWL<1>
+ RM_IHPSG13_1P_COLUMN_256_0[6]/RM_IHPSG13_1P_BITKIT_16x2_SRAM_2[1]/A_RWL<7> RM_IHPSG13_1P_COLUMN_256_0[6]/RM_IHPSG13_1P_BITKIT_16x2_SRAM_2[1]/A_RWL<6>
+ RM_IHPSG13_1P_COLUMN_256_0[6]/RM_IHPSG13_1P_BITKIT_16x2_SRAM_0[2]/A_RWL<0> RM_IHPSG13_1P_COLUMN_256_0[6]/RM_IHPSG13_1P_BITKIT_16x2_SRAM_2[3]/A_RWL<10>
+ RM_IHPSG13_1P_COLUMN_256_0[6]/RM_IHPSG13_1P_BITKIT_16x2_SRAM_2[1]/A_LWL<2> RM_IHPSG13_1P_COLUMN_256_0[6]/RM_IHPSG13_1P_BITKIT_16x2_SRAM_0[0]/A_LWL<13>
+ RM_IHPSG13_1P_COLUMN_256_0[6]/RM_IHPSG13_1P_BITKIT_16x2_SRAM_2[1]/A_LWL<12> RM_IHPSG13_1P_COLUMN_256_0[6]/RM_IHPSG13_1P_BITKIT_16x2_SRAM_1[1]/A_RWL<0>
+ RM_IHPSG13_1P_COLUMN_256_0[6]/RM_IHPSG13_1P_BITKIT_16x2_SRAM_1[2]/A_LWL<14> RM_IHPSG13_1P_COLUMN_256_0[6]/RM_IHPSG13_1P_BITKIT_16x2_SRAM_1[0]/A_RWL<5>
+ RM_IHPSG13_1P_COLUMN_256_0[6]/RM_IHPSG13_1P_BITKIT_16x2_SRAM_0[1]/A_LWL<10> RM_IHPSG13_1P_COLUMN_256_0[6]/RM_IHPSG13_1P_BITKIT_16x2_SRAM_0[1]/A_LWL<4>
+ RM_IHPSG13_1P_COLUMN_256_0[6]/RM_IHPSG13_1P_BITKIT_16x2_SRAM_3[1]/A_RWL<14> RM_IHPSG13_1P_COLUMN_256_0[6]/RM_IHPSG13_1P_BITKIT_16x2_SRAM_3[1]/A_RWL<1>
+ RM_IHPSG13_1P_COLUMN_256_0[6]/RM_IHPSG13_1P_BITKIT_16x2_SRAM_1[0]/A_RWL<13> RM_IHPSG13_1P_COLUMN_256_0[6]/RM_IHPSG13_1P_BITKIT_16x2_SRAM_1[3]/A_LWL<11>
+ RM_IHPSG13_1P_COLUMN_256_0[6]/RM_IHPSG13_1P_BITKIT_16x2_SRAM_2[1]/A_RWL<8> RM_IHPSG13_1P_COLUMN_256_0[6]/RM_IHPSG13_1P_BITKIT_16x2_SRAM_1[0]/A_LWL<3>
+ RM_IHPSG13_1P_COLUMN_256_0[6]/RM_IHPSG13_1P_BITKIT_16x2_SRAM_2[2]/A_RWL<14> RM_IHPSG13_1P_COLUMN_256_0[6]/RM_IHPSG13_1P_BITKIT_16x2_SRAM_1[3]/A_LWL<7>
+ RM_IHPSG13_1P_COLUMN_256_0[6]/RM_IHPSG13_1P_BITKIT_16x2_SRAM_0[0]/A_RWL<3> RM_IHPSG13_1P_COLUMN_256_0[6]/RM_IHPSG13_1P_BITKIT_16x2_SRAM_0[3]/A_LWL<9>
+ RM_IHPSG13_1P_COLUMN_256_0[6]/RM_IHPSG13_1P_BITKIT_16x2_SRAM_3[0]/A_LWL<2> RM_IHPSG13_1P_COLUMN_256_0[6]/RM_IHPSG13_1P_BITKIT_16x2_SRAM_1[1]/A_RWL<9>
+ RM_IHPSG13_1P_COLUMN_256_0[6]/RM_IHPSG13_1P_BITKIT_16x2_SRAM_3[3]/A_LWL<6> RM_IHPSG13_1P_COLUMN_256_0[6]/RM_IHPSG13_1P_BITKIT_16x2_SRAM_2[2]/A_LWL<9>
+ RM_IHPSG13_1P_COLUMN_256_0[6]/RM_IHPSG13_1P_BITKIT_16x2_SRAM_2[1]/A_LWL<3> RM_IHPSG13_1P_COLUMN_256_0[6]/RM_IHPSG13_1P_BITKIT_16x2_SRAM_0[0]/A_LWL<14>
+ RM_IHPSG13_1P_COLUMN_256_0[6]/RM_IHPSG13_1P_BITKIT_16x2_SRAM_1[0]/A_LWL<14> RM_IHPSG13_1P_COLUMN_256_0[6]/RM_IHPSG13_1P_BITKIT_16x2_SRAM_2[3]/A_LWL<15>
+ RM_IHPSG13_1P_COLUMN_256_0[6]/RM_IHPSG13_1P_BITKIT_16x2_SRAM_1[2]/A_LWL<15> RM_IHPSG13_1P_COLUMN_256_0[6]/RM_IHPSG13_1P_BITKIT_16x2_SRAM_0[1]/A_LWL<11>
+ RM_IHPSG13_1P_COLUMN_256_0[6]/RM_IHPSG13_1P_BITKIT_16x2_SRAM_0[1]/A_LWL<5> RM_IHPSG13_1P_COLUMN_256_0[6]/RM_IHPSG13_1P_BITKIT_16x2_SRAM_1[0]/A_RWL<11>
+ RM_IHPSG13_1P_COLUMN_256_0[6]/RM_IHPSG13_1P_BITKIT_16x2_SRAM_2[2]/A_RWL<0> RM_IHPSG13_1P_COLUMN_256_0[6]/RM_IHPSG13_1P_BITKIT_16x2_SRAM_1[3]/A_LWL<1>
+ RM_IHPSG13_1P_COLUMN_256_0[6]/RM_IHPSG13_1P_BITKIT_16x2_SRAM_3[1]/A_RWL<8> RM_IHPSG13_1P_COLUMN_256_0[6]/RM_IHPSG13_1P_BITKIT_16x2_SRAM_0[2]/A_RWL<1>
+ RM_IHPSG13_1P_COLUMN_256_0[6]/RM_IHPSG13_1P_BITKIT_16x2_SRAM_3[3]/A_LWL<10> RM_IHPSG13_1P_COLUMN_256_0[6]/RM_IHPSG13_1P_BITKIT_16x2_SRAM_1[3]/A_LWL<12>
+ RM_IHPSG13_1P_COLUMN_256_0[6]/RM_IHPSG13_1P_BITKIT_16x2_SRAM_1[2]/A_RWL<1> RM_IHPSG13_1P_COLUMN_256_0[6]/RM_IHPSG13_1P_BITKIT_16x2_SRAM_0[1]/A_RWL<6>
+ RM_IHPSG13_1P_COLUMN_256_0[6]/RM_IHPSG13_1P_BITKIT_16x2_SRAM_2[1]/A_RWL<9> RM_IHPSG13_1P_COLUMN_256_0[6]/RM_IHPSG13_1P_BITKIT_16x2_SRAM_1[1]/A_RWL<11>
+ RM_IHPSG13_1P_COLUMN_256_0[6]/RM_IHPSG13_1P_BITKIT_16x2_SRAM_2[0]/A_RWL<6> RM_IHPSG13_1P_COLUMN_256_0[6]/RM_IHPSG13_1P_BITKIT_16x2_SRAM_3[1]/A_LWL<3>
+ RM_IHPSG13_1P_COLUMN_256_0[6]/RM_IHPSG13_1P_BITKIT_16x2_SRAM_2[0]/A_RWL<4> RM_IHPSG13_1P_COLUMN_256_0[6]/RM_IHPSG13_1P_BITKIT_16x2_SRAM_3[3]/A_RWL<7>
+ RM_IHPSG13_1P_COLUMN_256_0[6]/RM_IHPSG13_1P_BITKIT_16x2_SRAM_0[1]/A_LWL<2> RM_IHPSG13_1P_COLUMN_256_0[6]/RM_IHPSG13_1P_BITKIT_16x2_SRAM_2[3]/A_RWL<12>
+ RM_IHPSG13_1P_COLUMN_256_0[6]/RM_IHPSG13_1P_BITKIT_16x2_SRAM_2[1]/A_LWL<4> RM_IHPSG13_1P_COLUMN_256_0[6]/RM_IHPSG13_1P_BITKIT_16x2_SRAM_2[0]/A_LWL<12>
+ RM_IHPSG13_1P_COLUMN_256_0[6]/RM_IHPSG13_1P_BITKIT_16x2_SRAM_1[1]/A_LWL<5> RM_IHPSG13_1P_COLUMN_256_0[6]/RM_IHPSG13_1P_BITKIT_16x2_SRAM_3[2]/A_RWL<0>
+ RM_IHPSG13_1P_COLUMN_256_0[6]/RM_IHPSG13_1P_BITKIT_16x2_SRAM_0[1]/A_LWL<12> RM_IHPSG13_1P_COLUMN_256_0[6]/RM_IHPSG13_1P_BITKIT_16x2_SRAM_0[1]/A_LWL<6>
+ RM_IHPSG13_1P_COLUMN_256_0[6]/RM_IHPSG13_1P_BITKIT_16x2_SRAM_2[2]/A_RWL<1> RM_IHPSG13_1P_COLUMN_256_0[6]/RM_IHPSG13_1P_BITKIT_16x2_SRAM_3[0]/A_RWL<14>
+ RM_IHPSG13_1P_COLUMN_256_0[6]/RM_IHPSG13_1P_BITKIT_16x2_SRAM_1[0]/A_RWL<15> RM_IHPSG13_1P_COLUMN_256_0[6]/RM_IHPSG13_1P_BITKIT_16x2_SRAM_1[1]/A_LWL<4>
+ RM_IHPSG13_1P_COLUMN_256_0[6]/RM_IHPSG13_1P_BITKIT_16x2_SRAM_1[3]/A_LWL<13> RM_IHPSG13_1P_COLUMN_256_0[6]/RM_IHPSG13_1P_BITKIT_16x2_SRAM_1[2]/A_RWL<2>
+ RM_IHPSG13_1P_COLUMN_256_0[6]/RM_IHPSG13_1P_BITKIT_16x2_SRAM_1[1]/A_RWL<12> RM_IHPSG13_1P_COLUMN_256_0[6]/RM_IHPSG13_1P_BITKIT_16x2_SRAM_3[0]/A_LWL<4>
+ RM_IHPSG13_1P_COLUMN_256_0[6]/RM_IHPSG13_1P_BITKIT_16x2_SRAM_0[2]/A_LWL<9> RM_IHPSG13_1P_COLUMN_256_0[6]/RM_IHPSG13_1P_BITKIT_16x2_SRAM_0[2]/A_RWL<3>
+ RM_IHPSG13_1P_COLUMN_256_0[6]/RM_IHPSG13_1P_BITKIT_16x2_SRAM_3[1]/A_LWL<4> RM_IHPSG13_1P_COLUMN_256_0[6]/RM_IHPSG13_1P_BITKIT_16x2_SRAM_2[1]/A_LWL<5>
+ RM_IHPSG13_1P_COLUMN_256_0[6]/RM_IHPSG13_1P_BITKIT_16x2_SRAM_1[2]/A_RWL<0> RM_IHPSG13_1P_COLUMN_256_0[6]/RM_IHPSG13_1P_BITKIT_16x2_SRAM_1[1]/A_RWL<5>
+ RM_IHPSG13_1P_COLUMN_256_0[6]/RM_IHPSG13_1P_BITKIT_16x2_SRAM_2[2]/A_LWL<15> RM_IHPSG13_1P_COLUMN_256_0[6]/RM_IHPSG13_1P_BITKIT_16x2_SRAM_3[2]/A_RWL<1>
+ RM_IHPSG13_1P_COLUMN_256_0[6]/RM_IHPSG13_1P_BITKIT_16x2_SRAM_1[3]/A_LWL<10> RM_IHPSG13_1P_COLUMN_256_0[6]/RM_IHPSG13_1P_BITKIT_16x2_SRAM_0[1]/A_LWL<7>
+ RM_IHPSG13_1P_COLUMN_256_0[6]/RM_IHPSG13_1P_BITKIT_16x2_SRAM_1[1]/A_LWL<3> RM_IHPSG13_1P_COLUMN_256_0[6]/RM_IHPSG13_1P_BITKIT_16x2_SRAM_1[0]/A_LWL<6>
+ RM_IHPSG13_1P_COLUMN_256_0[6]/RM_IHPSG13_1P_BITKIT_16x2_SRAM_3[2]/A_LWL<10> RM_IHPSG13_1P_COLUMN_256_0[6]/RM_IHPSG13_1P_BITKIT_16x2_SRAM_1[3]/A_LWL<14>
+ RM_IHPSG13_1P_COLUMN_256_0[6]/RM_IHPSG13_1P_BITKIT_16x2_SRAM_3[1]/A_LWL<1> RM_IHPSG13_1P_COLUMN_256_0[6]/RM_IHPSG13_1P_BITKIT_16x2_SRAM_3[1]/A_LWL<2>
+ RM_IHPSG13_1P_COLUMN_256_0[6]/RM_IHPSG13_1P_BITKIT_16x2_SRAM_0[0]/A_RWL<6> RM_IHPSG13_1P_COLUMN_256_0[6]/RM_IHPSG13_1P_BITKIT_16x2_SRAM_1[2]/A_RWL<3>
+ RM_IHPSG13_1P_COLUMN_256_0[6]/RM_IHPSG13_1P_BITKIT_16x2_SRAM_0[2]/A_LWL<10> RM_IHPSG13_1P_COLUMN_256_0[6]/RM_IHPSG13_1P_BITKIT_16x2_SRAM_1[3]/A_RWL<7>
+ RM_IHPSG13_1P_COLUMN_256_0[6]/RM_IHPSG13_1P_BITKIT_16x2_SRAM_1[1]/A_RWL<13> RM_IHPSG13_1P_COLUMN_256_0[6]/RM_IHPSG13_1P_BITKIT_16x2_SRAM_0[2]/A_RWL<4>
+ RM_IHPSG13_1P_COLUMN_256_0[6]/RM_IHPSG13_1P_BITKIT_16x2_SRAM_0[0]/A_LWL<12> RM_IHPSG13_1P_COLUMN_256_0[6]/RM_IHPSG13_1P_BITKIT_16x2_SRAM_2[3]/A_RWL<14>
+ RM_IHPSG13_1P_COLUMN_256_0[6]/RM_IHPSG13_1P_BITKIT_16x2_SRAM_2[1]/A_LWL<6> RM_IHPSG13_1P_COLUMN_256_0[6]/RM_IHPSG13_1P_BITKIT_16x2_SRAM_1[1]/A_LWL<7>
+ RM_IHPSG13_1P_COLUMN_256_0[6]/RM_IHPSG13_1P_BITKIT_16x2_SRAM_3[2]/A_RWL<2> RM_IHPSG13_1P_COLUMN_256_0[6]/RM_IHPSG13_1P_BITKIT_16x2_SRAM_1[0]/A_RWL<14>
+ RM_IHPSG13_1P_COLUMN_256_0[6]/RM_IHPSG13_1P_BITKIT_16x2_SRAM_0[1]/A_LWL<14> RM_IHPSG13_1P_COLUMN_256_0[6]/RM_IHPSG13_1P_BITKIT_16x2_SRAM_0[1]/A_LWL<8>
+ RM_IHPSG13_1P_COLUMN_256_0[6]/RM_IHPSG13_1P_BITKIT_16x2_SRAM_2[2]/A_RWL<3> RM_IHPSG13_1P_COLUMN_256_0[6]/RM_IHPSG13_1P_BITKIT_16x2_SRAM_1[3]/A_LWL<15>
+ RM_IHPSG13_1P_COLUMN_256_0[6]/RM_IHPSG13_1P_BITKIT_16x2_SRAM_1[0]/A_LWL<4> RM_IHPSG13_1P_COLUMN_256_0[6]/RM_IHPSG13_1P_BITKIT_16x2_SRAM_1[2]/A_RWL<4>
+ RM_IHPSG13_1P_COLUMN_256_0[6]/RM_IHPSG13_1P_BITKIT_16x2_SRAM_0[3]/A_RWL<8> RM_IHPSG13_1P_COLUMN_256_0[6]/RM_IHPSG13_1P_BITKIT_16x2_SRAM_2[1]/A_RWL<4>
+ RM_IHPSG13_1P_COLUMN_256_0[6]/RM_IHPSG13_1P_BITKIT_16x2_SRAM_2[0]/A_RWL<13> RM_IHPSG13_1P_COLUMN_256_0[6]/RM_IHPSG13_1P_BITKIT_16x2_SRAM_3[3]/A_RWL<10>
+ RM_IHPSG13_1P_COLUMN_256_0[6]/RM_IHPSG13_1P_BITKIT_16x2_SRAM_1[1]/A_RWL<14> RM_IHPSG13_1P_COLUMN_256_0[6]/RM_IHPSG13_1P_BITKIT_16x2_SRAM_0[2]/A_RWL<5>
+ RM_IHPSG13_1P_COLUMN_256_0[6]/RM_IHPSG13_1P_BITKIT_16x2_SRAM_0[0]/A_RWL<10> RM_IHPSG13_1P_COLUMN_256_0[6]/RM_IHPSG13_1P_BITKIT_16x2_SRAM_2[3]/A_RWL<9>
+ RM_IHPSG13_1P_COLUMN_256_0[6]/RM_IHPSG13_1P_BITKIT_16x2_SRAM_3[1]/A_LWL<6> RM_IHPSG13_1P_COLUMN_256_0[6]/RM_IHPSG13_1P_BITKIT_16x2_SRAM_2[0]/A_LWL<9>
+ RM_IHPSG13_1P_COLUMN_256_0[6]/RM_IHPSG13_1P_BITKIT_16x2_SRAM_2[3]/A_RWL<15> RM_IHPSG13_1P_COLUMN_256_0[6]/RM_IHPSG13_1P_BITKIT_16x2_SRAM_1[2]/A_RWL<11>
+ RM_IHPSG13_1P_COLUMN_256_0[6]/RM_IHPSG13_1P_BITKIT_16x2_SRAM_2[0]/A_LWL<7> RM_IHPSG13_1P_COLUMN_256_0[6]/RM_IHPSG13_1P_BITKIT_16x2_SRAM_3[3]/A_LWL<8>
+ RM_IHPSG13_1P_COLUMN_256_0[6]/RM_IHPSG13_1P_BITKIT_16x2_SRAM_2[1]/A_LWL<15> RM_IHPSG13_1P_COLUMN_256_0[6]/RM_IHPSG13_1P_BITKIT_16x2_SRAM_1[2]/A_LWL<10>
+ RM_IHPSG13_1P_COLUMN_256_0[6]/RM_IHPSG13_1P_BITKIT_16x2_SRAM_0[1]/A_LWL<9> RM_IHPSG13_1P_COLUMN_256_0[6]/RM_IHPSG13_1P_BITKIT_16x2_SRAM_1[1]/A_LWL<1>
+ RM_IHPSG13_1P_COLUMN_256_0[6]/RM_IHPSG13_1P_BITKIT_16x2_SRAM_3[1]/A_LWL<10> RM_IHPSG13_1P_COLUMN_256_0[6]/RM_IHPSG13_1P_BITKIT_16x2_SRAM_3[0]/A_LWL<1>
+ RM_IHPSG13_1P_COLUMN_256_0[6]/RM_IHPSG13_1P_BITKIT_16x2_SRAM_0[2]/A_LWL<12> RM_IHPSG13_1P_COLUMN_256_0[6]/RM_IHPSG13_1P_BITKIT_16x2_SRAM_1[1]/A_RWL<15>
+ RM_IHPSG13_1P_COLUMN_256_0[6]/RM_IHPSG13_1P_BITKIT_16x2_SRAM_0[2]/A_RWL<6> RM_IHPSG13_1P_COLUMN_256_0[6]/RM_IHPSG13_1P_BITKIT_16x2_SRAM_0[0]/A_RWL<11>
+ RM_IHPSG13_1P_COLUMN_256_0[6]/RM_IHPSG13_1P_BITKIT_16x2_SRAM_3[1]/A_LWL<7> RM_IHPSG13_1P_COLUMN_256_0[6]/RM_IHPSG13_1P_BITKIT_16x2_SRAM_3[1]/A_RWL<7>
+ RM_IHPSG13_1P_COLUMN_256_0[6]/RM_IHPSG13_1P_BITKIT_16x2_SRAM_1[2]/A_RWL<5> RM_IHPSG13_1P_COLUMN_256_0[6]/RM_IHPSG13_1P_BITKIT_16x2_SRAM_1[2]/A_LWL<0>
+ RM_IHPSG13_1P_COLUMN_256_0[6]/RM_IHPSG13_1P_BITKIT_16x2_SRAM_1[2]/A_RWL<12> RM_IHPSG13_1P_COLUMN_256_0[6]/RM_IHPSG13_1P_BITKIT_16x2_SRAM_2[1]/A_LWL<8>
+ RM_IHPSG13_1P_COLUMN_256_0[6]/RM_IHPSG13_1P_BITKIT_16x2_SRAM_2[2]/A_RWL<2> RM_IHPSG13_1P_COLUMN_256_0[6]/RM_IHPSG13_1P_BITKIT_16x2_SRAM_0[2]/A_LWL<1>
+ RM_IHPSG13_1P_COLUMN_256_0[6]/RM_IHPSG13_1P_BITKIT_16x2_SRAM_0[3]/A_RWL<15> RM_IHPSG13_1P_COLUMN_256_0[6]/RM_IHPSG13_1P_BITKIT_16x2_SRAM_1[1]/A_LWL<9>
+ RM_IHPSG13_1P_COLUMN_256_0[6]/RM_IHPSG13_1P_BITKIT_16x2_SRAM_3[2]/A_RWL<4> RM_IHPSG13_1P_COLUMN_256_0[6]/RM_IHPSG13_1P_BITKIT_16x2_SRAM_3[0]/A_RWL<12>
+ RM_IHPSG13_1P_COLUMN_256_0[6]/RM_IHPSG13_1P_BITKIT_16x2_SRAM_1[1]/A_LWL<6> RM_IHPSG13_1P_COLUMN_256_0[6]/RM_IHPSG13_1P_BITKIT_16x2_SRAM_3[3]/A_RWL<8>
+ RM_IHPSG13_1P_COLUMN_256_0[6]/RM_IHPSG13_1P_BITKIT_16x2_SRAM_2[2]/A_RWL<15> RM_IHPSG13_1P_COLUMN_256_0[6]/RM_IHPSG13_1P_BITKIT_16x2_SRAM_2[2]/A_RWL<5>
+ RM_IHPSG13_1P_COLUMN_256_0[6]/RM_IHPSG13_1P_BITKIT_16x2_SRAM_1[2]/A_RWL<6> RM_IHPSG13_1P_COLUMN_256_0[6]/RM_IHPSG13_1P_BITKIT_16x2_SRAM_3[2]/A_RWL<10>
+ RM_IHPSG13_1P_COLUMN_256_0[6]/RM_IHPSG13_1P_BITKIT_16x2_SRAM_0[0]/A_LWL<9> RM_IHPSG13_1P_COLUMN_256_0[6]/RM_IHPSG13_1P_BITKIT_16x2_SRAM_0[0]/A_RWL<12>
+ RM_IHPSG13_1P_COLUMN_256_0[6]/RM_IHPSG13_1P_BITKIT_16x2_SRAM_0[2]/A_RWL<7> RM_IHPSG13_1P_COLUMN_256_0[6]/RM_IHPSG13_1P_BITKIT_16x2_SRAM_1[3]/A_LWL<8>
+ RM_IHPSG13_1P_COLUMN_256_0[6]/RM_IHPSG13_1P_BITKIT_16x2_SRAM_0[3]/A_LWL<10> RM_IHPSG13_1P_COLUMN_256_0[6]/RM_IHPSG13_1P_BITKIT_16x2_SRAM_1[2]/A_LWL<1>
+ RM_IHPSG13_1P_COLUMN_256_0[6]/RM_IHPSG13_1P_BITKIT_16x2_SRAM_2[1]/A_LWL<9> RM_IHPSG13_1P_COLUMN_256_0[6]/RM_IHPSG13_1P_BITKIT_16x2_SRAM_1[2]/A_RWL<13>
+ RM_IHPSG13_1P_COLUMN_256_0[6]/RM_IHPSG13_1P_BITKIT_16x2_SRAM_0[1]/A_LWL<15> RM_IHPSG13_1P_COLUMN_256_0[6]/RM_IHPSG13_1P_BITKIT_16x2_SRAM_3[2]/A_LWL<8>
+ RM_IHPSG13_1P_COLUMN_256_0[6]/RM_IHPSG13_1P_BITKIT_16x2_SRAM_0[2]/A_LWL<2> RM_IHPSG13_1P_COLUMN_256_0[6]/RM_IHPSG13_1P_BITKIT_16x2_SRAM_2[0]/A_LWL<15>
+ RM_IHPSG13_1P_COLUMN_256_0[6]/RM_IHPSG13_1P_BITKIT_16x2_SRAM_2[3]/A_LWL<13> RM_IHPSG13_1P_COLUMN_256_0[6]/RM_IHPSG13_1P_BITKIT_16x2_SRAM_3[2]/A_RWL<5>
+ RM_IHPSG13_1P_COLUMN_256_0[6]/RM_IHPSG13_1P_BITKIT_16x2_SRAM_1[3]/A_RWL<10> RM_IHPSG13_1P_COLUMN_256_0[6]/RM_IHPSG13_1P_BITKIT_16x2_SRAM_1[1]/A_LWL<10>
+ RM_IHPSG13_1P_COLUMN_256_0[6]/RM_IHPSG13_1P_BITKIT_16x2_SRAM_0[0]/A_RWL<9> RM_IHPSG13_1P_COLUMN_256_0[6]/RM_IHPSG13_1P_BITKIT_16x2_SRAM_1[0]/A_LWL<1>
+ RM_IHPSG13_1P_COLUMN_256_0[6]/RM_IHPSG13_1P_BITKIT_16x2_SRAM_2[2]/A_RWL<6> RM_IHPSG13_1P_COLUMN_256_0[6]/RM_IHPSG13_1P_BITKIT_16x2_SRAM_2[2]/A_RWL<4>
+ RM_IHPSG13_1P_COLUMN_256_0[6]/RM_IHPSG13_1P_BITKIT_16x2_SRAM_2[1]/A_RWL<13> RM_IHPSG13_1P_COLUMN_256_0[6]/RM_IHPSG13_1P_BITKIT_16x2_SRAM_0[3]/A_LWL<2>
+ RM_IHPSG13_1P_COLUMN_256_0[6]/RM_IHPSG13_1P_BITKIT_16x2_SRAM_2[3]/A_LWL<0> RM_IHPSG13_1P_COLUMN_256_0[6]/RM_IHPSG13_1P_BITKIT_16x2_SRAM_3[2]/A_LWL<0>
+ RM_IHPSG13_1P_COLUMN_256_0[6]/RM_IHPSG13_1P_BITKIT_16x2_SRAM_1[2]/A_RWL<7> RM_IHPSG13_1P_COLUMN_256_0[6]/RM_IHPSG13_1P_BITKIT_16x2_SRAM_0[2]/A_LWL<14>
+ RM_IHPSG13_1P_COLUMN_256_0[6]/RM_IHPSG13_1P_BITKIT_16x2_SRAM_1[1]/A_RWL<7> RM_IHPSG13_1P_COLUMN_256_0[6]/RM_IHPSG13_1P_BITKIT_16x2_SRAM_2[2]/A_LWL<1>
+ RM_IHPSG13_1P_COLUMN_256_0[6]/RM_IHPSG13_1P_BITKIT_16x2_SRAM_0[0]/A_RWL<13> RM_IHPSG13_1P_COLUMN_256_0[6]/RM_IHPSG13_1P_BITKIT_16x2_SRAM_2[1]/A_LWL<7>
+ RM_IHPSG13_1P_COLUMN_256_0[6]/RM_IHPSG13_1P_BITKIT_16x2_SRAM_0[2]/A_RWL<8> RM_IHPSG13_1P_COLUMN_256_0[6]/RM_IHPSG13_1P_BITKIT_16x2_SRAM_3[0]/A_RWL<7>
+ RM_IHPSG13_1P_COLUMN_256_0[6]/RM_IHPSG13_1P_BITKIT_16x2_SRAM_3[1]/A_LWL<9> RM_IHPSG13_1P_COLUMN_256_0[6]/RM_IHPSG13_1P_BITKIT_16x2_SRAM_3[3]/A_LWL<5>
+ RM_IHPSG13_1P_COLUMN_256_0[6]/RM_IHPSG13_1P_BITKIT_16x2_SRAM_0[2]/A_RWL<2> RM_IHPSG13_1P_COLUMN_256_0[6]/RM_IHPSG13_1P_BITKIT_16x2_SRAM_1[2]/A_LWL<2>
+ RM_IHPSG13_1P_COLUMN_256_0[6]/RM_IHPSG13_1P_BITKIT_16x2_SRAM_1[2]/A_RWL<14> RM_IHPSG13_1P_COLUMN_256_0[6]/RM_IHPSG13_1P_BITKIT_16x2_SRAM_2[1]/A_RWL<2>
+ RM_IHPSG13_1P_COLUMN_256_0[6]/RM_IHPSG13_1P_BITKIT_16x2_SRAM_0[1]/A_RWL<10> RM_IHPSG13_1P_COLUMN_256_0[6]/RM_IHPSG13_1P_BITKIT_16x2_SRAM_0[2]/A_LWL<3>
+ RM_IHPSG13_1P_COLUMN_256_0[6]/RM_IHPSG13_1P_BITKIT_16x2_SRAM_0[2]/A_RWL<15> RM_IHPSG13_1P_COLUMN_256_0[6]/RM_IHPSG13_1P_BITKIT_16x2_SRAM_3[2]/A_RWL<6>
+ RM_IHPSG13_1P_COLUMN_256_0[6]/RM_IHPSG13_1P_BITKIT_16x2_SRAM_1[3]/A_RWL<11> RM_IHPSG13_1P_COLUMN_256_0[6]/RM_IHPSG13_1P_BITKIT_16x2_SRAM_2[1]/A_RWL<15>
+ RM_IHPSG13_1P_COLUMN_256_0[6]/RM_IHPSG13_1P_BITKIT_16x2_SRAM_2[2]/A_RWL<7> RM_IHPSG13_1P_COLUMN_256_0[6]/RM_IHPSG13_1P_BITKIT_16x2_SRAM_1[2]/A_RWL<10>
+ RM_IHPSG13_1P_COLUMN_256_0[6]/RM_IHPSG13_1P_BITKIT_16x2_SRAM_0[3]/A_RWL<0> RM_IHPSG13_1P_COLUMN_256_0[6]/RM_IHPSG13_1P_BITKIT_16x2_SRAM_1[0]/A_RWL<1>
+ RM_IHPSG13_1P_COLUMN_256_0[6]/RM_IHPSG13_1P_BITKIT_16x2_SRAM_3[2]/A_LWL<1> RM_IHPSG13_1P_COLUMN_256_0[6]/RM_IHPSG13_1P_BITKIT_16x2_SRAM_1[2]/A_RWL<8>
+ RM_IHPSG13_1P_COLUMN_256_0[6]/RM_IHPSG13_1P_BITKIT_16x2_SRAM_0[2]/A_LWL<15> RM_IHPSG13_1P_COLUMN_256_0[6]/RM_IHPSG13_1P_BITKIT_16x2_SRAM_1[3]/A_RWL<5>
+ RM_IHPSG13_1P_COLUMN_256_0[6]/RM_IHPSG13_1P_BITKIT_16x2_SRAM_3[1]/A_RWL<10> RM_IHPSG13_1P_COLUMN_256_0[6]/RM_IHPSG13_1P_BITKIT_16x2_SRAM_0[0]/A_RWL<14>
+ RM_IHPSG13_1P_COLUMN_256_0[6]/RM_IHPSG13_1P_BITKIT_16x2_SRAM_2[2]/A_LWL<2> RM_IHPSG13_1P_COLUMN_256_0[6]/RM_IHPSG13_1P_BITKIT_16x2_SRAM_1[2]/A_LWL<8>
+ RM_IHPSG13_1P_COLUMN_256_0[6]/RM_IHPSG13_1P_BITKIT_16x2_SRAM_1[0]/A_RWL<8> RM_IHPSG13_1P_COLUMN_256_0[6]/RM_IHPSG13_1P_BITKIT_16x2_SRAM_0[3]/A_LWL<12>
+ RM_IHPSG13_1P_COLUMN_256_0[6]/RM_IHPSG13_1P_BITKIT_16x2_SRAM_1[2]/A_LWL<3> RM_IHPSG13_1P_COLUMN_256_0[6]/RM_IHPSG13_1P_BITKIT_16x2_SRAM_3[1]/A_LWL<8>
+ RM_IHPSG13_1P_COLUMN_256_0[6]/RM_IHPSG13_1P_BITKIT_16x2_SRAM_3[1]/A_RWL<12> RM_IHPSG13_1P_COLUMN_256_0[6]/RM_IHPSG13_1P_BITKIT_16x2_SRAM_1[3]/A_LWL<3>
+ RM_IHPSG13_1P_COLUMN_256_0[6]/RM_IHPSG13_1P_BITKIT_16x2_SRAM_1[2]/A_RWL<15> RM_IHPSG13_1P_COLUMN_256_0[6]/RM_IHPSG13_1P_BITKIT_16x2_SRAM_0[0]/A_LWL<15>
+ RM_IHPSG13_1P_COLUMN_256_0[6]/RM_IHPSG13_1P_BITKIT_16x2_SRAM_3[0]/A_RWL<9> RM_IHPSG13_1P_COLUMN_256_0[6]/RM_IHPSG13_1P_BITKIT_16x2_SRAM_0[1]/A_RWL<11>
+ RM_IHPSG13_1P_COLUMN_256_0[6]/RM_IHPSG13_1P_BITKIT_16x2_SRAM_3[3]/A_LWL<2> RM_IHPSG13_1P_COLUMN_256_0[6]/RM_IHPSG13_1P_BITKIT_16x2_SRAM_0[2]/A_LWL<4>
+ RM_IHPSG13_1P_COLUMN_256_0[6]/RM_IHPSG13_1P_BITKIT_16x2_SRAM_2[2]/A_LWL<13> RM_IHPSG13_1P_COLUMN_256_0[6]/RM_IHPSG13_1P_BITKIT_16x2_SRAM_3[2]/A_RWL<7>
+ RM_IHPSG13_1P_COLUMN_256_0[6]/RM_IHPSG13_1P_BITKIT_16x2_SRAM_1[3]/A_RWL<12> RM_IHPSG13_1P_COLUMN_256_0[6]/RM_IHPSG13_1P_BITKIT_16x2_SRAM_0[3]/A_LWL<0>
+ RM_IHPSG13_1P_COLUMN_256_0[6]/RM_IHPSG13_1P_BITKIT_16x2_SRAM_1[0]/A_LWL<10> RM_IHPSG13_1P_COLUMN_256_0[6]/RM_IHPSG13_1P_BITKIT_16x2_SRAM_1[3]/A_RWL<0>
+ RM_IHPSG13_1P_COLUMN_256_0[6]/RM_IHPSG13_1P_BITKIT_16x2_SRAM_2[2]/A_RWL<8> RM_IHPSG13_1P_COLUMN_256_0[6]/RM_IHPSG13_1P_BITKIT_16x2_SRAM_2[3]/A_LWL<11>
+ RM_IHPSG13_1P_COLUMN_256_0[6]/RM_IHPSG13_1P_BITKIT_16x2_SRAM_2[2]/A_LWL<0> RM_IHPSG13_1P_COLUMN_256_0[6]/RM_IHPSG13_1P_BITKIT_16x2_SRAM_0[3]/A_RWL<1>
+ RM_IHPSG13_1P_COLUMN_256_0[6]/RM_IHPSG13_1P_BITKIT_16x2_SRAM_3[2]/A_LWL<2> RM_IHPSG13_1P_COLUMN_256_0[6]/RM_IHPSG13_1P_BITKIT_16x2_SRAM_1[2]/A_RWL<9>
+ RM_IHPSG13_1P_COLUMN_256_0[6]/RM_IHPSG13_1P_BITKIT_16x2_SRAM_1[0]/A_RWL<7> RM_IHPSG13_1P_COLUMN_256_0[6]/RM_IHPSG13_1P_BITKIT_16x2_SRAM_1[3]/A_LWL<5>
+ RM_IHPSG13_1P_COLUMN_256_0[6]/RM_IHPSG13_1P_BITKIT_16x2_SRAM_2[2]/A_LWL<3> RM_IHPSG13_1P_COLUMN_256_0[6]/RM_IHPSG13_1P_BITKIT_16x2_SRAM_0[1]/A_RWL<2>
+ RM_IHPSG13_1P_COLUMN_256_0[6]/RM_IHPSG13_1P_BITKIT_16x2_SRAM_0[3]/A_LWL<13> RM_IHPSG13_1P_COLUMN_256_0[6]/RM_IHPSG13_1P_BITKIT_16x2_SRAM_1[2]/A_LWL<4>
+ RM_IHPSG13_1P_COLUMN_256_0[6]/RM_IHPSG13_1P_BITKIT_16x2_SRAM_2[0]/A_RWL<2> RM_IHPSG13_1P_COLUMN_256_0[6]/RM_IHPSG13_1P_BITKIT_16x2_SRAM_0[1]/A_RWL<12>
+ RM_IHPSG13_1P_COLUMN_256_0[6]/RM_IHPSG13_1P_BITKIT_16x2_SRAM_2[0]/A_RWL<0> RM_IHPSG13_1P_COLUMN_256_0[6]/RM_IHPSG13_1P_BITKIT_16x2_SRAM_3[3]/A_RWL<3>
+ RM_IHPSG13_1P_COLUMN_256_0[6]/RM_IHPSG13_1P_BITKIT_16x2_SRAM_0[1]/A_RWL<9> RM_IHPSG13_1P_COLUMN_256_0[6]/RM_IHPSG13_1P_BITKIT_16x2_SRAM_0[2]/A_LWL<5>
+ RM_IHPSG13_1P_COLUMN_256_0[6]/RM_IHPSG13_1P_BITKIT_16x2_SRAM_2[3]/A_RWL<4> RM_IHPSG13_1P_COLUMN_256_0[6]/RM_IHPSG13_1P_BITKIT_16x2_SRAM_2[3]/A_RWL<0>
+ RM_IHPSG13_1P_COLUMN_256_0[6]/RM_IHPSG13_1P_BITKIT_16x2_SRAM_3[2]/A_RWL<8> RM_IHPSG13_1P_COLUMN_256_0[6]/RM_IHPSG13_1P_BITKIT_16x2_SRAM_2[2]/A_RWL<13>
+ RM_IHPSG13_1P_COLUMN_256_0[6]/RM_IHPSG13_1P_BITKIT_16x2_SRAM_1[3]/A_RWL<13> RM_IHPSG13_1P_COLUMN_256_0[6]/RM_IHPSG13_1P_BITKIT_16x2_SRAM_2[0]/A_RWL<15>
+ RM_IHPSG13_1P_COLUMN_256_0[6]/RM_IHPSG13_1P_BITKIT_16x2_SRAM_1[3]/A_RWL<1> RM_IHPSG13_1P_COLUMN_256_0[6]/RM_IHPSG13_1P_BITKIT_16x2_SRAM_2[2]/A_RWL<9>
+ RM_IHPSG13_1P_COLUMN_256_0[6]/RM_IHPSG13_1P_BITKIT_16x2_SRAM_1[1]/A_RWL<10> RM_IHPSG13_1P_COLUMN_256_0[6]/RM_IHPSG13_1P_BITKIT_16x2_SRAM_2[2]/A_LWL<7>
+ RM_IHPSG13_1P_COLUMN_256_0[6]/RM_IHPSG13_1P_BITKIT_16x2_SRAM_0[3]/A_RWL<2> RM_IHPSG13_1P_COLUMN_256_0[6]/RM_IHPSG13_1P_BITKIT_16x2_SRAM_3[2]/A_LWL<3>
+ RM_IHPSG13_1P_COLUMN_256_0[6]/RM_IHPSG13_1P_BITKIT_16x2_SRAM_3[0]/A_RWL<10> RM_IHPSG13_1P_COLUMN_256_0[6]/RM_IHPSG13_1P_BITKIT_16x2_SRAM_2[2]/A_LWL<4>
+ RM_IHPSG13_1P_COLUMN_256_0[6]/RM_IHPSG13_1P_BITKIT_16x2_SRAM_1[1]/A_LWL<8> RM_IHPSG13_1P_COLUMN_256_0[6]/RM_IHPSG13_1P_BITKIT_16x2_SRAM_0[3]/A_LWL<14>
+ RM_IHPSG13_1P_COLUMN_256_0[6]/RM_IHPSG13_1P_BITKIT_16x2_SRAM_3[0]/A_LWL<8> RM_IHPSG13_1P_COLUMN_256_0[6]/RM_IHPSG13_1P_BITKIT_16x2_SRAM_3[3]/A_RWL<0>
+ RM_IHPSG13_1P_COLUMN_256_0[6]/RM_IHPSG13_1P_BITKIT_16x2_SRAM_0[2]/A_LWL<13> RM_IHPSG13_1P_COLUMN_256_0[6]/RM_IHPSG13_1P_BITKIT_16x2_SRAM_0[1]/A_RWL<13>
+ RM_IHPSG13_1P_COLUMN_256_0[6]/RM_IHPSG13_1P_BITKIT_16x2_SRAM_3[0]/A_LWL<10> RM_IHPSG13_1P_COLUMN_256_0[6]/RM_IHPSG13_1P_BITKIT_16x2_SRAM_2[1]/A_LWL<13>
+ RM_IHPSG13_1P_COLUMN_256_0[6]/RM_IHPSG13_1P_BITKIT_16x2_SRAM_0[2]/A_LWL<6> RM_IHPSG13_1P_COLUMN_256_0[6]/RM_IHPSG13_1P_BITKIT_16x2_SRAM_2[3]/A_RWL<1>
+ RM_IHPSG13_1P_COLUMN_256_0[6]/RM_IHPSG13_1P_BITKIT_16x2_SRAM_3[2]/A_RWL<9> RM_IHPSG13_1P_COLUMN_256_0[6]/RM_IHPSG13_1P_BITKIT_16x2_SRAM_0[3]/A_LWL<11>
+ RM_IHPSG13_1P_COLUMN_256_0[6]/RM_IHPSG13_1P_BITKIT_16x2_SRAM_1[3]/A_RWL<14> RM_IHPSG13_1P_COLUMN_256_0[6]/RM_IHPSG13_1P_BITKIT_16x2_SRAM_0[2]/A_LWL<0>
+ RM_IHPSG13_1P_COLUMN_256_0[6]/RM_IHPSG13_1P_BITKIT_16x2_SRAM_1[1]/A_RWL<1> RM_IHPSG13_1P_COLUMN_256_0[6]/RM_IHPSG13_1P_BITKIT_16x2_SRAM_0[2]/A_RWL<10>
+ RM_IHPSG13_1P_COLUMN_256_0[6]/RM_IHPSG13_1P_BITKIT_16x2_SRAM_1[3]/A_RWL<2> RM_IHPSG13_1P_COLUMN_256_0[6]/RM_IHPSG13_1P_BITKIT_16x2_SRAM_2[2]/A_LWL<11>
+ RM_IHPSG13_1P_COLUMN_256_0[6]/RM_IHPSG13_1P_BITKIT_16x2_SRAM_2[1]/A_LWL<0> RM_IHPSG13_1P_COLUMN_256_0[6]/RM_IHPSG13_1P_BITKIT_16x2_SRAM_0[3]/A_RWL<3>
+ RM_IHPSG13_1P_COLUMN_256_0[6]/RM_IHPSG13_1P_BITKIT_16x2_SRAM_3[2]/A_LWL<4> RM_IHPSG13_1P_COLUMN_256_0[6]/RM_IHPSG13_1P_BITKIT_16x2_SRAM_1[1]/A_RWL<8>
+ RM_IHPSG13_1P_COLUMN_256_0[6]/RM_IHPSG13_1P_BITKIT_16x2_SRAM_1[2]/A_LWL<5> RM_IHPSG13_1P_COLUMN_256_0[6]/RM_IHPSG13_1P_BITKIT_16x2_SRAM_1[0]/A_LWL<2>
+ RM_IHPSG13_1P_COLUMN_256_0[6]/RM_IHPSG13_1P_BITKIT_16x2_SRAM_3[2]/A_RWL<12> RM_IHPSG13_1P_COLUMN_256_0[6]/RM_IHPSG13_1P_BITKIT_16x2_SRAM_2[2]/A_LWL<5>
+ RM_IHPSG13_1P_COLUMN_256_0[6]/RM_IHPSG13_1P_BITKIT_16x2_SRAM_1[3]/A_LWL<6> RM_IHPSG13_1P_COLUMN_256_0[6]/RM_IHPSG13_1P_BITKIT_16x2_SRAM_3[1]/A_RWL<9>
+ RM_IHPSG13_1P_COLUMN_256_0[6]/RM_IHPSG13_1P_BITKIT_16x2_SRAM_3[1]/A_LWL<5> RM_IHPSG13_1P_COLUMN_256_0[6]/RM_IHPSG13_1P_BITKIT_16x2_SRAM_0[0]/A_RWL<2>
+ RM_IHPSG13_1P_COLUMN_256_0[6]/RM_IHPSG13_1P_BITKIT_16x2_SRAM_0[3]/A_LWL<15> RM_IHPSG13_1P_COLUMN_256_0[6]/RM_IHPSG13_1P_BITKIT_16x2_SRAM_1[2]/A_LWL<6>
+ RM_IHPSG13_1P_COLUMN_256_0[6]/RM_IHPSG13_1P_BITKIT_16x2_SRAM_3[3]/A_RWL<1> RM_IHPSG13_1P_COLUMN_256_0[6]/RM_IHPSG13_1P_BITKIT_16x2_SRAM_0[1]/A_RWL<14>
+ RM_IHPSG13_1P_COLUMN_256_0[6]/RM_IHPSG13_1P_BITKIT_16x2_SRAM_3[2]/A_RWL<3> RM_IHPSG13_1P_COLUMN_256_0[6]/RM_IHPSG13_1P_BITKIT_16x2_SRAM_3[0]/A_LWL<11>
+ RM_IHPSG13_1P_COLUMN_256_0[6]/RM_IHPSG13_1P_BITKIT_16x2_SRAM_0[2]/A_LWL<7> RM_IHPSG13_1P_COLUMN_256_0[6]/RM_IHPSG13_1P_BITKIT_16x2_SRAM_0[0]/A_RWL<15>
+ RM_IHPSG13_1P_COLUMN_256_0[6]/RM_IHPSG13_1P_BITKIT_16x2_SRAM_2[3]/A_RWL<2> RM_IHPSG13_1P_COLUMN_256_0[6]/RM_IHPSG13_1P_BITKIT_16x2_SRAM_2[3]/A_LWL<14>
+ RM_IHPSG13_1P_COLUMN_256_0[6]/RM_IHPSG13_1P_BITKIT_16x2_SRAM_1[3]/A_RWL<15> RM_IHPSG13_1P_COLUMN_256_0[6]/RM_IHPSG13_1P_BITKIT_16x2_SRAM_0[2]/A_RWL<11>
+ RM_IHPSG13_1P_COLUMN_256_0[6]/RM_IHPSG13_1P_BITKIT_16x2_SRAM_1[3]/A_RWL<3> RM_IHPSG13_1P_COLUMN_256_0[6]/RM_IHPSG13_1P_BITKIT_16x2_SRAM_1[0]/A_RWL<10>
+ RM_IHPSG13_1P_COLUMN_256_0[6]/RM_IHPSG13_1P_BITKIT_16x2_SRAM_0[3]/A_RWL<4> RM_IHPSG13_1P_COLUMN_256_0[6]/RM_IHPSG13_1P_BITKIT_16x2_SRAM_2[3]/A_RWL<11>
+ RM_IHPSG13_1P_COLUMN_256_0[6]/RM_IHPSG13_1P_BITKIT_16x2_SRAM_3[2]/A_LWL<5> RM_IHPSG13_1P_COLUMN_256_0[6]/RM_IHPSG13_1P_BITKIT_16x2_SRAM_0[0]/A_RWL<4>
+ RM_IHPSG13_1P_COLUMN_256_0[6]/RM_IHPSG13_1P_BITKIT_16x2_SRAM_2[2]/A_LWL<6> RM_IHPSG13_1P_COLUMN_256_0[6]/RM_IHPSG13_1P_BITKIT_16x2_SRAM_1[0]/A_LWL<8>
+ RM_IHPSG13_1P_COLUMN_256_0[6]/RM_IHPSG13_1P_BITKIT_16x2_SRAM_0[3]/A_RWL<12> RM_IHPSG13_1P_COLUMN_256_0[6]/RM_IHPSG13_1P_BITKIT_16x2_SRAM_2[1]/A_RWL<0>
+ RM_IHPSG13_1P_COLUMN_256_0[6]/RM_IHPSG13_1P_BITKIT_16x2_SRAM_3[3]/A_RWL<6> RM_IHPSG13_1P_COLUMN_256_0[6]/RM_IHPSG13_1P_BITKIT_16x2_SRAM_2[0]/A_RWL<5>
+ RM_IHPSG13_1P_COLUMN_256_0[6]/RM_IHPSG13_1P_BITKIT_16x2_SRAM_0[2]/A_RWL<9> RM_IHPSG13_1P_COLUMN_256_0[6]/RM_IHPSG13_1P_BITKIT_16x2_SRAM_1[2]/A_LWL<7>
+ RM_IHPSG13_1P_COLUMN_256_0[6]/RM_IHPSG13_1P_BITKIT_16x2_SRAM_0[1]/A_LWL<13> RM_IHPSG13_1P_COLUMN_256_0[6]/RM_IHPSG13_1P_BITKIT_16x2_SRAM_3[3]/A_RWL<2>
+ RM_IHPSG13_1P_COLUMN_256_0[6]/RM_IHPSG13_1P_BITKIT_16x2_SRAM_2[3]/A_RWL<13> RM_IHPSG13_1P_COLUMN_256_0[6]/RM_IHPSG13_1P_BITKIT_16x2_SRAM_0[1]/A_RWL<15>
+ RM_IHPSG13_1P_COLUMN_256_0[6]/RM_IHPSG13_1P_BITKIT_16x2_SRAM_3[0]/A_LWL<12> RM_IHPSG13_1P_COLUMN_256_0[6]/RM_IHPSG13_1P_BITKIT_16x2_SRAM_0[2]/A_LWL<8>
+ RM_IHPSG13_1P_COLUMN_256_0[6]/RM_IHPSG13_1P_BITKIT_16x2_SRAM_2[0]/A_LWL<13> RM_IHPSG13_1P_COLUMN_256_0[6]/RM_IHPSG13_1P_BITKIT_16x2_SRAM_2[3]/A_RWL<3>
+ RM_IHPSG13_1P_COLUMN_256_0[6]/RM_IHPSG13_1P_BITKIT_16x2_SRAM_0[2]/A_LWL<11> RM_IHPSG13_1P_COLUMN_256_0[6]/RM_IHPSG13_1P_BITKIT_16x2_SRAM_3[3]/A_LWL<12>
+ RM_IHPSG13_1P_COLUMN_256_0[6]/RM_IHPSG13_1P_BITKIT_16x2_SRAM_2[0]/A_LWL<3> RM_IHPSG13_1P_COLUMN_256_0[6]/RM_IHPSG13_1P_BITKIT_16x2_SRAM_0[1]/A_LWL<0>
+ RM_IHPSG13_1P_COLUMN_256_0[6]/RM_IHPSG13_1P_BITKIT_16x2_SRAM_2[3]/A_LWL<7> RM_IHPSG13_1P_COLUMN_256_0[6]/RM_IHPSG13_1P_BITKIT_16x2_SRAM_0[2]/A_RWL<12>
+ RM_IHPSG13_1P_COLUMN_256_0[6]/RM_IHPSG13_1P_BITKIT_16x2_SRAM_1[3]/A_RWL<4> RM_IHPSG13_1P_COLUMN_256_0[6]/RM_IHPSG13_1P_BITKIT_16x2_SRAM_2[1]/A_LWL<11>
+ RM_IHPSG13_1P_COLUMN_256_0[6]/RM_IHPSG13_1P_BITKIT_16x2_SRAM_2[0]/A_LWL<0> RM_IHPSG13_1P_COLUMN_256_0[7]/RM_IHPSG13_1P_BITKIT_16x2_SRAM_3[3]/VSS
+ RM_IHPSG13_1P_COLUMN_256_0[6]/RM_IHPSG13_1P_BITKIT_16x2_SRAM_0[3]/A_RWL<5> RM_IHPSG13_1P_COLUMN_256_0[7]/RM_IHPSG13_1P_BITKIT_16x2_SRAM_3[3]/VDD
+ RM_IHPSG13_1P_COLUMN_256_0[6]/RM_IHPSG13_1P_BITKIT_16x2_SRAM_3[2]/A_LWL<6> RM_IHPSG13_1P_COLUMN_256
XRM_IHPSG13_1P_COLUMN_256_0[7] RM_IHPSG13_1P_COLUMN_256_0[7]/RM_IHPSG13_1P_BITKIT_16x2_SRAM_0[0]/A_BLT_BOT<0>
+ RM_IHPSG13_1P_COLUMN_256_0[7]/RM_IHPSG13_1P_BITKIT_16x2_SRAM_0[0]/A_BLT_BOT<1> RM_IHPSG13_1P_COLUMN_256_0[7]/RM_IHPSG13_1P_BITKIT_16x2_SRAM_0[0]/A_BLC_BOT<0>
+ RM_IHPSG13_1P_BITKIT_16x2_EDGE_LR_3[3]/LWL<6> RM_IHPSG13_1P_BITKIT_16x2_EDGE_LR_0[3]/LWL<11>
+ RM_IHPSG13_1P_COLUMN_256_0[7]/RM_IHPSG13_1P_BITKIT_16x2_SRAM_0[0]/A_BLC_BOT<1> RM_IHPSG13_1P_COLUMN_256_0[7]/RM_IHPSG13_1P_BITKIT_16x2_SRAM_3[1]/A_LWL<12>
+ RM_IHPSG13_1P_BITKIT_16x2_EDGE_LR_3[3]/LWL<8> RM_IHPSG13_1P_BITKIT_16x2_EDGE_LR_0[3]/LWL<9>
+ RM_IHPSG13_1P_COLUMN_256_0[7]/RM_IHPSG13_1P_BITKIT_16x2_SRAM_0[3]/A_LWL<4> RM_IHPSG13_1P_COLUMN_256_0[7]/RM_IHPSG13_1P_BITKIT_16x2_SRAM_3[2]/A_LWL<9>
+ RM_IHPSG13_1P_COLUMN_256_0[7]/RM_IHPSG13_1P_BITKIT_16x2_SRAM_2[3]/A_LWL<1> RM_IHPSG13_1P_BITKIT_16x2_EDGE_LR_0[3]/LWL<14>
+ RM_IHPSG13_1P_BITKIT_16x2_EDGE_LR_0[2]/LWL<14> RM_IHPSG13_1P_COLUMN_256_0[7]/RM_IHPSG13_1P_BITKIT_16x2_SRAM_2[0]/A_LWL<11>
+ RM_IHPSG13_1P_COLUMN_256_0[7]/RM_IHPSG13_1P_BITKIT_16x2_SRAM_2[3]/A_LWL<4> RM_IHPSG13_1P_COLUMN_256_0[7]/RM_IHPSG13_1P_BITKIT_16x2_SRAM_3[2]/A_LWL<12>
+ RM_IHPSG13_1P_COLUMN_256_0[7]/RM_IHPSG13_1P_BITKIT_16x2_SRAM_1[2]/A_LWL<9> RM_IHPSG13_1P_BITKIT_16x2_EDGE_LR_2[3]/LWL<9>
+ RM_IHPSG13_1P_COLUMN_256_0[7]/RM_IHPSG13_1P_BITKIT_16x2_SRAM_1[3]/A_LWL<2> RM_IHPSG13_1P_COLUMN_256_0[7]/RM_IHPSG13_1P_BITKIT_16x2_SRAM_0[3]/A_LWL<1>
+ RM_IHPSG13_1P_BITKIT_16x2_EDGE_LR_1[3]/LWL<7> RM_IHPSG13_1P_BITKIT_16x2_EDGE_LR_0[0]/LWL<0>
+ RM_IHPSG13_1P_BITKIT_16x2_EDGE_LR_1[0]/LWL<1> RM_IHPSG13_1P_BITKIT_16x2_EDGE_LR_0[2]/LWL<13>
+ RM_IHPSG13_1P_BITKIT_16x2_EDGE_LR_1[3]/LWL<5> RM_IHPSG13_1P_COLUMN_256_0[7]/RM_IHPSG13_1P_BITKIT_16x2_SRAM_2[3]/A_LWL<3>
+ RM_IHPSG13_1P_BITKIT_16x2_EDGE_LR_2[0]/LWL<13> RM_IHPSG13_1P_BITKIT_16x2_EDGE_LR_3[0]/LWL<3>
+ RM_IHPSG13_1P_COLUMN_256_0[7]/RM_IHPSG13_1P_BITKIT_16x2_SRAM_3[1]/A_LWL<15> RM_IHPSG13_1P_COLUMN_256_0[7]/RM_IHPSG13_1P_BITKIT_16x2_SRAM_2[0]/A_LWL<14>
+ RM_IHPSG13_1P_BITKIT_16x2_EDGE_LR_0[3]/LWL<7> RM_IHPSG13_1P_BITKIT_16x2_EDGE_LR_2[0]/LWL<0>
+ RM_IHPSG13_1P_COLUMN_256_0[7]/RM_IHPSG13_1P_BITKIT_16x2_SRAM_3[2]/A_LWL<15> RM_IHPSG13_1P_BITKIT_16x2_EDGE_LR_2[3]/LWL<4>
+ RM_IHPSG13_1P_COLUMN_256_0[7]/RM_IHPSG13_1P_BITKIT_16x2_SRAM_3[2]/A_LWL<7> RM_IHPSG13_1P_COLUMN_256_0[7]/RM_IHPSG13_1P_BITKIT_16x2_SRAM_0[0]/A_LWL<0>
+ RM_IHPSG13_1P_COLUMN_256_0[7]/RM_IHPSG13_1P_BITKIT_16x2_SRAM_1[3]/A_LWL<9> RM_IHPSG13_1P_BITKIT_16x2_EDGE_LR_2[0]/LWL<3>
+ RM_IHPSG13_1P_BITKIT_16x2_EDGE_LR_0[0]/LWL<5> RM_IHPSG13_1P_BITKIT_16x2_EDGE_LR_0[3]/LWL<13>
+ RM_IHPSG13_1P_COLUMN_256_0[7]/RM_IHPSG13_1P_BITKIT_16x2_SRAM_2[3]/A_LWL<8> RM_IHPSG13_1P_COLUMN_256_0[7]/RM_IHPSG13_1P_BITKIT_16x2_SRAM_0[3]/A_LWL<7>
+ RM_IHPSG13_1P_COLUMN_256_0[7]/RM_IHPSG13_1P_BITKIT_16x2_SRAM_3[0]/A_LWL<15> RM_IHPSG13_1P_COLUMN_256_0[7]/RM_IHPSG13_1P_BITKIT_16x2_SRAM_3[3]/A_LWL<13>
+ RM_IHPSG13_1P_COLUMN_256_0[7]/RM_IHPSG13_1P_BITKIT_16x2_SRAM_2[3]/A_LWL<6> RM_IHPSG13_1P_COLUMN_256_0[7]/RM_IHPSG13_1P_BITKIT_16x2_SRAM_2[1]/A_LWL<10>
+ RM_IHPSG13_1P_COLUMN_256_0[7]/RM_IHPSG13_1P_BITKIT_16x2_SRAM_3[3]/A_LWL<0> RM_IHPSG13_1P_BITKIT_16x2_EDGE_LR_2[0]/LWL<4>
+ RM_IHPSG13_1P_COLUMN_256_0[7]/RM_IHPSG13_1P_BITKIT_16x2_SRAM_2[2]/A_LWL<10> RM_IHPSG13_1P_BITKIT_16x2_EDGE_LR_2[1]/LWL<13>
+ RM_IHPSG13_1P_BITKIT_16x2_EDGE_LR_3[0]/LWL<6> RM_IHPSG13_1P_COLUMN_256_0[7]/RM_IHPSG13_1P_BITKIT_16x2_SRAM_3[3]/A_LWL<9>
+ RM_IHPSG13_1P_BITKIT_16x2_EDGE_LR_3[0]/LWL<4> RM_IHPSG13_1P_BITKIT_16x2_EDGE_LR_0[3]/LWL<10>
+ RM_IHPSG13_1P_COLUMN_256_0[7]/RM_IHPSG13_1P_BITKIT_16x2_SRAM_2[1]/A_LWL<14> RM_IHPSG13_1P_BITKIT_16x2_EDGE_LR_2[0]/LWL<5>
+ RM_IHPSG13_1P_COLUMN_256_0[7]/RM_IHPSG13_1P_BITKIT_16x2_SRAM_0[3]/A_LWL<8> RM_IHPSG13_1P_COLUMN_256_0[7]/RM_IHPSG13_1P_BITKIT_16x2_SRAM_3[3]/A_LWL<7>
+ RM_IHPSG13_1P_COLUMN_256_0[7]/RM_IHPSG13_1P_BITKIT_16x2_SRAM_2[2]/A_LWL<8> RM_IHPSG13_1P_COLUMN_256_0[7]/RM_IHPSG13_1P_BITKIT_16x2_SRAM_3[3]/A_LWL<15>
+ RM_IHPSG13_1P_COLUMN_256_0[7]/RM_IHPSG13_1P_BITKIT_16x2_SRAM_3[2]/A_LWL<13> RM_IHPSG13_1P_COLUMN_256_0[7]/RM_IHPSG13_1P_BITKIT_16x2_SRAM_2[0]/A_LWL<1>
+ RM_IHPSG13_1P_COLUMN_256_0[7]/RM_IHPSG13_1P_BITKIT_16x2_SRAM_0[0]/A_LWL<1> RM_IHPSG13_1P_COLUMN_256_0[7]/RM_IHPSG13_1P_BITKIT_16x2_SRAM_1[3]/A_LWL<0>
+ RM_IHPSG13_1P_COLUMN_256_0[7]/RM_IHPSG13_1P_BITKIT_16x2_SRAM_2[0]/A_LWL<10> RM_IHPSG13_1P_COLUMN_256_0[7]/RM_IHPSG13_1P_BITKIT_16x2_SRAM_3[3]/A_LWL<11>
+ RM_IHPSG13_1P_COLUMN_256_0[7]/RM_IHPSG13_1P_BITKIT_16x2_SRAM_0[0]/A_LWL<3> RM_IHPSG13_1P_BITKIT_16x2_EDGE_LR_2[0]/LWL<6>
+ RM_IHPSG13_1P_COLUMN_256_0[7]/RM_IHPSG13_1P_BITKIT_16x2_SRAM_2[3]/A_LWL<5> RM_IHPSG13_1P_BITKIT_16x2_EDGE_LR_1[0]/LWL<7>
+ RM_IHPSG13_1P_BITKIT_16x2_EDGE_LR_2[1]/LWL<15> RM_IHPSG13_1P_BITKIT_16x2_EDGE_LR_0[1]/LWL<0>
+ RM_IHPSG13_1P_BITKIT_16x2_EDGE_LR_2[0]/LWL<2> RM_IHPSG13_1P_BITKIT_16x2_EDGE_LR_1[0]/LWL<11>
+ RM_IHPSG13_1P_COLUMN_256_0[7]/RM_IHPSG13_1P_BITKIT_16x2_SRAM_2[0]/A_LWL<2> RM_IHPSG13_1P_BITKIT_16x2_EDGE_LR_2[0]/LWL<15>
+ RM_IHPSG13_1P_COLUMN_256_0[7]/RM_IHPSG13_1P_BITKIT_16x2_SRAM_0[0]/A_LWL<4> RM_IHPSG13_1P_COLUMN_256_0[7]/RM_IHPSG13_1P_BITKIT_16x2_SRAM_1[0]/A_LWL<12>
+ RM_IHPSG13_1P_BITKIT_16x2_EDGE_LR_1[0]/LWL<8> RM_IHPSG13_1P_BITKIT_16x2_EDGE_LR_3[0]/LWL<9>
+ RM_IHPSG13_1P_COLUMN_256_0[7]/RM_IHPSG13_1P_BITKIT_16x2_SRAM_3[1]/A_LWL<13> RM_IHPSG13_1P_BITKIT_16x2_EDGE_LR_3[3]/LWL<9>
+ RM_IHPSG13_1P_COLUMN_256_0[7]/RM_IHPSG13_1P_BITKIT_16x2_SRAM_2[3]/A_LWL<10> RM_IHPSG13_1P_BITKIT_16x2_EDGE_LR_2[2]/LWL<13>
+ RM_IHPSG13_1P_COLUMN_256_0[7]/RM_IHPSG13_1P_BITKIT_16x2_SRAM_3[2]/A_LWL<11> RM_IHPSG13_1P_BITKIT_16x2_EDGE_LR_0[0]/LWL<7>
+ RM_IHPSG13_1P_COLUMN_256_0[7]/RM_IHPSG13_1P_BITKIT_16x2_SRAM_0[3]/A_LWL<5> RM_IHPSG13_1P_BITKIT_16x2_EDGE_LR_3[0]/LWL<2>
+ RM_IHPSG13_1P_COLUMN_256_0[7]/RM_IHPSG13_1P_BITKIT_16x2_SRAM_2[2]/A_LWL<14> RM_IHPSG13_1P_COLUMN_256_0[7]/RM_IHPSG13_1P_BITKIT_16x2_SRAM_3[0]/A_LWL<3>
+ RM_IHPSG13_1P_COLUMN_256_0[7]/RM_IHPSG13_1P_BITKIT_16x2_SRAM_2[0]/A_LWL<4> RM_IHPSG13_1P_COLUMN_256_0[7]/RM_IHPSG13_1P_BITKIT_16x2_SRAM_3[3]/A_LWL<14>
+ RM_IHPSG13_1P_BITKIT_16x2_EDGE_LR_1[1]/LWL<10> RM_IHPSG13_1P_COLUMN_256_0[7]/RM_IHPSG13_1P_BITKIT_16x2_SRAM_1[0]/A_LWL<5>
+ RM_IHPSG13_1P_BITKIT_16x2_EDGE_LR_2[1]/LWL<0> RM_IHPSG13_1P_BITKIT_16x2_EDGE_LR_1[0]/LWL<10>
+ RM_IHPSG13_1P_BITKIT_16x2_EDGE_LR_1[0]/LWL<12> RM_IHPSG13_1P_BITKIT_16x2_EDGE_LR_2[3]/LWL<11>
+ RM_IHPSG13_1P_COLUMN_256_0[7]/RM_IHPSG13_1P_BITKIT_16x2_SRAM_0[0]/A_LWL<6> RM_IHPSG13_1P_BITKIT_16x2_EDGE_LR_1[1]/LWL<1>
+ RM_IHPSG13_1P_BITKIT_16x2_EDGE_LR_1[3]/LWL<8> RM_IHPSG13_1P_BITKIT_16x2_EDGE_LR_3[1]/LWL<2>
+ RM_IHPSG13_1P_BITKIT_16x2_EDGE_LR_1[0]/LWL<14> RM_IHPSG13_1P_COLUMN_256_0[7]/RM_IHPSG13_1P_BITKIT_16x2_SRAM_3[0]/A_LWL<13>
+ RM_IHPSG13_1P_BITKIT_16x2_EDGE_LR_2[2]/LWL<15> RM_IHPSG13_1P_BITKIT_16x2_EDGE_LR_1[1]/LWL<11>
+ RM_IHPSG13_1P_COLUMN_256_0[7]/RM_IHPSG13_1P_BITKIT_16x2_SRAM_3[1]/A_LWL<11> RM_IHPSG13_1P_COLUMN_256_0[7]/RM_IHPSG13_1P_BITKIT_16x2_SRAM_3[0]/A_LWL<0>
+ RM_IHPSG13_1P_BITKIT_16x2_EDGE_LR_2[3]/LWL<12> RM_IHPSG13_1P_COLUMN_256_0[7]/RM_IHPSG13_1P_BITKIT_16x2_SRAM_0[0]/A_LWL<7>
+ RM_IHPSG13_1P_COLUMN_256_0[7]/RM_IHPSG13_1P_BITKIT_16x2_SRAM_1[0]/A_LWL<15> RM_IHPSG13_1P_BITKIT_16x2_EDGE_LR_3[1]/LWL<3>
+ RM_IHPSG13_1P_COLUMN_256_0[7]/RM_IHPSG13_1P_BITKIT_16x2_SRAM_1[1]/A_LWL<12> RM_IHPSG13_1P_BITKIT_16x2_EDGE_LR_0[1]/LWL<4>
+ RM_IHPSG13_1P_COLUMN_256_0[7]/RM_IHPSG13_1P_BITKIT_16x2_SRAM_3[0]/A_LWL<5> RM_IHPSG13_1P_COLUMN_256_0[7]/RM_IHPSG13_1P_BITKIT_16x2_SRAM_2[0]/A_LWL<6>
+ RM_IHPSG13_1P_COLUMN_256_0[7]/RM_IHPSG13_1P_BITKIT_16x2_SRAM_3[2]/A_LWL<14> RM_IHPSG13_1P_COLUMN_256_0[7]/RM_IHPSG13_1P_BITKIT_16x2_SRAM_1[0]/A_LWL<7>
+ RM_IHPSG13_1P_BITKIT_16x2_EDGE_LR_2[1]/LWL<2> RM_IHPSG13_1P_BITKIT_16x2_EDGE_LR_2[2]/LWL<11>
+ RM_IHPSG13_1P_BITKIT_16x2_EDGE_LR_2[3]/LWL<13> RM_IHPSG13_1P_COLUMN_256_0[7]/RM_IHPSG13_1P_BITKIT_16x2_SRAM_0[0]/A_LWL<8>
+ RM_IHPSG13_1P_BITKIT_16x2_EDGE_LR_1[3]/LWL<6> RM_IHPSG13_1P_BITKIT_16x2_EDGE_LR_3[1]/LWL<4>
+ RM_IHPSG13_1P_BITKIT_16x2_EDGE_LR_0[0]/LWL<1> RM_IHPSG13_1P_COLUMN_256_0[7]/RM_IHPSG13_1P_BITKIT_16x2_SRAM_1[1]/A_LWL<13>
+ RM_IHPSG13_1P_COLUMN_256_0[7]/RM_IHPSG13_1P_BITKIT_16x2_SRAM_1[0]/A_LWL<13> RM_IHPSG13_1P_BITKIT_16x2_EDGE_LR_0[1]/LWL<5>
+ RM_IHPSG13_1P_COLUMN_256_0[7]/RM_IHPSG13_1P_BITKIT_16x2_SRAM_3[0]/A_LWL<6> RM_IHPSG13_1P_COLUMN_256_0[7]/RM_IHPSG13_1P_BITKIT_16x2_SRAM_2[3]/A_LWL<12>
+ RM_IHPSG13_1P_COLUMN_256_0[7]/RM_IHPSG13_1P_BITKIT_16x2_SRAM_1[1]/A_LWL<11> RM_IHPSG13_1P_BITKIT_16x2_EDGE_LR_0[0]/LWL<8>
+ RM_IHPSG13_1P_COLUMN_256_0[7]/RM_IHPSG13_1P_BITKIT_16x2_SRAM_1[0]/A_LWL<0> RM_IHPSG13_1P_COLUMN_256_0[7]/RM_IHPSG13_1P_BITKIT_16x2_SRAM_0[3]/A_LWL<3>
+ RM_IHPSG13_1P_BITKIT_16x2_EDGE_LR_1[1]/LWL<12> RM_IHPSG13_1P_BITKIT_16x2_EDGE_LR_1[0]/LWL<9>
+ RM_IHPSG13_1P_BITKIT_16x2_EDGE_LR_2[1]/LWL<3> RM_IHPSG13_1P_COLUMN_256_0[7]/RM_IHPSG13_1P_BITKIT_16x2_SRAM_2[3]/A_LWL<2>
+ RM_IHPSG13_1P_BITKIT_16x2_EDGE_LR_2[3]/LWL<14> RM_IHPSG13_1P_BITKIT_16x2_EDGE_LR_1[2]/LWL<10>
+ RM_IHPSG13_1P_COLUMN_256_0[7]/RM_IHPSG13_1P_BITKIT_16x2_SRAM_2[0]/A_LWL<5> RM_IHPSG13_1P_COLUMN_256_0[7]/RM_IHPSG13_1P_BITKIT_16x2_SRAM_3[3]/A_LWL<4>
+ RM_IHPSG13_1P_BITKIT_16x2_EDGE_LR_1[1]/LWL<3> RM_IHPSG13_1P_COLUMN_256_0[7]/RM_IHPSG13_1P_BITKIT_16x2_SRAM_3[0]/A_LWL<7>
+ RM_IHPSG13_1P_COLUMN_256_0[7]/RM_IHPSG13_1P_BITKIT_16x2_SRAM_0[0]/A_LWL<10> RM_IHPSG13_1P_COLUMN_256_0[7]/RM_IHPSG13_1P_BITKIT_16x2_SRAM_1[1]/A_LWL<0>
+ RM_IHPSG13_1P_COLUMN_256_0[7]/RM_IHPSG13_1P_BITKIT_16x2_SRAM_2[0]/A_LWL<8> RM_IHPSG13_1P_COLUMN_256_0[7]/RM_IHPSG13_1P_BITKIT_16x2_SRAM_3[1]/A_LWL<14>
+ RM_IHPSG13_1P_COLUMN_256_0[7]/RM_IHPSG13_1P_BITKIT_16x2_SRAM_1[2]/A_LWL<11> RM_IHPSG13_1P_BITKIT_16x2_EDGE_LR_1[1]/LWL<14>
+ RM_IHPSG13_1P_COLUMN_256_0[7]/RM_IHPSG13_1P_BITKIT_16x2_SRAM_0[1]/A_LWL<1> RM_IHPSG13_1P_COLUMN_256_0[7]/RM_IHPSG13_1P_BITKIT_16x2_SRAM_1[0]/A_LWL<9>
+ RM_IHPSG13_1P_BITKIT_16x2_EDGE_LR_2[1]/LWL<4> RM_IHPSG13_1P_BITKIT_16x2_EDGE_LR_3[0]/LWL<0>
+ RM_IHPSG13_1P_BITKIT_16x2_EDGE_LR_2[1]/LWL<11> RM_IHPSG13_1P_BITKIT_16x2_EDGE_LR_2[3]/LWL<15>
+ RM_IHPSG13_1P_BITKIT_16x2_EDGE_LR_0[3]/LWL<6> RM_IHPSG13_1P_BITKIT_16x2_EDGE_LR_1[1]/LWL<5>
+ RM_IHPSG13_1P_BITKIT_16x2_EDGE_LR_1[2]/LWL<11> RM_IHPSG13_1P_BITKIT_16x2_EDGE_LR_2[0]/LWL<1>
+ RM_IHPSG13_1P_BITKIT_16x2_EDGE_LR_2[3]/LWL<5> RM_IHPSG13_1P_BITKIT_16x2_EDGE_LR_3[1]/LWL<6>
+ RM_IHPSG13_1P_BITKIT_16x2_EDGE_LR_2[0]/LWL<8> RM_IHPSG13_1P_COLUMN_256_0[7]/RM_IHPSG13_1P_BITKIT_16x2_SRAM_1[1]/A_LWL<15>
+ RM_IHPSG13_1P_BITKIT_16x2_EDGE_LR_0[1]/LWL<7> RM_IHPSG13_1P_COLUMN_256_0[7]/RM_IHPSG13_1P_BITKIT_16x2_SRAM_3[3]/A_LWL<3>
+ RM_IHPSG13_1P_COLUMN_256_0[7]/RM_IHPSG13_1P_BITKIT_16x2_SRAM_0[0]/A_LWL<11> RM_IHPSG13_1P_COLUMN_256_0[7]/RM_IHPSG13_1P_BITKIT_16x2_SRAM_2[2]/A_LWL<12>
+ RM_IHPSG13_1P_COLUMN_256_0[7]/RM_IHPSG13_1P_BITKIT_16x2_SRAM_1[0]/A_LWL<11> RM_IHPSG13_1P_COLUMN_256_0[7]/RM_IHPSG13_1P_BITKIT_16x2_SRAM_1[2]/A_LWL<12>
+ RM_IHPSG13_1P_BITKIT_16x2_EDGE_LR_2[2]/LWL<14> RM_IHPSG13_1P_BITKIT_16x2_EDGE_LR_2[1]/LWL<5>
+ RM_IHPSG13_1P_COLUMN_256_0[7]/RM_IHPSG13_1P_BITKIT_16x2_SRAM_0[0]/A_LWL<5> RM_IHPSG13_1P_COLUMN_256_0[7]/RM_IHPSG13_1P_BITKIT_16x2_SRAM_1[3]/A_LWL<4>
+ RM_IHPSG13_1P_BITKIT_16x2_EDGE_LR_0[1]/LWL<1> RM_IHPSG13_1P_BITKIT_16x2_EDGE_LR_0[1]/LWL<3>
+ RM_IHPSG13_1P_COLUMN_256_0[7]/RM_IHPSG13_1P_BITKIT_16x2_SRAM_3[1]/A_LWL<0> RM_IHPSG13_1P_BITKIT_16x2_EDGE_LR_1[0]/LWL<3>
+ RM_IHPSG13_1P_COLUMN_256_0[7]/RM_IHPSG13_1P_BITKIT_16x2_SRAM_2[3]/A_LWL<9> RM_IHPSG13_1P_COLUMN_256_0[7]/RM_IHPSG13_1P_BITKIT_16x2_SRAM_2[1]/A_LWL<1>
+ RM_IHPSG13_1P_COLUMN_256_0[7]/RM_IHPSG13_1P_BITKIT_16x2_SRAM_3[0]/A_LWL<9> RM_IHPSG13_1P_BITKIT_16x2_EDGE_LR_0[1]/LWL<8>
+ RM_IHPSG13_1P_COLUMN_256_0[7]/RM_IHPSG13_1P_BITKIT_16x2_SRAM_1[1]/A_LWL<14> RM_IHPSG13_1P_COLUMN_256_0[7]/RM_IHPSG13_1P_BITKIT_16x2_SRAM_0[0]/A_LWL<2>
+ RM_IHPSG13_1P_BITKIT_16x2_EDGE_LR_1[2]/LWL<12> RM_IHPSG13_1P_COLUMN_256_0[7]/RM_IHPSG13_1P_BITKIT_16x2_SRAM_1[1]/A_LWL<2>
+ RM_IHPSG13_1P_COLUMN_256_0[7]/RM_IHPSG13_1P_BITKIT_16x2_SRAM_0[3]/A_LWL<6> RM_IHPSG13_1P_COLUMN_256_0[7]/RM_IHPSG13_1P_BITKIT_16x2_SRAM_3[0]/A_LWL<14>
+ RM_IHPSG13_1P_COLUMN_256_0[7]/RM_IHPSG13_1P_BITKIT_16x2_SRAM_1[2]/A_LWL<13> RM_IHPSG13_1P_COLUMN_256_0[7]/RM_IHPSG13_1P_BITKIT_16x2_SRAM_0[1]/A_LWL<3>
+ RM_IHPSG13_1P_BITKIT_16x2_EDGE_LR_3[0]/LWL<12> RM_IHPSG13_1P_BITKIT_16x2_EDGE_LR_2[1]/LWL<6>
+ RM_IHPSG13_1P_BITKIT_16x2_EDGE_LR_2[0]/LWL<11> RM_IHPSG13_1P_COLUMN_256_0[7]/RM_IHPSG13_1P_BITKIT_16x2_SRAM_3[3]/A_LWL<1>
+ RM_IHPSG13_1P_BITKIT_16x2_EDGE_LR_1[1]/LWL<7> RM_IHPSG13_1P_BITKIT_16x2_EDGE_LR_1[1]/LWL<6>
+ RM_IHPSG13_1P_BITKIT_16x2_EDGE_LR_0[2]/LWL<0> RM_IHPSG13_1P_BITKIT_16x2_EDGE_LR_1[3]/LWL<10>
+ RM_IHPSG13_1P_COLUMN_256_0[7]/RM_IHPSG13_1P_BITKIT_16x2_SRAM_2[1]/A_LWL<2> RM_IHPSG13_1P_COLUMN_256_0[7]/RM_IHPSG13_1P_BITKIT_16x2_SRAM_0[0]/A_LWL<13>
+ RM_IHPSG13_1P_COLUMN_256_0[7]/RM_IHPSG13_1P_BITKIT_16x2_SRAM_2[1]/A_LWL<12> RM_IHPSG13_1P_BITKIT_16x2_EDGE_LR_3[1]/LWL<0>
+ RM_IHPSG13_1P_COLUMN_256_0[7]/RM_IHPSG13_1P_BITKIT_16x2_SRAM_1[2]/A_LWL<14> RM_IHPSG13_1P_BITKIT_16x2_EDGE_LR_3[0]/LWL<5>
+ RM_IHPSG13_1P_COLUMN_256_0[7]/RM_IHPSG13_1P_BITKIT_16x2_SRAM_0[1]/A_LWL<10> RM_IHPSG13_1P_COLUMN_256_0[7]/RM_IHPSG13_1P_BITKIT_16x2_SRAM_0[1]/A_LWL<4>
+ RM_IHPSG13_1P_BITKIT_16x2_EDGE_LR_2[1]/LWL<14> RM_IHPSG13_1P_BITKIT_16x2_EDGE_LR_2[1]/LWL<1>
+ RM_IHPSG13_1P_BITKIT_16x2_EDGE_LR_3[0]/LWL<13> RM_IHPSG13_1P_COLUMN_256_0[7]/RM_IHPSG13_1P_BITKIT_16x2_SRAM_1[3]/A_LWL<11>
+ RM_IHPSG13_1P_BITKIT_16x2_EDGE_LR_1[1]/LWL<8> RM_IHPSG13_1P_COLUMN_256_0[7]/RM_IHPSG13_1P_BITKIT_16x2_SRAM_1[0]/A_LWL<3>
+ RM_IHPSG13_1P_BITKIT_16x2_EDGE_LR_1[2]/LWL<14> RM_IHPSG13_1P_COLUMN_256_0[7]/RM_IHPSG13_1P_BITKIT_16x2_SRAM_1[3]/A_LWL<7>
+ RM_IHPSG13_1P_BITKIT_16x2_EDGE_LR_0[0]/LWL<3> RM_IHPSG13_1P_COLUMN_256_0[7]/RM_IHPSG13_1P_BITKIT_16x2_SRAM_0[3]/A_LWL<9>
+ RM_IHPSG13_1P_COLUMN_256_0[7]/RM_IHPSG13_1P_BITKIT_16x2_SRAM_3[0]/A_LWL<2> RM_IHPSG13_1P_BITKIT_16x2_EDGE_LR_3[1]/LWL<9>
+ RM_IHPSG13_1P_COLUMN_256_0[7]/RM_IHPSG13_1P_BITKIT_16x2_SRAM_3[3]/A_LWL<6> RM_IHPSG13_1P_COLUMN_256_0[7]/RM_IHPSG13_1P_BITKIT_16x2_SRAM_2[2]/A_LWL<9>
+ RM_IHPSG13_1P_COLUMN_256_0[7]/RM_IHPSG13_1P_BITKIT_16x2_SRAM_2[1]/A_LWL<3> RM_IHPSG13_1P_COLUMN_256_0[7]/RM_IHPSG13_1P_BITKIT_16x2_SRAM_0[0]/A_LWL<14>
+ RM_IHPSG13_1P_COLUMN_256_0[7]/RM_IHPSG13_1P_BITKIT_16x2_SRAM_1[0]/A_LWL<14> RM_IHPSG13_1P_COLUMN_256_0[7]/RM_IHPSG13_1P_BITKIT_16x2_SRAM_2[3]/A_LWL<15>
+ RM_IHPSG13_1P_COLUMN_256_0[7]/RM_IHPSG13_1P_BITKIT_16x2_SRAM_1[2]/A_LWL<15> RM_IHPSG13_1P_COLUMN_256_0[7]/RM_IHPSG13_1P_BITKIT_16x2_SRAM_0[1]/A_LWL<11>
+ RM_IHPSG13_1P_COLUMN_256_0[7]/RM_IHPSG13_1P_BITKIT_16x2_SRAM_0[1]/A_LWL<5> RM_IHPSG13_1P_BITKIT_16x2_EDGE_LR_3[0]/LWL<11>
+ RM_IHPSG13_1P_BITKIT_16x2_EDGE_LR_1[2]/LWL<0> RM_IHPSG13_1P_COLUMN_256_0[7]/RM_IHPSG13_1P_BITKIT_16x2_SRAM_1[3]/A_LWL<1>
+ RM_IHPSG13_1P_BITKIT_16x2_EDGE_LR_2[1]/LWL<8> RM_IHPSG13_1P_BITKIT_16x2_EDGE_LR_0[2]/LWL<1>
+ RM_IHPSG13_1P_COLUMN_256_0[7]/RM_IHPSG13_1P_BITKIT_16x2_SRAM_3[3]/A_LWL<10> RM_IHPSG13_1P_COLUMN_256_0[7]/RM_IHPSG13_1P_BITKIT_16x2_SRAM_1[3]/A_LWL<12>
+ RM_IHPSG13_1P_BITKIT_16x2_EDGE_LR_3[2]/LWL<1> RM_IHPSG13_1P_BITKIT_16x2_EDGE_LR_0[1]/LWL<6>
+ RM_IHPSG13_1P_BITKIT_16x2_EDGE_LR_1[1]/LWL<9> RM_IHPSG13_1P_BITKIT_16x2_EDGE_LR_3[1]/LWL<11>
+ RM_IHPSG13_1P_BITKIT_16x2_EDGE_LR_1[0]/LWL<6> RM_IHPSG13_1P_COLUMN_256_0[7]/RM_IHPSG13_1P_BITKIT_16x2_SRAM_3[1]/A_LWL<3>
+ RM_IHPSG13_1P_BITKIT_16x2_EDGE_LR_1[0]/LWL<4> RM_IHPSG13_1P_BITKIT_16x2_EDGE_LR_2[3]/LWL<7>
+ RM_IHPSG13_1P_COLUMN_256_0[7]/RM_IHPSG13_1P_BITKIT_16x2_SRAM_0[1]/A_LWL<2> RM_IHPSG13_1P_BITKIT_16x2_EDGE_LR_1[3]/LWL<12>
+ RM_IHPSG13_1P_COLUMN_256_0[7]/RM_IHPSG13_1P_BITKIT_16x2_SRAM_2[1]/A_LWL<4> RM_IHPSG13_1P_COLUMN_256_0[7]/RM_IHPSG13_1P_BITKIT_16x2_SRAM_2[0]/A_LWL<12>
+ RM_IHPSG13_1P_COLUMN_256_0[7]/RM_IHPSG13_1P_BITKIT_16x2_SRAM_1[1]/A_LWL<5> RM_IHPSG13_1P_BITKIT_16x2_EDGE_LR_2[2]/LWL<0>
+ RM_IHPSG13_1P_COLUMN_256_0[7]/RM_IHPSG13_1P_BITKIT_16x2_SRAM_0[1]/A_LWL<12> RM_IHPSG13_1P_COLUMN_256_0[7]/RM_IHPSG13_1P_BITKIT_16x2_SRAM_0[1]/A_LWL<6>
+ RM_IHPSG13_1P_BITKIT_16x2_EDGE_LR_1[2]/LWL<1> RM_IHPSG13_1P_BITKIT_16x2_EDGE_LR_2[0]/LWL<14>
+ RM_IHPSG13_1P_BITKIT_16x2_EDGE_LR_3[0]/LWL<15> RM_IHPSG13_1P_COLUMN_256_0[7]/RM_IHPSG13_1P_BITKIT_16x2_SRAM_1[1]/A_LWL<4>
+ RM_IHPSG13_1P_COLUMN_256_0[7]/RM_IHPSG13_1P_BITKIT_16x2_SRAM_1[3]/A_LWL<13> RM_IHPSG13_1P_BITKIT_16x2_EDGE_LR_3[2]/LWL<2>
+ RM_IHPSG13_1P_BITKIT_16x2_EDGE_LR_3[1]/LWL<12> RM_IHPSG13_1P_COLUMN_256_0[7]/RM_IHPSG13_1P_BITKIT_16x2_SRAM_3[0]/A_LWL<4>
+ RM_IHPSG13_1P_COLUMN_256_0[7]/RM_IHPSG13_1P_BITKIT_16x2_SRAM_0[2]/A_LWL<9> RM_IHPSG13_1P_BITKIT_16x2_EDGE_LR_0[2]/LWL<3>
+ RM_IHPSG13_1P_COLUMN_256_0[7]/RM_IHPSG13_1P_BITKIT_16x2_SRAM_3[1]/A_LWL<4> RM_IHPSG13_1P_COLUMN_256_0[7]/RM_IHPSG13_1P_BITKIT_16x2_SRAM_2[1]/A_LWL<5>
+ RM_IHPSG13_1P_BITKIT_16x2_EDGE_LR_3[2]/LWL<0> RM_IHPSG13_1P_BITKIT_16x2_EDGE_LR_3[1]/LWL<5>
+ RM_IHPSG13_1P_COLUMN_256_0[7]/RM_IHPSG13_1P_BITKIT_16x2_SRAM_2[2]/A_LWL<15> RM_IHPSG13_1P_BITKIT_16x2_EDGE_LR_2[2]/LWL<1>
+ RM_IHPSG13_1P_COLUMN_256_0[7]/RM_IHPSG13_1P_BITKIT_16x2_SRAM_1[3]/A_LWL<10> RM_IHPSG13_1P_COLUMN_256_0[7]/RM_IHPSG13_1P_BITKIT_16x2_SRAM_0[1]/A_LWL<7>
+ RM_IHPSG13_1P_COLUMN_256_0[7]/RM_IHPSG13_1P_BITKIT_16x2_SRAM_1[1]/A_LWL<3> RM_IHPSG13_1P_COLUMN_256_0[7]/RM_IHPSG13_1P_BITKIT_16x2_SRAM_1[0]/A_LWL<6>
+ RM_IHPSG13_1P_COLUMN_256_0[7]/RM_IHPSG13_1P_BITKIT_16x2_SRAM_3[2]/A_LWL<10> RM_IHPSG13_1P_COLUMN_256_0[7]/RM_IHPSG13_1P_BITKIT_16x2_SRAM_1[3]/A_LWL<14>
+ RM_IHPSG13_1P_COLUMN_256_0[7]/RM_IHPSG13_1P_BITKIT_16x2_SRAM_3[1]/A_LWL<1> RM_IHPSG13_1P_COLUMN_256_0[7]/RM_IHPSG13_1P_BITKIT_16x2_SRAM_3[1]/A_LWL<2>
+ RM_IHPSG13_1P_BITKIT_16x2_EDGE_LR_0[0]/LWL<6> RM_IHPSG13_1P_BITKIT_16x2_EDGE_LR_3[2]/LWL<3>
+ RM_IHPSG13_1P_COLUMN_256_0[7]/RM_IHPSG13_1P_BITKIT_16x2_SRAM_0[2]/A_LWL<10> RM_IHPSG13_1P_BITKIT_16x2_EDGE_LR_3[3]/LWL<7>
+ RM_IHPSG13_1P_BITKIT_16x2_EDGE_LR_3[1]/LWL<13> RM_IHPSG13_1P_BITKIT_16x2_EDGE_LR_0[2]/LWL<4>
+ RM_IHPSG13_1P_COLUMN_256_0[7]/RM_IHPSG13_1P_BITKIT_16x2_SRAM_0[0]/A_LWL<12> RM_IHPSG13_1P_BITKIT_16x2_EDGE_LR_1[3]/LWL<14>
+ RM_IHPSG13_1P_COLUMN_256_0[7]/RM_IHPSG13_1P_BITKIT_16x2_SRAM_2[1]/A_LWL<6> RM_IHPSG13_1P_COLUMN_256_0[7]/RM_IHPSG13_1P_BITKIT_16x2_SRAM_1[1]/A_LWL<7>
+ RM_IHPSG13_1P_BITKIT_16x2_EDGE_LR_2[2]/LWL<2> RM_IHPSG13_1P_BITKIT_16x2_EDGE_LR_3[0]/LWL<14>
+ RM_IHPSG13_1P_COLUMN_256_0[7]/RM_IHPSG13_1P_BITKIT_16x2_SRAM_0[1]/A_LWL<14> RM_IHPSG13_1P_COLUMN_256_0[7]/RM_IHPSG13_1P_BITKIT_16x2_SRAM_0[1]/A_LWL<8>
+ RM_IHPSG13_1P_BITKIT_16x2_EDGE_LR_1[2]/LWL<3> RM_IHPSG13_1P_COLUMN_256_0[7]/RM_IHPSG13_1P_BITKIT_16x2_SRAM_1[3]/A_LWL<15>
+ RM_IHPSG13_1P_COLUMN_256_0[7]/RM_IHPSG13_1P_BITKIT_16x2_SRAM_1[0]/A_LWL<4> RM_IHPSG13_1P_BITKIT_16x2_EDGE_LR_3[2]/LWL<4>
+ RM_IHPSG13_1P_BITKIT_16x2_EDGE_LR_0[3]/LWL<8> RM_IHPSG13_1P_BITKIT_16x2_EDGE_LR_1[1]/LWL<4>
+ RM_IHPSG13_1P_BITKIT_16x2_EDGE_LR_1[0]/LWL<13> RM_IHPSG13_1P_BITKIT_16x2_EDGE_LR_2[3]/LWL<10>
+ RM_IHPSG13_1P_BITKIT_16x2_EDGE_LR_3[1]/LWL<14> RM_IHPSG13_1P_BITKIT_16x2_EDGE_LR_0[2]/LWL<5>
+ RM_IHPSG13_1P_BITKIT_16x2_EDGE_LR_0[0]/LWL<10> RM_IHPSG13_1P_BITKIT_16x2_EDGE_LR_1[3]/LWL<9>
+ RM_IHPSG13_1P_COLUMN_256_0[7]/RM_IHPSG13_1P_BITKIT_16x2_SRAM_3[1]/A_LWL<6> RM_IHPSG13_1P_COLUMN_256_0[7]/RM_IHPSG13_1P_BITKIT_16x2_SRAM_2[0]/A_LWL<9>
+ RM_IHPSG13_1P_BITKIT_16x2_EDGE_LR_1[3]/LWL<15> RM_IHPSG13_1P_BITKIT_16x2_EDGE_LR_3[2]/LWL<11>
+ RM_IHPSG13_1P_COLUMN_256_0[7]/RM_IHPSG13_1P_BITKIT_16x2_SRAM_2[0]/A_LWL<7> RM_IHPSG13_1P_COLUMN_256_0[7]/RM_IHPSG13_1P_BITKIT_16x2_SRAM_3[3]/A_LWL<8>
+ RM_IHPSG13_1P_COLUMN_256_0[7]/RM_IHPSG13_1P_BITKIT_16x2_SRAM_2[1]/A_LWL<15> RM_IHPSG13_1P_COLUMN_256_0[7]/RM_IHPSG13_1P_BITKIT_16x2_SRAM_1[2]/A_LWL<10>
+ RM_IHPSG13_1P_COLUMN_256_0[7]/RM_IHPSG13_1P_BITKIT_16x2_SRAM_0[1]/A_LWL<9> RM_IHPSG13_1P_COLUMN_256_0[7]/RM_IHPSG13_1P_BITKIT_16x2_SRAM_1[1]/A_LWL<1>
+ RM_IHPSG13_1P_COLUMN_256_0[7]/RM_IHPSG13_1P_BITKIT_16x2_SRAM_3[1]/A_LWL<10> RM_IHPSG13_1P_COLUMN_256_0[7]/RM_IHPSG13_1P_BITKIT_16x2_SRAM_3[0]/A_LWL<1>
+ RM_IHPSG13_1P_COLUMN_256_0[7]/RM_IHPSG13_1P_BITKIT_16x2_SRAM_0[2]/A_LWL<12> RM_IHPSG13_1P_BITKIT_16x2_EDGE_LR_3[1]/LWL<15>
+ RM_IHPSG13_1P_BITKIT_16x2_EDGE_LR_0[2]/LWL<6> RM_IHPSG13_1P_BITKIT_16x2_EDGE_LR_0[0]/LWL<11>
+ RM_IHPSG13_1P_COLUMN_256_0[7]/RM_IHPSG13_1P_BITKIT_16x2_SRAM_3[1]/A_LWL<7> RM_IHPSG13_1P_BITKIT_16x2_EDGE_LR_2[1]/LWL<7>
+ RM_IHPSG13_1P_BITKIT_16x2_EDGE_LR_3[2]/LWL<5> RM_IHPSG13_1P_COLUMN_256_0[7]/RM_IHPSG13_1P_BITKIT_16x2_SRAM_1[2]/A_LWL<0>
+ RM_IHPSG13_1P_BITKIT_16x2_EDGE_LR_3[2]/LWL<12> RM_IHPSG13_1P_COLUMN_256_0[7]/RM_IHPSG13_1P_BITKIT_16x2_SRAM_2[1]/A_LWL<8>
+ RM_IHPSG13_1P_BITKIT_16x2_EDGE_LR_1[2]/LWL<2> RM_IHPSG13_1P_COLUMN_256_0[7]/RM_IHPSG13_1P_BITKIT_16x2_SRAM_0[2]/A_LWL<1>
+ RM_IHPSG13_1P_BITKIT_16x2_EDGE_LR_0[3]/LWL<15> RM_IHPSG13_1P_COLUMN_256_0[7]/RM_IHPSG13_1P_BITKIT_16x2_SRAM_1[1]/A_LWL<9>
+ RM_IHPSG13_1P_BITKIT_16x2_EDGE_LR_2[2]/LWL<4> RM_IHPSG13_1P_BITKIT_16x2_EDGE_LR_2[0]/LWL<12>
+ RM_IHPSG13_1P_COLUMN_256_0[7]/RM_IHPSG13_1P_BITKIT_16x2_SRAM_1[1]/A_LWL<6> RM_IHPSG13_1P_BITKIT_16x2_EDGE_LR_2[3]/LWL<8>
+ RM_IHPSG13_1P_BITKIT_16x2_EDGE_LR_1[2]/LWL<15> RM_IHPSG13_1P_BITKIT_16x2_EDGE_LR_1[2]/LWL<5>
+ RM_IHPSG13_1P_BITKIT_16x2_EDGE_LR_3[2]/LWL<6> RM_IHPSG13_1P_BITKIT_16x2_EDGE_LR_2[2]/LWL<10>
+ RM_IHPSG13_1P_COLUMN_256_0[7]/RM_IHPSG13_1P_BITKIT_16x2_SRAM_0[0]/A_LWL<9> RM_IHPSG13_1P_BITKIT_16x2_EDGE_LR_0[0]/LWL<12>
+ RM_IHPSG13_1P_BITKIT_16x2_EDGE_LR_0[2]/LWL<7> RM_IHPSG13_1P_COLUMN_256_0[7]/RM_IHPSG13_1P_BITKIT_16x2_SRAM_1[3]/A_LWL<8>
+ RM_IHPSG13_1P_COLUMN_256_0[7]/RM_IHPSG13_1P_BITKIT_16x2_SRAM_0[3]/A_LWL<10> RM_IHPSG13_1P_COLUMN_256_0[7]/RM_IHPSG13_1P_BITKIT_16x2_SRAM_1[2]/A_LWL<1>
+ RM_IHPSG13_1P_COLUMN_256_0[7]/RM_IHPSG13_1P_BITKIT_16x2_SRAM_2[1]/A_LWL<9> RM_IHPSG13_1P_BITKIT_16x2_EDGE_LR_3[2]/LWL<13>
+ RM_IHPSG13_1P_COLUMN_256_0[7]/RM_IHPSG13_1P_BITKIT_16x2_SRAM_0[1]/A_LWL<15> RM_IHPSG13_1P_COLUMN_256_0[7]/RM_IHPSG13_1P_BITKIT_16x2_SRAM_3[2]/A_LWL<8>
+ RM_IHPSG13_1P_COLUMN_256_0[7]/RM_IHPSG13_1P_BITKIT_16x2_SRAM_0[2]/A_LWL<2> RM_IHPSG13_1P_COLUMN_256_0[7]/RM_IHPSG13_1P_BITKIT_16x2_SRAM_2[0]/A_LWL<15>
+ RM_IHPSG13_1P_COLUMN_256_0[7]/RM_IHPSG13_1P_BITKIT_16x2_SRAM_2[3]/A_LWL<13> RM_IHPSG13_1P_BITKIT_16x2_EDGE_LR_2[2]/LWL<5>
+ RM_IHPSG13_1P_BITKIT_16x2_EDGE_LR_3[3]/LWL<10> RM_IHPSG13_1P_COLUMN_256_0[7]/RM_IHPSG13_1P_BITKIT_16x2_SRAM_1[1]/A_LWL<10>
+ RM_IHPSG13_1P_BITKIT_16x2_EDGE_LR_0[0]/LWL<9> RM_IHPSG13_1P_COLUMN_256_0[7]/RM_IHPSG13_1P_BITKIT_16x2_SRAM_1[0]/A_LWL<1>
+ RM_IHPSG13_1P_BITKIT_16x2_EDGE_LR_1[2]/LWL<6> RM_IHPSG13_1P_BITKIT_16x2_EDGE_LR_1[2]/LWL<4>
+ RM_IHPSG13_1P_BITKIT_16x2_EDGE_LR_1[1]/LWL<13> RM_IHPSG13_1P_COLUMN_256_0[7]/RM_IHPSG13_1P_BITKIT_16x2_SRAM_0[3]/A_LWL<2>
+ RM_IHPSG13_1P_COLUMN_256_0[7]/RM_IHPSG13_1P_BITKIT_16x2_SRAM_2[3]/A_LWL<0> RM_IHPSG13_1P_COLUMN_256_0[7]/RM_IHPSG13_1P_BITKIT_16x2_SRAM_3[2]/A_LWL<0>
+ RM_IHPSG13_1P_BITKIT_16x2_EDGE_LR_3[2]/LWL<7> RM_IHPSG13_1P_COLUMN_256_0[7]/RM_IHPSG13_1P_BITKIT_16x2_SRAM_0[2]/A_LWL<14>
+ RM_IHPSG13_1P_BITKIT_16x2_EDGE_LR_3[1]/LWL<7> RM_IHPSG13_1P_COLUMN_256_0[7]/RM_IHPSG13_1P_BITKIT_16x2_SRAM_2[2]/A_LWL<1>
+ RM_IHPSG13_1P_BITKIT_16x2_EDGE_LR_0[0]/LWL<13> RM_IHPSG13_1P_COLUMN_256_0[7]/RM_IHPSG13_1P_BITKIT_16x2_SRAM_2[1]/A_LWL<7>
+ RM_IHPSG13_1P_BITKIT_16x2_EDGE_LR_0[2]/LWL<8> RM_IHPSG13_1P_BITKIT_16x2_EDGE_LR_2[0]/LWL<7>
+ RM_IHPSG13_1P_COLUMN_256_0[7]/RM_IHPSG13_1P_BITKIT_16x2_SRAM_3[1]/A_LWL<9> RM_IHPSG13_1P_COLUMN_256_0[7]/RM_IHPSG13_1P_BITKIT_16x2_SRAM_3[3]/A_LWL<5>
+ RM_IHPSG13_1P_BITKIT_16x2_EDGE_LR_0[2]/LWL<2> RM_IHPSG13_1P_COLUMN_256_0[7]/RM_IHPSG13_1P_BITKIT_16x2_SRAM_1[2]/A_LWL<2>
+ RM_IHPSG13_1P_BITKIT_16x2_EDGE_LR_3[2]/LWL<14> RM_IHPSG13_1P_BITKIT_16x2_EDGE_LR_1[1]/LWL<2>
+ RM_IHPSG13_1P_BITKIT_16x2_EDGE_LR_0[1]/LWL<10> RM_IHPSG13_1P_COLUMN_256_0[7]/RM_IHPSG13_1P_BITKIT_16x2_SRAM_0[2]/A_LWL<3>
+ RM_IHPSG13_1P_BITKIT_16x2_EDGE_LR_0[2]/LWL<15> RM_IHPSG13_1P_BITKIT_16x2_EDGE_LR_2[2]/LWL<6>
+ RM_IHPSG13_1P_BITKIT_16x2_EDGE_LR_3[3]/LWL<11> RM_IHPSG13_1P_BITKIT_16x2_EDGE_LR_1[1]/LWL<15>
+ RM_IHPSG13_1P_BITKIT_16x2_EDGE_LR_1[2]/LWL<7> RM_IHPSG13_1P_BITKIT_16x2_EDGE_LR_3[2]/LWL<10>
+ RM_IHPSG13_1P_BITKIT_16x2_EDGE_LR_0[3]/LWL<0> RM_IHPSG13_1P_BITKIT_16x2_EDGE_LR_3[0]/LWL<1>
+ RM_IHPSG13_1P_COLUMN_256_0[7]/RM_IHPSG13_1P_BITKIT_16x2_SRAM_3[2]/A_LWL<1> RM_IHPSG13_1P_BITKIT_16x2_EDGE_LR_3[2]/LWL<8>
+ RM_IHPSG13_1P_COLUMN_256_0[7]/RM_IHPSG13_1P_BITKIT_16x2_SRAM_0[2]/A_LWL<15> RM_IHPSG13_1P_BITKIT_16x2_EDGE_LR_3[3]/LWL<5>
+ RM_IHPSG13_1P_BITKIT_16x2_EDGE_LR_2[1]/LWL<10> RM_IHPSG13_1P_BITKIT_16x2_EDGE_LR_0[0]/LWL<14>
+ RM_IHPSG13_1P_COLUMN_256_0[7]/RM_IHPSG13_1P_BITKIT_16x2_SRAM_2[2]/A_LWL<2> RM_IHPSG13_1P_COLUMN_256_0[7]/RM_IHPSG13_1P_BITKIT_16x2_SRAM_1[2]/A_LWL<8>
+ RM_IHPSG13_1P_BITKIT_16x2_EDGE_LR_3[0]/LWL<8> RM_IHPSG13_1P_COLUMN_256_0[7]/RM_IHPSG13_1P_BITKIT_16x2_SRAM_0[3]/A_LWL<12>
+ RM_IHPSG13_1P_COLUMN_256_0[7]/RM_IHPSG13_1P_BITKIT_16x2_SRAM_1[2]/A_LWL<3> RM_IHPSG13_1P_COLUMN_256_0[7]/RM_IHPSG13_1P_BITKIT_16x2_SRAM_3[1]/A_LWL<8>
+ RM_IHPSG13_1P_BITKIT_16x2_EDGE_LR_2[1]/LWL<12> RM_IHPSG13_1P_COLUMN_256_0[7]/RM_IHPSG13_1P_BITKIT_16x2_SRAM_1[3]/A_LWL<3>
+ RM_IHPSG13_1P_BITKIT_16x2_EDGE_LR_3[2]/LWL<15> RM_IHPSG13_1P_COLUMN_256_0[7]/RM_IHPSG13_1P_BITKIT_16x2_SRAM_0[0]/A_LWL<15>
+ RM_IHPSG13_1P_BITKIT_16x2_EDGE_LR_2[0]/LWL<9> RM_IHPSG13_1P_BITKIT_16x2_EDGE_LR_0[1]/LWL<11>
+ RM_IHPSG13_1P_COLUMN_256_0[7]/RM_IHPSG13_1P_BITKIT_16x2_SRAM_3[3]/A_LWL<2> RM_IHPSG13_1P_COLUMN_256_0[7]/RM_IHPSG13_1P_BITKIT_16x2_SRAM_0[2]/A_LWL<4>
+ RM_IHPSG13_1P_COLUMN_256_0[7]/RM_IHPSG13_1P_BITKIT_16x2_SRAM_2[2]/A_LWL<13> RM_IHPSG13_1P_BITKIT_16x2_EDGE_LR_2[2]/LWL<7>
+ RM_IHPSG13_1P_BITKIT_16x2_EDGE_LR_3[3]/LWL<12> RM_IHPSG13_1P_COLUMN_256_0[7]/RM_IHPSG13_1P_BITKIT_16x2_SRAM_0[3]/A_LWL<0>
+ RM_IHPSG13_1P_COLUMN_256_0[7]/RM_IHPSG13_1P_BITKIT_16x2_SRAM_1[0]/A_LWL<10> RM_IHPSG13_1P_BITKIT_16x2_EDGE_LR_3[3]/LWL<0>
+ RM_IHPSG13_1P_BITKIT_16x2_EDGE_LR_1[2]/LWL<8> RM_IHPSG13_1P_COLUMN_256_0[7]/RM_IHPSG13_1P_BITKIT_16x2_SRAM_2[3]/A_LWL<11>
+ RM_IHPSG13_1P_COLUMN_256_0[7]/RM_IHPSG13_1P_BITKIT_16x2_SRAM_2[2]/A_LWL<0> RM_IHPSG13_1P_BITKIT_16x2_EDGE_LR_0[3]/LWL<1>
+ RM_IHPSG13_1P_COLUMN_256_0[7]/RM_IHPSG13_1P_BITKIT_16x2_SRAM_3[2]/A_LWL<2> RM_IHPSG13_1P_BITKIT_16x2_EDGE_LR_3[2]/LWL<9>
+ RM_IHPSG13_1P_BITKIT_16x2_EDGE_LR_3[0]/LWL<7> RM_IHPSG13_1P_COLUMN_256_0[7]/RM_IHPSG13_1P_BITKIT_16x2_SRAM_1[3]/A_LWL<5>
+ RM_IHPSG13_1P_COLUMN_256_0[7]/RM_IHPSG13_1P_BITKIT_16x2_SRAM_2[2]/A_LWL<3> RM_IHPSG13_1P_BITKIT_16x2_EDGE_LR_0[1]/LWL<2>
+ RM_IHPSG13_1P_COLUMN_256_0[7]/RM_IHPSG13_1P_BITKIT_16x2_SRAM_0[3]/A_LWL<13> RM_IHPSG13_1P_COLUMN_256_0[7]/RM_IHPSG13_1P_BITKIT_16x2_SRAM_1[2]/A_LWL<4>
+ RM_IHPSG13_1P_BITKIT_16x2_EDGE_LR_1[0]/LWL<2> RM_IHPSG13_1P_BITKIT_16x2_EDGE_LR_0[1]/LWL<12>
+ RM_IHPSG13_1P_BITKIT_16x2_EDGE_LR_1[0]/LWL<0> RM_IHPSG13_1P_BITKIT_16x2_EDGE_LR_2[3]/LWL<3>
+ RM_IHPSG13_1P_BITKIT_16x2_EDGE_LR_0[1]/LWL<9> RM_IHPSG13_1P_COLUMN_256_0[7]/RM_IHPSG13_1P_BITKIT_16x2_SRAM_0[2]/A_LWL<5>
+ RM_IHPSG13_1P_BITKIT_16x2_EDGE_LR_1[3]/LWL<4> RM_IHPSG13_1P_BITKIT_16x2_EDGE_LR_1[3]/LWL<0>
+ RM_IHPSG13_1P_BITKIT_16x2_EDGE_LR_2[2]/LWL<8> RM_IHPSG13_1P_BITKIT_16x2_EDGE_LR_1[2]/LWL<13>
+ RM_IHPSG13_1P_BITKIT_16x2_EDGE_LR_3[3]/LWL<13> RM_IHPSG13_1P_BITKIT_16x2_EDGE_LR_1[0]/LWL<15>
+ RM_IHPSG13_1P_BITKIT_16x2_EDGE_LR_3[3]/LWL<1> RM_IHPSG13_1P_BITKIT_16x2_EDGE_LR_1[2]/LWL<9>
+ RM_IHPSG13_1P_BITKIT_16x2_EDGE_LR_3[1]/LWL<10> RM_IHPSG13_1P_COLUMN_256_0[7]/RM_IHPSG13_1P_BITKIT_16x2_SRAM_2[2]/A_LWL<7>
+ RM_IHPSG13_1P_BITKIT_16x2_EDGE_LR_0[3]/LWL<2> RM_IHPSG13_1P_COLUMN_256_0[7]/RM_IHPSG13_1P_BITKIT_16x2_SRAM_3[2]/A_LWL<3>
+ RM_IHPSG13_1P_BITKIT_16x2_EDGE_LR_2[0]/LWL<10> RM_IHPSG13_1P_COLUMN_256_0[7]/RM_IHPSG13_1P_BITKIT_16x2_SRAM_2[2]/A_LWL<4>
+ RM_IHPSG13_1P_COLUMN_256_0[7]/RM_IHPSG13_1P_BITKIT_16x2_SRAM_1[1]/A_LWL<8> RM_IHPSG13_1P_COLUMN_256_0[7]/RM_IHPSG13_1P_BITKIT_16x2_SRAM_0[3]/A_LWL<14>
+ RM_IHPSG13_1P_COLUMN_256_0[7]/RM_IHPSG13_1P_BITKIT_16x2_SRAM_3[0]/A_LWL<8> RM_IHPSG13_1P_BITKIT_16x2_EDGE_LR_2[3]/LWL<0>
+ RM_IHPSG13_1P_COLUMN_256_0[7]/RM_IHPSG13_1P_BITKIT_16x2_SRAM_0[2]/A_LWL<13> RM_IHPSG13_1P_BITKIT_16x2_EDGE_LR_0[1]/LWL<13>
+ RM_IHPSG13_1P_COLUMN_256_0[7]/RM_IHPSG13_1P_BITKIT_16x2_SRAM_3[0]/A_LWL<10> RM_IHPSG13_1P_COLUMN_256_0[7]/RM_IHPSG13_1P_BITKIT_16x2_SRAM_2[1]/A_LWL<13>
+ RM_IHPSG13_1P_COLUMN_256_0[7]/RM_IHPSG13_1P_BITKIT_16x2_SRAM_0[2]/A_LWL<6> RM_IHPSG13_1P_BITKIT_16x2_EDGE_LR_1[3]/LWL<1>
+ RM_IHPSG13_1P_BITKIT_16x2_EDGE_LR_2[2]/LWL<9> RM_IHPSG13_1P_COLUMN_256_0[7]/RM_IHPSG13_1P_BITKIT_16x2_SRAM_0[3]/A_LWL<11>
+ RM_IHPSG13_1P_BITKIT_16x2_EDGE_LR_3[3]/LWL<14> RM_IHPSG13_1P_COLUMN_256_0[7]/RM_IHPSG13_1P_BITKIT_16x2_SRAM_0[2]/A_LWL<0>
+ RM_IHPSG13_1P_BITKIT_16x2_EDGE_LR_3[1]/LWL<1> RM_IHPSG13_1P_BITKIT_16x2_EDGE_LR_0[2]/LWL<10>
+ RM_IHPSG13_1P_BITKIT_16x2_EDGE_LR_3[3]/LWL<2> RM_IHPSG13_1P_COLUMN_256_0[7]/RM_IHPSG13_1P_BITKIT_16x2_SRAM_2[2]/A_LWL<11>
+ RM_IHPSG13_1P_COLUMN_256_0[7]/RM_IHPSG13_1P_BITKIT_16x2_SRAM_2[1]/A_LWL<0> RM_IHPSG13_1P_BITKIT_16x2_EDGE_LR_0[3]/LWL<3>
+ RM_IHPSG13_1P_COLUMN_256_0[7]/RM_IHPSG13_1P_BITKIT_16x2_SRAM_3[2]/A_LWL<4> RM_IHPSG13_1P_BITKIT_16x2_EDGE_LR_3[1]/LWL<8>
+ RM_IHPSG13_1P_COLUMN_256_0[7]/RM_IHPSG13_1P_BITKIT_16x2_SRAM_1[2]/A_LWL<5> RM_IHPSG13_1P_COLUMN_256_0[7]/RM_IHPSG13_1P_BITKIT_16x2_SRAM_1[0]/A_LWL<2>
+ RM_IHPSG13_1P_BITKIT_16x2_EDGE_LR_2[2]/LWL<12> RM_IHPSG13_1P_COLUMN_256_0[7]/RM_IHPSG13_1P_BITKIT_16x2_SRAM_2[2]/A_LWL<5>
+ RM_IHPSG13_1P_COLUMN_256_0[7]/RM_IHPSG13_1P_BITKIT_16x2_SRAM_1[3]/A_LWL<6> RM_IHPSG13_1P_BITKIT_16x2_EDGE_LR_2[1]/LWL<9>
+ RM_IHPSG13_1P_COLUMN_256_0[7]/RM_IHPSG13_1P_BITKIT_16x2_SRAM_3[1]/A_LWL<5> RM_IHPSG13_1P_BITKIT_16x2_EDGE_LR_0[0]/LWL<2>
+ RM_IHPSG13_1P_COLUMN_256_0[7]/RM_IHPSG13_1P_BITKIT_16x2_SRAM_0[3]/A_LWL<15> RM_IHPSG13_1P_COLUMN_256_0[7]/RM_IHPSG13_1P_BITKIT_16x2_SRAM_1[2]/A_LWL<6>
+ RM_IHPSG13_1P_BITKIT_16x2_EDGE_LR_2[3]/LWL<1> RM_IHPSG13_1P_BITKIT_16x2_EDGE_LR_0[1]/LWL<14>
+ RM_IHPSG13_1P_BITKIT_16x2_EDGE_LR_2[2]/LWL<3> RM_IHPSG13_1P_COLUMN_256_0[7]/RM_IHPSG13_1P_BITKIT_16x2_SRAM_3[0]/A_LWL<11>
+ RM_IHPSG13_1P_COLUMN_256_0[7]/RM_IHPSG13_1P_BITKIT_16x2_SRAM_0[2]/A_LWL<7> RM_IHPSG13_1P_BITKIT_16x2_EDGE_LR_0[0]/LWL<15>
+ RM_IHPSG13_1P_BITKIT_16x2_EDGE_LR_1[3]/LWL<2> RM_IHPSG13_1P_COLUMN_256_0[7]/RM_IHPSG13_1P_BITKIT_16x2_SRAM_2[3]/A_LWL<14>
+ RM_IHPSG13_1P_BITKIT_16x2_EDGE_LR_3[3]/LWL<15> RM_IHPSG13_1P_BITKIT_16x2_EDGE_LR_0[2]/LWL<11>
+ RM_IHPSG13_1P_BITKIT_16x2_EDGE_LR_3[3]/LWL<3> RM_IHPSG13_1P_BITKIT_16x2_EDGE_LR_3[0]/LWL<10>
+ RM_IHPSG13_1P_BITKIT_16x2_EDGE_LR_0[3]/LWL<4> RM_IHPSG13_1P_BITKIT_16x2_EDGE_LR_1[3]/LWL<11>
+ RM_IHPSG13_1P_COLUMN_256_0[7]/RM_IHPSG13_1P_BITKIT_16x2_SRAM_3[2]/A_LWL<5> RM_IHPSG13_1P_BITKIT_16x2_EDGE_LR_0[0]/LWL<4>
+ RM_IHPSG13_1P_COLUMN_256_0[7]/RM_IHPSG13_1P_BITKIT_16x2_SRAM_2[2]/A_LWL<6> RM_IHPSG13_1P_COLUMN_256_0[7]/RM_IHPSG13_1P_BITKIT_16x2_SRAM_1[0]/A_LWL<8>
+ RM_IHPSG13_1P_BITKIT_16x2_EDGE_LR_0[3]/LWL<12> RM_IHPSG13_1P_BITKIT_16x2_EDGE_LR_1[1]/LWL<0>
+ RM_IHPSG13_1P_BITKIT_16x2_EDGE_LR_2[3]/LWL<6> RM_IHPSG13_1P_BITKIT_16x2_EDGE_LR_1[0]/LWL<5>
+ RM_IHPSG13_1P_BITKIT_16x2_EDGE_LR_0[2]/LWL<9> RM_IHPSG13_1P_COLUMN_256_0[7]/RM_IHPSG13_1P_BITKIT_16x2_SRAM_1[2]/A_LWL<7>
+ RM_IHPSG13_1P_COLUMN_256_0[7]/RM_IHPSG13_1P_BITKIT_16x2_SRAM_0[1]/A_LWL<13> RM_IHPSG13_1P_BITKIT_16x2_EDGE_LR_2[3]/LWL<2>
+ RM_IHPSG13_1P_BITKIT_16x2_EDGE_LR_1[3]/LWL<13> RM_IHPSG13_1P_BITKIT_16x2_EDGE_LR_0[1]/LWL<15>
+ RM_IHPSG13_1P_COLUMN_256_0[7]/RM_IHPSG13_1P_BITKIT_16x2_SRAM_3[0]/A_LWL<12> RM_IHPSG13_1P_COLUMN_256_0[7]/RM_IHPSG13_1P_BITKIT_16x2_SRAM_0[2]/A_LWL<8>
+ RM_IHPSG13_1P_COLUMN_256_0[7]/RM_IHPSG13_1P_BITKIT_16x2_SRAM_2[0]/A_LWL<13> RM_IHPSG13_1P_BITKIT_16x2_EDGE_LR_1[3]/LWL<3>
+ RM_IHPSG13_1P_COLUMN_256_0[7]/RM_IHPSG13_1P_BITKIT_16x2_SRAM_0[2]/A_LWL<11> RM_IHPSG13_1P_COLUMN_256_0[7]/RM_IHPSG13_1P_BITKIT_16x2_SRAM_3[3]/A_LWL<12>
+ RM_IHPSG13_1P_COLUMN_256_0[7]/RM_IHPSG13_1P_BITKIT_16x2_SRAM_2[0]/A_LWL<3> RM_IHPSG13_1P_COLUMN_256_0[7]/RM_IHPSG13_1P_BITKIT_16x2_SRAM_0[1]/A_LWL<0>
+ RM_IHPSG13_1P_COLUMN_256_0[7]/RM_IHPSG13_1P_BITKIT_16x2_SRAM_2[3]/A_LWL<7> RM_IHPSG13_1P_BITKIT_16x2_EDGE_LR_0[2]/LWL<12>
+ RM_IHPSG13_1P_BITKIT_16x2_EDGE_LR_3[3]/LWL<4> RM_IHPSG13_1P_COLUMN_256_0[7]/RM_IHPSG13_1P_BITKIT_16x2_SRAM_2[1]/A_LWL<11>
+ RM_IHPSG13_1P_COLUMN_256_0[7]/RM_IHPSG13_1P_BITKIT_16x2_SRAM_2[0]/A_LWL<0> RM_IHPSG13_1P_COLUMN_256_0[7]/RM_IHPSG13_1P_BITKIT_16x2_SRAM_3[3]/VSS
+ RM_IHPSG13_1P_BITKIT_16x2_EDGE_LR_0[3]/LWL<5> RM_IHPSG13_1P_COLUMN_256_0[7]/RM_IHPSG13_1P_BITKIT_16x2_SRAM_3[3]/VDD
+ RM_IHPSG13_1P_COLUMN_256_0[7]/RM_IHPSG13_1P_BITKIT_16x2_SRAM_3[2]/A_LWL<6> RM_IHPSG13_1P_COLUMN_256
XRM_IHPSG13_1P_BITKIT_16x2_EDGE_LR_6[0] RM_IHPSG13_1P_BITKIT_16x2_EDGE_LR_6[0]/LWL<1>
+ RM_IHPSG13_1P_BITKIT_16x2_EDGE_LR_6[0]/LWL<2> RM_IHPSG13_1P_BITKIT_16x2_EDGE_LR_6[0]/LWL<3>
+ RM_IHPSG13_1P_BITKIT_16x2_EDGE_LR_6[0]/LWL<4> RM_IHPSG13_1P_BITKIT_16x2_EDGE_LR_6[0]/LWL<5>
+ RM_IHPSG13_1P_BITKIT_16x2_EDGE_LR_6[0]/LWL<7> RM_IHPSG13_1P_BITKIT_16x2_EDGE_LR_6[0]/LWL<8>
+ RM_IHPSG13_1P_BITKIT_16x2_EDGE_LR_6[0]/LWL<9> RM_IHPSG13_1P_BITKIT_16x2_EDGE_LR_6[0]/LWL<10>
+ RM_IHPSG13_1P_BITKIT_16x2_EDGE_LR_6[0]/LWL<11> RM_IHPSG13_1P_BITKIT_16x2_EDGE_LR_6[0]/LWL<12>
+ RM_IHPSG13_1P_BITKIT_16x2_EDGE_LR_6[0]/LWL<14> RM_IHPSG13_1P_BITKIT_16x2_EDGE_LR_6[0]/LWL<15>
+ RM_IHPSG13_1P_BITKIT_16x2_EDGE_LR_6[0]/LWL<0> RM_IHPSG13_1P_BITKIT_16x2_EDGE_LR_6[0]/LWL<6>
+ RM_IHPSG13_1P_BITKIT_16x2_EDGE_LR_6[0]/LWL<13> RM_IHPSG13_1P_COLUMN_256_0[7]/RM_IHPSG13_1P_BITKIT_16x2_SRAM_3[3]/VSS
+ RM_IHPSG13_1P_COLUMN_256_0[7]/RM_IHPSG13_1P_BITKIT_16x2_SRAM_3[3]/VDD RM_IHPSG13_1P_BITKIT_16x2_EDGE_LR
XRM_IHPSG13_1P_BITKIT_16x2_EDGE_LR_6[1] RM_IHPSG13_1P_BITKIT_16x2_EDGE_LR_6[1]/LWL<1>
+ RM_IHPSG13_1P_BITKIT_16x2_EDGE_LR_6[1]/LWL<2> RM_IHPSG13_1P_BITKIT_16x2_EDGE_LR_6[1]/LWL<3>
+ RM_IHPSG13_1P_BITKIT_16x2_EDGE_LR_6[1]/LWL<4> RM_IHPSG13_1P_BITKIT_16x2_EDGE_LR_6[1]/LWL<5>
+ RM_IHPSG13_1P_BITKIT_16x2_EDGE_LR_6[1]/LWL<7> RM_IHPSG13_1P_BITKIT_16x2_EDGE_LR_6[1]/LWL<8>
+ RM_IHPSG13_1P_BITKIT_16x2_EDGE_LR_6[1]/LWL<9> RM_IHPSG13_1P_BITKIT_16x2_EDGE_LR_6[1]/LWL<10>
+ RM_IHPSG13_1P_BITKIT_16x2_EDGE_LR_6[1]/LWL<11> RM_IHPSG13_1P_BITKIT_16x2_EDGE_LR_6[1]/LWL<12>
+ RM_IHPSG13_1P_BITKIT_16x2_EDGE_LR_6[1]/LWL<14> RM_IHPSG13_1P_BITKIT_16x2_EDGE_LR_6[1]/LWL<15>
+ RM_IHPSG13_1P_BITKIT_16x2_EDGE_LR_6[1]/LWL<0> RM_IHPSG13_1P_BITKIT_16x2_EDGE_LR_6[1]/LWL<6>
+ RM_IHPSG13_1P_BITKIT_16x2_EDGE_LR_6[1]/LWL<13> RM_IHPSG13_1P_COLUMN_256_0[7]/RM_IHPSG13_1P_BITKIT_16x2_SRAM_3[3]/VSS
+ RM_IHPSG13_1P_COLUMN_256_0[7]/RM_IHPSG13_1P_BITKIT_16x2_SRAM_3[3]/VDD RM_IHPSG13_1P_BITKIT_16x2_EDGE_LR
XRM_IHPSG13_1P_BITKIT_16x2_EDGE_LR_6[2] RM_IHPSG13_1P_BITKIT_16x2_EDGE_LR_6[2]/LWL<1>
+ RM_IHPSG13_1P_BITKIT_16x2_EDGE_LR_6[2]/LWL<2> RM_IHPSG13_1P_BITKIT_16x2_EDGE_LR_6[2]/LWL<3>
+ RM_IHPSG13_1P_BITKIT_16x2_EDGE_LR_6[2]/LWL<4> RM_IHPSG13_1P_BITKIT_16x2_EDGE_LR_6[2]/LWL<5>
+ RM_IHPSG13_1P_BITKIT_16x2_EDGE_LR_6[2]/LWL<7> RM_IHPSG13_1P_BITKIT_16x2_EDGE_LR_6[2]/LWL<8>
+ RM_IHPSG13_1P_BITKIT_16x2_EDGE_LR_6[2]/LWL<9> RM_IHPSG13_1P_BITKIT_16x2_EDGE_LR_6[2]/LWL<10>
+ RM_IHPSG13_1P_BITKIT_16x2_EDGE_LR_6[2]/LWL<11> RM_IHPSG13_1P_BITKIT_16x2_EDGE_LR_6[2]/LWL<12>
+ RM_IHPSG13_1P_BITKIT_16x2_EDGE_LR_6[2]/LWL<14> RM_IHPSG13_1P_BITKIT_16x2_EDGE_LR_6[2]/LWL<15>
+ RM_IHPSG13_1P_BITKIT_16x2_EDGE_LR_6[2]/LWL<0> RM_IHPSG13_1P_BITKIT_16x2_EDGE_LR_6[2]/LWL<6>
+ RM_IHPSG13_1P_BITKIT_16x2_EDGE_LR_6[2]/LWL<13> RM_IHPSG13_1P_COLUMN_256_0[7]/RM_IHPSG13_1P_BITKIT_16x2_SRAM_3[3]/VSS
+ RM_IHPSG13_1P_COLUMN_256_0[7]/RM_IHPSG13_1P_BITKIT_16x2_SRAM_3[3]/VDD RM_IHPSG13_1P_BITKIT_16x2_EDGE_LR
XRM_IHPSG13_1P_BITKIT_16x2_EDGE_LR_6[3] RM_IHPSG13_1P_BITKIT_16x2_EDGE_LR_6[3]/LWL<1>
+ RM_IHPSG13_1P_BITKIT_16x2_EDGE_LR_6[3]/LWL<2> RM_IHPSG13_1P_BITKIT_16x2_EDGE_LR_6[3]/LWL<3>
+ RM_IHPSG13_1P_BITKIT_16x2_EDGE_LR_6[3]/LWL<4> RM_IHPSG13_1P_BITKIT_16x2_EDGE_LR_6[3]/LWL<5>
+ RM_IHPSG13_1P_BITKIT_16x2_EDGE_LR_6[3]/LWL<7> RM_IHPSG13_1P_BITKIT_16x2_EDGE_LR_6[3]/LWL<8>
+ RM_IHPSG13_1P_BITKIT_16x2_EDGE_LR_6[3]/LWL<9> RM_IHPSG13_1P_BITKIT_16x2_EDGE_LR_6[3]/LWL<10>
+ RM_IHPSG13_1P_BITKIT_16x2_EDGE_LR_6[3]/LWL<11> RM_IHPSG13_1P_BITKIT_16x2_EDGE_LR_6[3]/LWL<12>
+ RM_IHPSG13_1P_BITKIT_16x2_EDGE_LR_6[3]/LWL<14> RM_IHPSG13_1P_BITKIT_16x2_EDGE_LR_6[3]/LWL<15>
+ RM_IHPSG13_1P_BITKIT_16x2_EDGE_LR_6[3]/LWL<0> RM_IHPSG13_1P_BITKIT_16x2_EDGE_LR_6[3]/LWL<6>
+ RM_IHPSG13_1P_BITKIT_16x2_EDGE_LR_6[3]/LWL<13> RM_IHPSG13_1P_COLUMN_256_0[7]/RM_IHPSG13_1P_BITKIT_16x2_SRAM_3[3]/VSS
+ RM_IHPSG13_1P_COLUMN_256_0[7]/RM_IHPSG13_1P_BITKIT_16x2_SRAM_3[3]/VDD RM_IHPSG13_1P_BITKIT_16x2_EDGE_LR
XRM_IHPSG13_1P_BITKIT_16x2_EDGE_LR_7[0] RM_IHPSG13_1P_BITKIT_16x2_EDGE_LR_7[0]/LWL<1>
+ RM_IHPSG13_1P_BITKIT_16x2_EDGE_LR_7[0]/LWL<2> RM_IHPSG13_1P_BITKIT_16x2_EDGE_LR_7[0]/LWL<3>
+ RM_IHPSG13_1P_BITKIT_16x2_EDGE_LR_7[0]/LWL<4> RM_IHPSG13_1P_BITKIT_16x2_EDGE_LR_7[0]/LWL<5>
+ RM_IHPSG13_1P_BITKIT_16x2_EDGE_LR_7[0]/LWL<7> RM_IHPSG13_1P_BITKIT_16x2_EDGE_LR_7[0]/LWL<8>
+ RM_IHPSG13_1P_BITKIT_16x2_EDGE_LR_7[0]/LWL<9> RM_IHPSG13_1P_BITKIT_16x2_EDGE_LR_7[0]/LWL<10>
+ RM_IHPSG13_1P_BITKIT_16x2_EDGE_LR_7[0]/LWL<11> RM_IHPSG13_1P_BITKIT_16x2_EDGE_LR_7[0]/LWL<12>
+ RM_IHPSG13_1P_BITKIT_16x2_EDGE_LR_7[0]/LWL<14> RM_IHPSG13_1P_BITKIT_16x2_EDGE_LR_7[0]/LWL<15>
+ RM_IHPSG13_1P_BITKIT_16x2_EDGE_LR_7[0]/LWL<0> RM_IHPSG13_1P_BITKIT_16x2_EDGE_LR_7[0]/LWL<6>
+ RM_IHPSG13_1P_BITKIT_16x2_EDGE_LR_7[0]/LWL<13> RM_IHPSG13_1P_COLUMN_256_0[7]/RM_IHPSG13_1P_BITKIT_16x2_SRAM_3[3]/VSS
+ RM_IHPSG13_1P_COLUMN_256_0[7]/RM_IHPSG13_1P_BITKIT_16x2_SRAM_3[3]/VDD RM_IHPSG13_1P_BITKIT_16x2_EDGE_LR
XRM_IHPSG13_1P_BITKIT_16x2_EDGE_LR_7[1] RM_IHPSG13_1P_BITKIT_16x2_EDGE_LR_7[1]/LWL<1>
+ RM_IHPSG13_1P_BITKIT_16x2_EDGE_LR_7[1]/LWL<2> RM_IHPSG13_1P_BITKIT_16x2_EDGE_LR_7[1]/LWL<3>
+ RM_IHPSG13_1P_BITKIT_16x2_EDGE_LR_7[1]/LWL<4> RM_IHPSG13_1P_BITKIT_16x2_EDGE_LR_7[1]/LWL<5>
+ RM_IHPSG13_1P_BITKIT_16x2_EDGE_LR_7[1]/LWL<7> RM_IHPSG13_1P_BITKIT_16x2_EDGE_LR_7[1]/LWL<8>
+ RM_IHPSG13_1P_BITKIT_16x2_EDGE_LR_7[1]/LWL<9> RM_IHPSG13_1P_BITKIT_16x2_EDGE_LR_7[1]/LWL<10>
+ RM_IHPSG13_1P_BITKIT_16x2_EDGE_LR_7[1]/LWL<11> RM_IHPSG13_1P_BITKIT_16x2_EDGE_LR_7[1]/LWL<12>
+ RM_IHPSG13_1P_BITKIT_16x2_EDGE_LR_7[1]/LWL<14> RM_IHPSG13_1P_BITKIT_16x2_EDGE_LR_7[1]/LWL<15>
+ RM_IHPSG13_1P_BITKIT_16x2_EDGE_LR_7[1]/LWL<0> RM_IHPSG13_1P_BITKIT_16x2_EDGE_LR_7[1]/LWL<6>
+ RM_IHPSG13_1P_BITKIT_16x2_EDGE_LR_7[1]/LWL<13> RM_IHPSG13_1P_COLUMN_256_0[7]/RM_IHPSG13_1P_BITKIT_16x2_SRAM_3[3]/VSS
+ RM_IHPSG13_1P_COLUMN_256_0[7]/RM_IHPSG13_1P_BITKIT_16x2_SRAM_3[3]/VDD RM_IHPSG13_1P_BITKIT_16x2_EDGE_LR
XRM_IHPSG13_1P_BITKIT_16x2_EDGE_LR_7[2] RM_IHPSG13_1P_BITKIT_16x2_EDGE_LR_7[2]/LWL<1>
+ RM_IHPSG13_1P_BITKIT_16x2_EDGE_LR_7[2]/LWL<2> RM_IHPSG13_1P_BITKIT_16x2_EDGE_LR_7[2]/LWL<3>
+ RM_IHPSG13_1P_BITKIT_16x2_EDGE_LR_7[2]/LWL<4> RM_IHPSG13_1P_BITKIT_16x2_EDGE_LR_7[2]/LWL<5>
+ RM_IHPSG13_1P_BITKIT_16x2_EDGE_LR_7[2]/LWL<7> RM_IHPSG13_1P_BITKIT_16x2_EDGE_LR_7[2]/LWL<8>
+ RM_IHPSG13_1P_BITKIT_16x2_EDGE_LR_7[2]/LWL<9> RM_IHPSG13_1P_BITKIT_16x2_EDGE_LR_7[2]/LWL<10>
+ RM_IHPSG13_1P_BITKIT_16x2_EDGE_LR_7[2]/LWL<11> RM_IHPSG13_1P_BITKIT_16x2_EDGE_LR_7[2]/LWL<12>
+ RM_IHPSG13_1P_BITKIT_16x2_EDGE_LR_7[2]/LWL<14> RM_IHPSG13_1P_BITKIT_16x2_EDGE_LR_7[2]/LWL<15>
+ RM_IHPSG13_1P_BITKIT_16x2_EDGE_LR_7[2]/LWL<0> RM_IHPSG13_1P_BITKIT_16x2_EDGE_LR_7[2]/LWL<6>
+ RM_IHPSG13_1P_BITKIT_16x2_EDGE_LR_7[2]/LWL<13> RM_IHPSG13_1P_COLUMN_256_0[7]/RM_IHPSG13_1P_BITKIT_16x2_SRAM_3[3]/VSS
+ RM_IHPSG13_1P_COLUMN_256_0[7]/RM_IHPSG13_1P_BITKIT_16x2_SRAM_3[3]/VDD RM_IHPSG13_1P_BITKIT_16x2_EDGE_LR
XRM_IHPSG13_1P_BITKIT_16x2_EDGE_LR_7[3] RM_IHPSG13_1P_BITKIT_16x2_EDGE_LR_7[3]/LWL<1>
+ RM_IHPSG13_1P_BITKIT_16x2_EDGE_LR_7[3]/LWL<2> RM_IHPSG13_1P_BITKIT_16x2_EDGE_LR_7[3]/LWL<3>
+ RM_IHPSG13_1P_BITKIT_16x2_EDGE_LR_7[3]/LWL<4> RM_IHPSG13_1P_BITKIT_16x2_EDGE_LR_7[3]/LWL<5>
+ RM_IHPSG13_1P_BITKIT_16x2_EDGE_LR_7[3]/LWL<7> RM_IHPSG13_1P_BITKIT_16x2_EDGE_LR_7[3]/LWL<8>
+ RM_IHPSG13_1P_BITKIT_16x2_EDGE_LR_7[3]/LWL<9> RM_IHPSG13_1P_BITKIT_16x2_EDGE_LR_7[3]/LWL<10>
+ RM_IHPSG13_1P_BITKIT_16x2_EDGE_LR_7[3]/LWL<11> RM_IHPSG13_1P_BITKIT_16x2_EDGE_LR_7[3]/LWL<12>
+ RM_IHPSG13_1P_BITKIT_16x2_EDGE_LR_7[3]/LWL<14> RM_IHPSG13_1P_BITKIT_16x2_EDGE_LR_7[3]/LWL<15>
+ RM_IHPSG13_1P_BITKIT_16x2_EDGE_LR_7[3]/LWL<0> RM_IHPSG13_1P_BITKIT_16x2_EDGE_LR_7[3]/LWL<6>
+ RM_IHPSG13_1P_BITKIT_16x2_EDGE_LR_7[3]/LWL<13> RM_IHPSG13_1P_COLUMN_256_0[7]/RM_IHPSG13_1P_BITKIT_16x2_SRAM_3[3]/VSS
+ RM_IHPSG13_1P_COLUMN_256_0[7]/RM_IHPSG13_1P_BITKIT_16x2_SRAM_3[3]/VDD RM_IHPSG13_1P_BITKIT_16x2_EDGE_LR
.ends

.subckt RM_IHPSG13_1P_DEC_LE_l1empty m2_1178_0# w_n102_735# dw_0_780#
X0 a_293_1380# a_293_894# w_n102_735# w_n102_735# sg13_lv_pmos ad=0.3078p pd=2u as=0.3078p ps=2u w=1.62u l=0.385u
X1 a_905_894# a_905_1380# dw_0_780# dw_0_780# sg13_lv_nmos ad=0.1577p pd=1.21u as=0.1577p ps=1.21u w=0.83u l=0.13u
X2 dw_0_780# a_905_1380# a_905_894# dw_0_780# sg13_lv_nmos ad=0.2822p pd=2.34u as=0.1577p ps=1.21u w=0.83u l=0.13u
X3 w_n102_735# a_293_894# a_293_1380# w_n102_735# sg13_lv_pmos ad=0.3078p pd=2u as=0.3078p ps=2u w=1.62u l=0.385u
X4 a_293_894# a_293_1380# dw_0_780# dw_0_780# sg13_lv_nmos ad=0.1577p pd=1.21u as=0.2822p ps=2.34u w=0.83u l=0.13u
X5 a_293_894# a_293_1380# dw_0_780# dw_0_780# sg13_lv_nmos ad=0.1577p pd=1.21u as=0.1577p ps=1.21u w=0.83u l=0.13u
X6 w_n102_735# a_293_894# a_293_1380# w_n102_735# sg13_lv_pmos ad=0.3078p pd=2u as=0.3078p ps=2u w=1.62u l=0.385u
X7 dw_0_780# a_293_1380# a_293_894# dw_0_780# sg13_lv_nmos ad=0.1577p pd=1.21u as=0.1577p ps=1.21u w=0.83u l=0.13u
X8 dw_0_780# a_293_1380# a_293_894# dw_0_780# sg13_lv_nmos ad=0.1577p pd=1.21u as=0.1577p ps=1.21u w=0.83u l=0.13u
X9 a_905_1380# a_905_894# w_n102_735# w_n102_735# sg13_lv_pmos ad=0.3078p pd=2u as=0.3078p ps=2u w=1.62u l=0.385u
X10 w_n102_735# a_905_894# a_905_1380# w_n102_735# sg13_lv_pmos ad=0.3078p pd=2u as=0.3078p ps=2u w=1.62u l=0.385u
X11 dw_0_780# a_905_1380# a_905_894# dw_0_780# sg13_lv_nmos ad=0.1577p pd=1.21u as=0.1577p ps=1.21u w=0.83u l=0.13u
X12 a_905_894# a_905_1380# dw_0_780# dw_0_780# sg13_lv_nmos ad=0.1577p pd=1.21u as=0.1577p ps=1.21u w=0.83u l=0.13u
X13 w_n102_735# a_905_894# a_905_1380# w_n102_735# sg13_lv_pmos ad=0.5508p pd=3.92u as=0.3078p ps=2u w=1.62u l=0.385u
X14 a_293_894# a_293_1380# dw_0_780# dw_0_780# sg13_lv_nmos ad=0.1577p pd=1.21u as=0.1577p ps=1.21u w=0.83u l=0.13u
X15 a_905_1380# a_905_894# w_n102_735# w_n102_735# sg13_lv_pmos ad=0.3078p pd=2u as=0.3078p ps=2u w=1.62u l=0.385u
X16 dw_0_780# a_905_1380# a_905_894# dw_0_780# sg13_lv_nmos ad=0.1577p pd=1.21u as=0.1577p ps=1.21u w=0.83u l=0.13u
X17 a_905_894# a_905_1380# dw_0_780# dw_0_780# sg13_lv_nmos ad=0.1577p pd=1.21u as=0.1577p ps=1.21u w=0.83u l=0.13u
X18 dw_0_780# a_293_1380# a_293_894# dw_0_780# sg13_lv_nmos ad=0.1577p pd=1.21u as=0.1577p ps=1.21u w=0.83u l=0.13u
X19 a_293_1380# a_293_894# w_n102_735# w_n102_735# sg13_lv_pmos ad=0.3078p pd=2u as=0.5508p ps=3.92u w=1.62u l=0.385u
.ends

.subckt RM_IHPSG13_1P_DEC_LE_l2empty w_n102_2037# m2_1280_0# dw_0_1620#
X0 a_293_2016# a_293_1738# dw_0_1620# dw_0_1620# sg13_lv_nmos ad=0.1577p pd=1.21u as=0.2822p ps=2.34u w=0.83u l=0.13u
X1 a_293_2016# a_293_1738# dw_0_1620# dw_0_1620# sg13_lv_nmos ad=0.1577p pd=1.21u as=0.1577p ps=1.21u w=0.83u l=0.13u
X2 a_293_1738# a_293_2016# w_n102_2037# w_n102_2037# sg13_lv_pmos ad=0.3078p pd=2u as=0.3078p ps=2u w=1.62u l=0.385u
X3 w_n102_2037# a_905_2016# a_905_1738# w_n102_2037# sg13_lv_pmos ad=0.3078p pd=2u as=0.3078p ps=2u w=1.62u l=0.385u
X4 w_n102_2037# a_905_2016# a_905_1738# w_n102_2037# sg13_lv_pmos ad=0.5508p pd=3.92u as=0.3078p ps=2u w=1.62u l=0.385u
X5 dw_0_1620# a_293_1738# a_293_2016# dw_0_1620# sg13_lv_nmos ad=0.1577p pd=1.21u as=0.1577p ps=1.21u w=0.83u l=0.13u
X6 dw_0_1620# a_293_1738# a_293_2016# dw_0_1620# sg13_lv_nmos ad=0.1577p pd=1.21u as=0.1577p ps=1.21u w=0.83u l=0.13u
X7 a_293_1738# a_293_2016# w_n102_2037# w_n102_2037# sg13_lv_pmos ad=0.3078p pd=2u as=0.5508p ps=3.92u w=1.62u l=0.385u
X8 dw_0_1620# a_905_1738# a_905_2016# dw_0_1620# sg13_lv_nmos ad=0.1577p pd=1.21u as=0.1577p ps=1.21u w=0.83u l=0.13u
X9 a_293_2016# a_293_1738# dw_0_1620# dw_0_1620# sg13_lv_nmos ad=0.1577p pd=1.21u as=0.1577p ps=1.21u w=0.83u l=0.13u
X10 a_905_2016# a_905_1738# dw_0_1620# dw_0_1620# sg13_lv_nmos ad=0.1577p pd=1.21u as=0.1577p ps=1.21u w=0.83u l=0.13u
X11 w_n102_2037# a_293_2016# a_293_1738# w_n102_2037# sg13_lv_pmos ad=0.3078p pd=2u as=0.3078p ps=2u w=1.62u l=0.385u
X12 w_n102_2037# a_293_2016# a_293_1738# w_n102_2037# sg13_lv_pmos ad=0.3078p pd=2u as=0.3078p ps=2u w=1.62u l=0.385u
X13 a_905_2016# a_905_1738# dw_0_1620# dw_0_1620# sg13_lv_nmos ad=0.1577p pd=1.21u as=0.1577p ps=1.21u w=0.83u l=0.13u
X14 a_905_1738# a_905_2016# w_n102_2037# w_n102_2037# sg13_lv_pmos ad=0.3078p pd=2u as=0.3078p ps=2u w=1.62u l=0.385u
X15 dw_0_1620# a_905_1738# a_905_2016# dw_0_1620# sg13_lv_nmos ad=0.1577p pd=1.21u as=0.1577p ps=1.21u w=0.83u l=0.13u
X16 a_905_1738# a_905_2016# w_n102_2037# w_n102_2037# sg13_lv_pmos ad=0.3078p pd=2u as=0.3078p ps=2u w=1.62u l=0.385u
X17 dw_0_1620# a_293_1738# a_293_2016# dw_0_1620# sg13_lv_nmos ad=0.1577p pd=1.21u as=0.1577p ps=1.21u w=0.83u l=0.13u
X18 a_905_2016# a_905_1738# dw_0_1620# dw_0_1620# sg13_lv_nmos ad=0.1577p pd=1.21u as=0.1577p ps=1.21u w=0.83u l=0.13u
X19 dw_0_1620# a_905_1738# a_905_2016# dw_0_1620# sg13_lv_nmos ad=0.2822p pd=2.34u as=0.1577p ps=1.21u w=0.83u l=0.13u
.ends

.subckt RM_IHPSG13_1P_DEC04 ECLK_L_TOP ECLK_H_TOP ECLK_H_BOT ECLK_L_BOT ADDR<3> ADDR<2>
+ ADDR<1> ADDR<0> VDD VSS WL<0> WL<1> WL<2> WL<3> WL<4> WL<5> WL<6> WL<7> WL<8> WL<9>
+ WL<10> WL<11> WL<12> WL<13> WL<14> WL<15> CS m2_1382_0# m2_260_840# m2_770_840#
+ m2_362_840# m2_56_840# m2_872_840# m2_158_840#
X0 VSS a_4445_278# a_4407_98# VSS sg13_lv_nmos ad=0.1577p pd=1.21u as=0.2822p ps=2.34u w=0.83u l=0.13u
X1 VSS a_2767_2616# WL<6> VSS sg13_lv_nmos ad=0.16625p pd=1.255u as=0.16625p ps=1.255u w=0.875u l=0.13u
X2 VSS a_2027_60# a_1951_176# VSS sg13_lv_nmos ad=91.2f pd=0.86u as=91.2f ps=0.86u w=0.48u l=0.13u
X3 a_2359_1778# a_1849_1778# VSS VSS sg13_lv_nmos ad=0.3332p pd=2.64u as=0.3332p ps=2.64u w=0.98u l=0.13u
X4 a_1747_1408# ADDR<1> VSS VSS sg13_lv_nmos ad=0.1653p pd=1.25u as=0.13605p ps=1.25u w=0.87u l=0.13u
X5 a_3787_2616# a_2767_2616# a_3685_2616# VDD sg13_lv_pmos ad=0.3078p pd=2u as=0.3078p ps=2u w=1.62u l=0.13u
X6 a_3175_2616# CS a_3277_3066# VSS sg13_lv_nmos ad=0.3332p pd=2.64u as=0.1862p ps=1.36u w=0.98u l=0.13u
X7 a_3175_2616# a_2359_1778# VDD VDD sg13_lv_pmos ad=0.3078p pd=2u as=0.5508p ps=3.92u w=1.62u l=0.13u
X8 a_2563_936# a_2359_936# VDD VDD sg13_lv_pmos ad=0.5508p pd=3.92u as=0.5508p ps=3.92u w=1.62u l=0.13u
X9 a_2027_2647# a_1849_2685# VSS VSS sg13_lv_nmos ad=0.1632p pd=1.64u as=91.2f ps=0.86u w=0.48u l=0.13u
X10 WL<1> a_3826_308# VSS VSS sg13_lv_nmos ad=0.2975p pd=2.43u as=0.16625p ps=1.255u w=0.875u l=0.13u
X11 a_1849_98# CS a_1747_98# VSS sg13_lv_nmos ad=0.13605p pd=1.25u as=0.1653p ps=1.25u w=0.87u l=0.13u
X12 a_1951_1856# a_1551_1778# a_1849_1778# VSS sg13_lv_nmos ad=91.2f pd=0.86u as=0.13605p ps=1.25u w=0.48u l=0.13u
X13 WL<14> a_3175_2100# VSS VSS sg13_lv_nmos ad=0.16625p pd=1.255u as=0.2975p ps=2.43u w=0.875u l=0.13u
X14 a_2027_60# a_1849_98# VSS VSS sg13_lv_nmos ad=0.1632p pd=1.64u as=91.2f ps=0.86u w=0.48u l=0.13u
X15 WL<7> a_3175_2616# VSS VSS sg13_lv_nmos ad=0.16625p pd=1.255u as=0.2975p ps=2.43u w=0.875u l=0.13u
X16 a_3277_1778# a_2359_2616# a_3175_1778# VSS sg13_lv_nmos ad=0.1862p pd=1.36u as=0.1862p ps=1.36u w=0.98u l=0.13u
X17 a_2027_967# a_1849_1005# VDD VDD sg13_lv_pmos ad=0.1632p pd=1.64u as=91.2f ps=0.86u w=0.48u l=0.13u
X18 WL<14> a_3826_308# a_3787_2100# VDD sg13_lv_pmos ad=0.5508p pd=3.92u as=0.3078p ps=2u w=1.62u l=0.13u
X19 VSS a_2027_967# a_1951_1408# VSS sg13_lv_nmos ad=91.2f pd=0.86u as=91.2f ps=0.86u w=0.48u l=0.13u
X20 a_4093_420# a_3175_420# VDD VDD sg13_lv_pmos ad=0.3078p pd=2u as=0.5508p ps=3.92u w=1.62u l=0.13u
X21 a_3175_936# a_2563_1778# VDD VDD sg13_lv_pmos ad=0.3078p pd=2u as=0.5508p ps=3.92u w=1.62u l=0.13u
X22 a_4093_2616# a_3175_2616# VDD VDD sg13_lv_pmos ad=0.3078p pd=2u as=0.5508p ps=3.92u w=1.62u l=0.13u
X23 a_2767_420# a_2563_98# a_2767_98# VSS sg13_lv_nmos ad=0.3332p pd=2.64u as=0.1862p ps=1.36u w=0.98u l=0.13u
X24 VSS a_2767_420# WL<8> VSS sg13_lv_nmos ad=0.16625p pd=1.255u as=0.16625p ps=1.255u w=0.875u l=0.13u
X25 WL<12> a_3175_2100# VSS VSS sg13_lv_nmos ad=0.16625p pd=1.255u as=0.2975p ps=2.43u w=0.875u l=0.13u
X26 VDD a_2359_2616# a_3175_936# VDD sg13_lv_pmos ad=0.3078p pd=2u as=0.3078p ps=2u w=1.62u l=0.13u
X27 a_2767_936# a_2563_936# VDD VDD sg13_lv_pmos ad=0.3078p pd=2u as=0.5508p ps=3.92u w=1.62u l=0.13u
X28 WL<11> a_3826_308# VSS VSS sg13_lv_nmos ad=0.2975p pd=2.43u as=0.16625p ps=1.255u w=0.875u l=0.13u
X29 WL<5> a_3175_2616# VSS VSS sg13_lv_nmos ad=0.16625p pd=1.255u as=0.2975p ps=2.43u w=0.875u l=0.13u
X30 a_4195_2100# a_2767_2100# a_4093_2100# VDD sg13_lv_pmos ad=0.3078p pd=2u as=0.3078p ps=2u w=1.62u l=0.13u
X31 WL<2> a_3826_308# VSS VSS sg13_lv_nmos ad=0.2975p pd=2.43u as=0.16625p ps=1.255u w=0.875u l=0.13u
X32 a_4195_420# a_2767_2100# a_4093_420# VDD sg13_lv_pmos ad=0.3078p pd=2u as=0.3078p ps=2u w=1.62u l=0.13u
X33 a_3685_420# a_3175_420# VDD VDD sg13_lv_pmos ad=0.3078p pd=2u as=0.5508p ps=3.92u w=1.62u l=0.13u
X34 a_1849_2685# a_1551_2685# a_1747_2685# VDD sg13_lv_pmos ad=0.14887p pd=1.355u as=0.18525p ps=1.355u w=0.975u l=0.13u
X35 a_5317_2616# a_3175_2616# VDD VDD sg13_lv_pmos ad=0.3078p pd=2u as=0.5508p ps=3.92u w=1.62u l=0.13u
X36 VSS CS a_1551_98# VSS sg13_lv_nmos ad=0.13605p pd=1.25u as=0.1632p ps=1.64u w=0.48u l=0.13u
X37 WL<3> a_3826_308# a_4195_420# VDD sg13_lv_pmos ad=0.5508p pd=3.92u as=0.3078p ps=2u w=1.62u l=0.13u
X38 a_3787_420# a_2767_2616# a_3685_420# VDD sg13_lv_pmos ad=0.3078p pd=2u as=0.3078p ps=2u w=1.62u l=0.13u
X39 a_3175_936# CS VDD VDD sg13_lv_pmos ad=0.5508p pd=3.92u as=0.3078p ps=2u w=1.62u l=0.13u
X40 VDD a_2359_98# a_2767_936# VDD sg13_lv_pmos ad=0.5508p pd=3.92u as=0.3078p ps=2u w=1.62u l=0.13u
X41 a_1849_1778# CS a_1747_1778# VSS sg13_lv_nmos ad=0.13605p pd=1.25u as=0.1653p ps=1.25u w=0.87u l=0.13u
X42 WL<13> a_3826_308# VSS VSS sg13_lv_nmos ad=0.2975p pd=2.43u as=0.16625p ps=1.255u w=0.875u l=0.13u
X43 a_2359_98# a_1849_98# VSS VSS sg13_lv_nmos ad=0.3332p pd=2.64u as=0.3332p ps=2.64u w=0.98u l=0.13u
X44 a_1951_176# a_1551_98# a_1849_98# VSS sg13_lv_nmos ad=91.2f pd=0.86u as=0.13605p ps=1.25u w=0.48u l=0.13u
X45 a_1951_3088# a_1551_2685# a_1849_2685# VSS sg13_lv_nmos ad=91.2f pd=0.86u as=0.13605p ps=1.25u w=0.48u l=0.13u
X46 a_2563_2616# a_2359_2616# VSS VSS sg13_lv_nmos ad=0.3332p pd=2.64u as=0.3332p ps=2.64u w=0.98u l=0.13u
X47 a_2767_2616# a_2563_98# a_2767_3066# VSS sg13_lv_nmos ad=0.3332p pd=2.64u as=0.1862p ps=1.36u w=0.98u l=0.13u
X48 a_5419_2100# a_2767_936# a_5317_2100# VDD sg13_lv_pmos ad=0.3078p pd=2u as=0.3078p ps=2u w=1.62u l=0.13u
X49 WL<0> a_3175_420# VSS VSS sg13_lv_nmos ad=0.16625p pd=1.255u as=0.2975p ps=2.43u w=0.875u l=0.13u
X50 WL<12> a_3826_308# a_5011_2100# VDD sg13_lv_pmos ad=0.5508p pd=3.92u as=0.3078p ps=2u w=1.62u l=0.13u
X51 WL<2> a_3826_308# a_3787_420# VDD sg13_lv_pmos ad=0.5508p pd=3.92u as=0.3078p ps=2u w=1.62u l=0.13u
X52 WL<6> a_3826_308# VSS VSS sg13_lv_nmos ad=0.2975p pd=2.43u as=0.16625p ps=1.255u w=0.875u l=0.13u
X53 VDD a_2027_2647# a_1951_2746# VDD sg13_lv_pmos ad=91.2f pd=0.86u as=91.2f ps=0.86u w=0.48u l=0.13u
X54 VDD a_2027_1740# a_1951_2198# VDD sg13_lv_pmos ad=91.2f pd=0.86u as=91.2f ps=0.86u w=0.48u l=0.13u
X55 a_1951_1066# CS a_1849_1005# VDD sg13_lv_pmos ad=91.2f pd=0.86u as=0.14887p ps=1.355u w=0.48u l=0.13u
X56 a_2767_1778# a_2359_936# VSS VSS sg13_lv_nmos ad=0.1862p pd=1.36u as=0.3332p ps=2.64u w=0.98u l=0.13u
X57 a_1747_1005# ADDR<1> VDD VDD sg13_lv_pmos ad=0.18525p pd=1.355u as=0.14812p ps=1.355u w=0.975u l=0.13u
X58 a_3175_420# CS a_3277_98# VSS sg13_lv_nmos ad=0.3332p pd=2.64u as=0.1862p ps=1.36u w=0.98u l=0.13u
X59 a_1849_1005# CS a_1747_1408# VSS sg13_lv_nmos ad=0.13605p pd=1.25u as=0.1653p ps=1.25u w=0.87u l=0.13u
X60 a_2359_936# a_1849_1005# VSS VSS sg13_lv_nmos ad=0.3332p pd=2.64u as=0.3332p ps=2.64u w=0.98u l=0.13u
X61 WL<6> a_3826_308# a_3787_2616# VDD sg13_lv_pmos ad=0.5508p pd=3.92u as=0.3078p ps=2u w=1.62u l=0.13u
X62 WL<2> a_3175_420# VSS VSS sg13_lv_nmos ad=0.16625p pd=1.255u as=0.2975p ps=2.43u w=0.875u l=0.13u
X63 a_4093_936# a_3175_936# VDD VDD sg13_lv_pmos ad=0.3078p pd=2u as=0.5508p ps=3.92u w=1.62u l=0.13u
X64 a_3175_3066# a_2359_1778# VSS VSS sg13_lv_nmos ad=0.1862p pd=1.36u as=0.3332p ps=2.64u w=0.98u l=0.13u
X65 a_2359_1778# a_1849_1778# VDD VDD sg13_lv_pmos ad=0.5508p pd=3.92u as=0.5508p ps=3.92u w=1.62u l=0.13u
X66 a_4445_278# a_4407_98# VDD VDD sg13_lv_pmos ad=0.3078p pd=2u as=0.5508p ps=3.92u w=1.62u l=0.385u
X67 VSS a_2767_2616# WL<10> VSS sg13_lv_nmos ad=0.16625p pd=1.255u as=0.16625p ps=1.255u w=0.875u l=0.13u
X68 VSS ECLK_L_BOT a_3826_308# VSS sg13_lv_nmos ad=0.2397p pd=2.09u as=0.2397p ps=2.09u w=0.705u l=0.13u
X69 a_3175_2100# CS a_3277_1778# VSS sg13_lv_nmos ad=0.3332p pd=2.64u as=0.1862p ps=1.36u w=0.98u l=0.13u
X70 VDD a_2027_60# a_1951_518# VDD sg13_lv_pmos ad=91.2f pd=0.86u as=91.2f ps=0.86u w=0.48u l=0.13u
X71 VSS a_2767_2100# WL<7> VSS sg13_lv_nmos ad=0.16625p pd=1.255u as=0.16625p ps=1.255u w=0.875u l=0.13u
R0 ECLK_H_TOP ECLK_H_BOT 0.203077
X72 a_3277_1386# a_2359_2616# a_3175_1386# VSS sg13_lv_nmos ad=0.1862p pd=1.36u as=0.1862p ps=1.36u w=0.98u l=0.13u
X73 a_3685_2100# a_3175_2100# VDD VDD sg13_lv_pmos ad=0.3078p pd=2u as=0.5508p ps=3.92u w=1.62u l=0.13u
X74 a_2027_967# a_1849_1005# VSS VSS sg13_lv_nmos ad=0.1632p pd=1.64u as=91.2f ps=0.86u w=0.48u l=0.13u
X75 VSS a_4445_278# a_4407_98# VSS sg13_lv_nmos ad=0.2822p pd=2.34u as=0.1577p ps=1.21u w=0.83u l=0.13u
X76 a_4195_2616# a_2767_2100# a_4093_2616# VDD sg13_lv_pmos ad=0.3078p pd=2u as=0.3078p ps=2u w=1.62u l=0.13u
X77 WL<0> a_3826_308# a_5011_420# VDD sg13_lv_pmos ad=0.5508p pd=3.92u as=0.3078p ps=2u w=1.62u l=0.13u
X78 a_4195_936# a_2767_2100# a_4093_936# VDD sg13_lv_pmos ad=0.3078p pd=2u as=0.3078p ps=2u w=1.62u l=0.13u
X79 a_3685_936# a_3175_936# VDD VDD sg13_lv_pmos ad=0.3078p pd=2u as=0.5508p ps=3.92u w=1.62u l=0.13u
X80 VDD a_2359_2616# a_3175_2100# VDD sg13_lv_pmos ad=0.3078p pd=2u as=0.3078p ps=2u w=1.62u l=0.13u
X81 WL<11> a_3826_308# a_4195_936# VDD sg13_lv_pmos ad=0.5508p pd=3.92u as=0.3078p ps=2u w=1.62u l=0.13u
X82 a_3787_936# a_2767_2616# a_3685_936# VDD sg13_lv_pmos ad=0.3078p pd=2u as=0.3078p ps=2u w=1.62u l=0.13u
X83 ECLK_L_BOT ECLK_H_BOT VSS VSS sg13_lv_nmos ad=0.2397p pd=2.09u as=0.2397p ps=2.09u w=0.705u l=0.13u
X84 VSS a_2767_420# WL<12> VSS sg13_lv_nmos ad=0.16625p pd=1.255u as=0.16625p ps=1.255u w=0.875u l=0.13u
X85 a_1747_2160# ADDR<2> VDD VDD sg13_lv_pmos ad=0.18525p pd=1.355u as=0.14812p ps=1.355u w=0.975u l=0.13u
X86 VSS CS a_1551_1005# VSS sg13_lv_nmos ad=0.13605p pd=1.25u as=0.1632p ps=1.64u w=0.48u l=0.13u
X87 VSS a_2767_936# WL<1> VSS sg13_lv_nmos ad=0.16625p pd=1.255u as=0.16625p ps=1.255u w=0.875u l=0.13u
X88 a_1747_98# ADDR<0> VSS VSS sg13_lv_nmos ad=0.1653p pd=1.25u as=0.13605p ps=1.25u w=0.87u l=0.13u
X89 a_2027_60# a_1849_98# VDD VDD sg13_lv_pmos ad=0.1632p pd=1.64u as=91.2f ps=0.86u w=0.48u l=0.13u
X90 WL<11> a_3175_936# VSS VSS sg13_lv_nmos ad=0.16625p pd=1.255u as=0.2975p ps=2.43u w=0.875u l=0.13u
X91 a_3175_98# a_2563_1778# VSS VSS sg13_lv_nmos ad=0.1862p pd=1.36u as=0.3332p ps=2.64u w=0.98u l=0.13u
X92 WL<4> a_3826_308# VSS VSS sg13_lv_nmos ad=0.2975p pd=2.43u as=0.16625p ps=1.255u w=0.875u l=0.13u
X93 VSS a_2767_936# WL<5> VSS sg13_lv_nmos ad=0.16625p pd=1.255u as=0.16625p ps=1.255u w=0.875u l=0.13u
X94 WL<15> a_3826_308# VSS VSS sg13_lv_nmos ad=0.2975p pd=2.43u as=0.16625p ps=1.255u w=0.875u l=0.13u
X95 a_4909_2100# a_3175_2100# VDD VDD sg13_lv_pmos ad=0.3078p pd=2u as=0.5508p ps=3.92u w=1.62u l=0.13u
X96 a_5419_2616# a_2767_936# a_5317_2616# VDD sg13_lv_pmos ad=0.3078p pd=2u as=0.3078p ps=2u w=1.62u l=0.13u
X97 VDD CS a_1551_2685# VDD sg13_lv_pmos ad=0.14812p pd=1.355u as=0.1632p ps=1.64u w=0.48u l=0.13u
X98 WL<4> a_3826_308# a_5011_2616# VDD sg13_lv_pmos ad=0.5508p pd=3.92u as=0.3078p ps=2u w=1.62u l=0.13u
X99 a_5317_420# a_3175_420# VDD VDD sg13_lv_pmos ad=0.3078p pd=2u as=0.5508p ps=3.92u w=1.62u l=0.13u
X100 WL<10> a_3826_308# a_3787_936# VDD sg13_lv_pmos ad=0.5508p pd=3.92u as=0.3078p ps=2u w=1.62u l=0.13u
X101 a_2767_98# a_2563_936# VSS VSS sg13_lv_nmos ad=0.1862p pd=1.36u as=0.3332p ps=2.64u w=0.98u l=0.13u
X102 VSS CS a_1551_1778# VSS sg13_lv_nmos ad=0.13605p pd=1.25u as=0.1632p ps=1.64u w=0.48u l=0.13u
X103 VSS a_2767_2100# WL<3> VSS sg13_lv_nmos ad=0.16625p pd=1.255u as=0.16625p ps=1.255u w=0.875u l=0.13u
X104 WL<9> a_3175_936# VSS VSS sg13_lv_nmos ad=0.16625p pd=1.255u as=0.2975p ps=2.43u w=0.875u l=0.13u
X105 WL<13> a_3826_308# a_5419_2100# VDD sg13_lv_pmos ad=0.5508p pd=3.92u as=0.3078p ps=2u w=1.62u l=0.13u
X106 a_2359_2616# a_1849_2685# VDD VDD sg13_lv_pmos ad=0.5508p pd=3.92u as=0.5508p ps=3.92u w=1.62u l=0.13u
X107 a_5419_420# a_2767_936# a_5317_420# VDD sg13_lv_pmos ad=0.3078p pd=2u as=0.3078p ps=2u w=1.62u l=0.13u
X108 a_4909_420# a_3175_420# VDD VDD sg13_lv_pmos ad=0.3078p pd=2u as=0.5508p ps=3.92u w=1.62u l=0.13u
X109 VSS a_2767_2616# WL<2> VSS sg13_lv_nmos ad=0.16625p pd=1.255u as=0.16625p ps=1.255u w=0.875u l=0.13u
X110 a_2027_1740# a_1849_1778# VDD VDD sg13_lv_pmos ad=0.1632p pd=1.64u as=91.2f ps=0.86u w=0.48u l=0.13u
X111 WL<6> a_3175_2616# VSS VSS sg13_lv_nmos ad=0.16625p pd=1.255u as=0.2975p ps=2.43u w=0.875u l=0.13u
X112 a_2027_2647# a_1849_2685# VDD VDD sg13_lv_pmos ad=0.1632p pd=1.64u as=91.2f ps=0.86u w=0.48u l=0.13u
X113 a_2767_2100# a_2359_98# a_2767_1778# VSS sg13_lv_nmos ad=0.3332p pd=2.64u as=0.1862p ps=1.36u w=0.98u l=0.13u
X114 a_2767_1386# a_2563_936# VSS VSS sg13_lv_nmos ad=0.1862p pd=1.36u as=0.3332p ps=2.64u w=0.98u l=0.13u
X115 VDD a_4407_98# a_4445_278# VDD sg13_lv_pmos ad=0.5508p pd=3.92u as=0.3078p ps=2u w=1.62u l=0.385u
X116 a_2563_1778# a_2359_1778# VSS VSS sg13_lv_nmos ad=0.3332p pd=2.64u as=0.3332p ps=2.64u w=0.98u l=0.13u
X117 a_1951_1408# a_1551_1005# a_1849_1005# VSS sg13_lv_nmos ad=91.2f pd=0.86u as=0.13605p ps=1.25u w=0.48u l=0.13u
X118 a_1849_1005# a_1551_1005# a_1747_1005# VDD sg13_lv_pmos ad=0.14887p pd=1.355u as=0.18525p ps=1.355u w=0.975u l=0.13u
X119 a_1951_518# CS a_1849_98# VDD sg13_lv_pmos ad=91.2f pd=0.86u as=0.14887p ps=1.355u w=0.48u l=0.13u
X120 a_3685_2616# a_3175_2616# VDD VDD sg13_lv_pmos ad=0.3078p pd=2u as=0.5508p ps=3.92u w=1.62u l=0.13u
X121 a_2767_2100# a_2359_936# VDD VDD sg13_lv_pmos ad=0.3078p pd=2u as=0.5508p ps=3.92u w=1.62u l=0.13u
X122 WL<1> a_3826_308# a_5419_420# VDD sg13_lv_pmos ad=0.5508p pd=3.92u as=0.3078p ps=2u w=1.62u l=0.13u
X123 WL<8> a_3826_308# a_5011_936# VDD sg13_lv_pmos ad=0.5508p pd=3.92u as=0.3078p ps=2u w=1.62u l=0.13u
X124 VDD a_2563_2616# a_3175_2616# VDD sg13_lv_pmos ad=0.3078p pd=2u as=0.3078p ps=2u w=1.62u l=0.13u
X125 a_5011_420# a_2767_420# a_4909_420# VDD sg13_lv_pmos ad=0.3078p pd=2u as=0.3078p ps=2u w=1.62u l=0.13u
X126 a_2563_98# a_2359_98# VSS VSS sg13_lv_nmos ad=0.3332p pd=2.64u as=0.3332p ps=2.64u w=0.98u l=0.13u
X127 WL<10> a_3826_308# VSS VSS sg13_lv_nmos ad=0.2975p pd=2.43u as=0.16625p ps=1.255u w=0.875u l=0.13u
X128 WL<4> a_3175_2616# VSS VSS sg13_lv_nmos ad=0.16625p pd=1.255u as=0.2975p ps=2.43u w=0.875u l=0.13u
X129 VSS a_2767_2616# WL<14> VSS sg13_lv_nmos ad=0.16625p pd=1.255u as=0.16625p ps=1.255u w=0.875u l=0.13u
X130 a_3175_1778# a_2359_1778# VSS VSS sg13_lv_nmos ad=0.1862p pd=1.36u as=0.3332p ps=2.64u w=0.98u l=0.13u
X131 a_3175_936# CS a_3277_1386# VSS sg13_lv_nmos ad=0.3332p pd=2.64u as=0.1862p ps=1.36u w=0.98u l=0.13u
X132 a_4909_2616# a_3175_2616# VDD VDD sg13_lv_pmos ad=0.3078p pd=2u as=0.5508p ps=3.92u w=1.62u l=0.13u
X133 a_3277_98# a_2563_2616# a_3175_98# VSS sg13_lv_nmos ad=0.1862p pd=1.36u as=0.1862p ps=1.36u w=0.98u l=0.13u
X134 VDD ECLK_L_BOT a_3826_308# VDD sg13_lv_pmos ad=0.5508p pd=3.92u as=0.5508p ps=3.92u w=1.62u l=0.13u
X135 a_3175_2100# CS VDD VDD sg13_lv_pmos ad=0.5508p pd=3.92u as=0.3078p ps=2u w=1.62u l=0.13u
X136 a_5317_936# a_3175_936# VDD VDD sg13_lv_pmos ad=0.3078p pd=2u as=0.5508p ps=3.92u w=1.62u l=0.13u
X137 VSS a_2767_2100# WL<11> VSS sg13_lv_nmos ad=0.16625p pd=1.255u as=0.16625p ps=1.255u w=0.875u l=0.13u
X138 a_1849_1778# a_1551_1778# a_1747_2160# VDD sg13_lv_pmos ad=0.14887p pd=1.355u as=0.18525p ps=1.355u w=0.975u l=0.13u
X139 WL<5> a_3826_308# VSS VSS sg13_lv_nmos ad=0.2975p pd=2.43u as=0.16625p ps=1.255u w=0.875u l=0.13u
X140 a_5011_2100# a_2767_420# a_4909_2100# VDD sg13_lv_pmos ad=0.3078p pd=2u as=0.3078p ps=2u w=1.62u l=0.13u
X141 VSS a_2027_1740# a_1951_1856# VSS sg13_lv_nmos ad=91.2f pd=0.86u as=91.2f ps=0.86u w=0.48u l=0.13u
X142 WL<15> a_3175_2100# VSS VSS sg13_lv_nmos ad=0.16625p pd=1.255u as=0.2975p ps=2.43u w=0.875u l=0.13u
X143 ECLK_L_BOT ECLK_H_BOT VDD VDD sg13_lv_pmos ad=0.5508p pd=3.92u as=0.5508p ps=3.92u w=1.62u l=0.13u
X144 WL<3> a_3826_308# VSS VSS sg13_lv_nmos ad=0.2975p pd=2.43u as=0.16625p ps=1.255u w=0.875u l=0.13u
X145 WL<5> a_3826_308# a_5419_2616# VDD sg13_lv_pmos ad=0.5508p pd=3.92u as=0.3078p ps=2u w=1.62u l=0.13u
X146 a_1951_2746# CS a_1849_2685# VDD sg13_lv_pmos ad=91.2f pd=0.86u as=0.14887p ps=1.355u w=0.48u l=0.13u
X147 a_1951_2198# CS a_1849_1778# VDD sg13_lv_pmos ad=91.2f pd=0.86u as=0.14887p ps=1.355u w=0.48u l=0.13u
X148 WL<15> a_3826_308# a_4195_2100# VDD sg13_lv_pmos ad=0.5508p pd=3.92u as=0.3078p ps=2u w=1.62u l=0.13u
X149 a_4407_98# a_4445_278# VSS VSS sg13_lv_nmos ad=0.1577p pd=1.21u as=0.1577p ps=1.21u w=0.83u l=0.13u
X150 a_5419_936# a_2767_936# a_5317_936# VDD sg13_lv_pmos ad=0.3078p pd=2u as=0.3078p ps=2u w=1.62u l=0.13u
X151 a_4909_936# a_3175_936# VDD VDD sg13_lv_pmos ad=0.3078p pd=2u as=0.5508p ps=3.92u w=1.62u l=0.13u
X152 VSS a_2767_936# WL<9> VSS sg13_lv_nmos ad=0.16625p pd=1.255u as=0.16625p ps=1.255u w=0.875u l=0.13u
X153 WL<8> a_3826_308# VSS VSS sg13_lv_nmos ad=0.2975p pd=2.43u as=0.16625p ps=1.255u w=0.875u l=0.13u
X154 WL<13> a_3175_2100# VSS VSS sg13_lv_nmos ad=0.16625p pd=1.255u as=0.2975p ps=2.43u w=0.875u l=0.13u
X155 WL<1> a_3175_420# VSS VSS sg13_lv_nmos ad=0.16625p pd=1.255u as=0.2975p ps=2.43u w=0.875u l=0.13u
X156 a_2767_2616# a_2359_936# VDD VDD sg13_lv_pmos ad=0.3078p pd=2u as=0.5508p ps=3.92u w=1.62u l=0.13u
X157 WL<9> a_3826_308# a_5419_936# VDD sg13_lv_pmos ad=0.5508p pd=3.92u as=0.3078p ps=2u w=1.62u l=0.13u
X158 a_1747_3088# ADDR<3> VSS VSS sg13_lv_nmos ad=0.1653p pd=1.25u as=0.13605p ps=1.25u w=0.87u l=0.13u
X159 a_2359_2616# a_1849_2685# VSS VSS sg13_lv_nmos ad=0.3332p pd=2.64u as=0.3332p ps=2.64u w=0.98u l=0.13u
X160 a_5011_936# a_2767_420# a_4909_936# VDD sg13_lv_pmos ad=0.3078p pd=2u as=0.3078p ps=2u w=1.62u l=0.13u
X161 a_2359_98# a_1849_98# VDD VDD sg13_lv_pmos ad=0.5508p pd=3.92u as=0.5508p ps=3.92u w=1.62u l=0.13u
X162 a_2563_936# a_2359_936# VSS VSS sg13_lv_nmos ad=0.3332p pd=2.64u as=0.3332p ps=2.64u w=0.98u l=0.13u
X163 a_2767_936# a_2359_98# a_2767_1386# VSS sg13_lv_nmos ad=0.3332p pd=2.64u as=0.1862p ps=1.36u w=0.98u l=0.13u
X164 VDD CS a_1551_1005# VDD sg13_lv_pmos ad=0.14812p pd=1.355u as=0.1632p ps=1.64u w=0.48u l=0.13u
X165 WL<3> a_3175_420# VSS VSS sg13_lv_nmos ad=0.16625p pd=1.255u as=0.2975p ps=2.43u w=0.875u l=0.13u
X166 VDD a_2359_98# a_2767_2100# VDD sg13_lv_pmos ad=0.5508p pd=3.92u as=0.3078p ps=2u w=1.62u l=0.13u
X167 a_2563_1778# a_2359_1778# VDD VDD sg13_lv_pmos ad=0.5508p pd=3.92u as=0.5508p ps=3.92u w=1.62u l=0.13u
X168 a_3175_2616# CS VDD VDD sg13_lv_pmos ad=0.5508p pd=3.92u as=0.3078p ps=2u w=1.62u l=0.13u
X169 VSS a_2027_2647# a_1951_3088# VSS sg13_lv_nmos ad=91.2f pd=0.86u as=91.2f ps=0.86u w=0.48u l=0.13u
X170 a_3277_3066# a_2563_2616# a_3175_3066# VSS sg13_lv_nmos ad=0.1862p pd=1.36u as=0.1862p ps=1.36u w=0.98u l=0.13u
X171 WL<10> a_3175_936# VSS VSS sg13_lv_nmos ad=0.16625p pd=1.255u as=0.2975p ps=2.43u w=0.875u l=0.13u
X172 VSS a_2767_420# WL<4> VSS sg13_lv_nmos ad=0.16625p pd=1.255u as=0.16625p ps=1.255u w=0.875u l=0.13u
X173 WL<14> a_3826_308# VSS VSS sg13_lv_nmos ad=0.2975p pd=2.43u as=0.16625p ps=1.255u w=0.875u l=0.13u
X174 WL<0> a_3826_308# VSS VSS sg13_lv_nmos ad=0.2975p pd=2.43u as=0.16625p ps=1.255u w=0.875u l=0.13u
X175 a_3175_1386# a_2563_1778# VSS VSS sg13_lv_nmos ad=0.1862p pd=1.36u as=0.3332p ps=2.64u w=0.98u l=0.13u
X176 WL<7> a_3826_308# VSS VSS sg13_lv_nmos ad=0.2975p pd=2.43u as=0.16625p ps=1.255u w=0.875u l=0.13u
X177 a_5011_2616# a_2767_420# a_4909_2616# VDD sg13_lv_pmos ad=0.3078p pd=2u as=0.3078p ps=2u w=1.62u l=0.13u
X178 VDD ECLK_L_BOT a_3826_308# VDD sg13_lv_pmos ad=0.5508p pd=3.92u as=0.5508p ps=3.92u w=1.62u l=0.13u
X179 a_3787_2100# a_2767_2616# a_3685_2100# VDD sg13_lv_pmos ad=0.3078p pd=2u as=0.3078p ps=2u w=1.62u l=0.13u
X180 VDD a_2027_967# a_1951_1066# VDD sg13_lv_pmos ad=91.2f pd=0.86u as=91.2f ps=0.86u w=0.48u l=0.13u
X181 VSS CS a_1551_2685# VSS sg13_lv_nmos ad=0.13605p pd=1.25u as=0.1632p ps=1.64u w=0.48u l=0.13u
X182 a_1747_480# ADDR<0> VDD VDD sg13_lv_pmos ad=0.18525p pd=1.355u as=0.14812p ps=1.355u w=0.975u l=0.13u
X183 VSS ECLK_L_BOT a_3826_308# VSS sg13_lv_nmos ad=0.2397p pd=2.09u as=0.2397p ps=2.09u w=0.705u l=0.13u
X184 WL<7> a_3826_308# a_4195_2616# VDD sg13_lv_pmos ad=0.5508p pd=3.92u as=0.3078p ps=2u w=1.62u l=0.13u
X185 a_3175_2100# a_2359_1778# VDD VDD sg13_lv_pmos ad=0.3078p pd=2u as=0.5508p ps=3.92u w=1.62u l=0.13u
X186 a_2563_98# a_2359_98# VDD VDD sg13_lv_pmos ad=0.5508p pd=3.92u as=0.5508p ps=3.92u w=1.62u l=0.13u
X187 WL<8> a_3175_936# VSS VSS sg13_lv_nmos ad=0.16625p pd=1.255u as=0.2975p ps=2.43u w=0.875u l=0.13u
X188 VSS a_2767_2100# WL<15> VSS sg13_lv_nmos ad=0.16625p pd=1.255u as=0.16625p ps=1.255u w=0.875u l=0.13u
X189 VDD CS a_1551_98# VDD sg13_lv_pmos ad=0.14812p pd=1.355u as=0.1632p ps=1.64u w=0.48u l=0.13u
X190 a_2027_1740# a_1849_1778# VSS VSS sg13_lv_nmos ad=0.1632p pd=1.64u as=91.2f ps=0.86u w=0.48u l=0.13u
X191 VSS a_2767_420# WL<0> VSS sg13_lv_nmos ad=0.16625p pd=1.255u as=0.16625p ps=1.255u w=0.875u l=0.13u
R1 ECLK_L_TOP ECLK_L_BOT 0.203077
X192 a_1849_98# a_1551_98# a_1747_480# VDD sg13_lv_pmos ad=0.14887p pd=1.355u as=0.18525p ps=1.355u w=0.975u l=0.13u
X193 a_3175_420# a_2563_1778# VDD VDD sg13_lv_pmos ad=0.3078p pd=2u as=0.5508p ps=3.92u w=1.62u l=0.13u
X194 a_4093_2100# a_3175_2100# VDD VDD sg13_lv_pmos ad=0.3078p pd=2u as=0.5508p ps=3.92u w=1.62u l=0.13u
X195 a_1747_2685# ADDR<3> VDD VDD sg13_lv_pmos ad=0.18525p pd=1.355u as=0.14812p ps=1.355u w=0.975u l=0.13u
X196 WL<9> a_3826_308# VSS VSS sg13_lv_nmos ad=0.2975p pd=2.43u as=0.16625p ps=1.255u w=0.875u l=0.13u
X197 VDD CS a_1551_1778# VDD sg13_lv_pmos ad=0.14812p pd=1.355u as=0.1632p ps=1.64u w=0.48u l=0.13u
X198 VDD a_2563_2616# a_3175_420# VDD sg13_lv_pmos ad=0.3078p pd=2u as=0.3078p ps=2u w=1.62u l=0.13u
X199 a_2767_420# a_2563_936# VDD VDD sg13_lv_pmos ad=0.3078p pd=2u as=0.5508p ps=3.92u w=1.62u l=0.13u
X200 a_2359_936# a_1849_1005# VDD VDD sg13_lv_pmos ad=0.5508p pd=3.92u as=0.5508p ps=3.92u w=1.62u l=0.13u
X201 a_1747_1778# ADDR<2> VSS VSS sg13_lv_nmos ad=0.1653p pd=1.25u as=0.13605p ps=1.25u w=0.87u l=0.13u
X202 VSS a_2767_936# WL<13> VSS sg13_lv_nmos ad=0.16625p pd=1.255u as=0.16625p ps=1.255u w=0.875u l=0.13u
X203 WL<12> a_3826_308# VSS VSS sg13_lv_nmos ad=0.2975p pd=2.43u as=0.16625p ps=1.255u w=0.875u l=0.13u
X204 VDD a_2563_98# a_2767_2616# VDD sg13_lv_pmos ad=0.5508p pd=3.92u as=0.3078p ps=2u w=1.62u l=0.13u
X205 a_1849_2685# CS a_1747_3088# VSS sg13_lv_nmos ad=0.13605p pd=1.25u as=0.1653p ps=1.25u w=0.87u l=0.13u
X206 a_2767_3066# a_2359_936# VSS VSS sg13_lv_nmos ad=0.1862p pd=1.36u as=0.3332p ps=2.64u w=0.98u l=0.13u
X207 a_2563_2616# a_2359_2616# VDD VDD sg13_lv_pmos ad=0.5508p pd=3.92u as=0.5508p ps=3.92u w=1.62u l=0.13u
X208 a_5317_2100# a_3175_2100# VDD VDD sg13_lv_pmos ad=0.3078p pd=2u as=0.5508p ps=3.92u w=1.62u l=0.13u
X209 a_3175_420# CS VDD VDD sg13_lv_pmos ad=0.5508p pd=3.92u as=0.3078p ps=2u w=1.62u l=0.13u
X210 VDD a_2563_98# a_2767_420# VDD sg13_lv_pmos ad=0.5508p pd=3.92u as=0.3078p ps=2u w=1.62u l=0.13u
.ends

.subckt RM_IHPSG13_1P_DEC02 ADDR<0> ADDR<1> CS VSS VDD CS_OUT
X0 a_931_98# ADDR<1> VSS VSS sg13_lv_nmos ad=0.1862p pd=1.36u as=0.3332p ps=2.64u w=0.98u l=0.13u
X1 CS_OUT a_931_420# VSS VSS sg13_lv_nmos ad=0.1862p pd=1.36u as=0.3332p ps=2.64u w=0.98u l=0.13u
X2 a_931_420# ADDR<1> VDD VDD sg13_lv_pmos ad=0.3078p pd=2u as=0.5508p ps=3.92u w=1.62u l=0.13u
X3 a_931_420# CS a_1033_98# VSS sg13_lv_nmos ad=0.3332p pd=2.64u as=0.1862p ps=1.36u w=0.98u l=0.13u
X4 VDD a_523_98# a_931_420# VDD sg13_lv_pmos ad=0.3078p pd=2u as=0.3078p ps=2u w=1.62u l=0.13u
X5 a_931_420# CS VDD VDD sg13_lv_pmos ad=0.5508p pd=3.92u as=0.3078p ps=2u w=1.62u l=0.13u
X6 CS_OUT a_931_420# VDD VDD sg13_lv_pmos ad=0.3078p pd=2u as=0.5508p ps=3.92u w=1.62u l=0.13u
X7 VSS a_59_278# a_21_98# VSS sg13_lv_nmos ad=0.2822p pd=2.34u as=0.1577p ps=1.21u w=0.83u l=0.13u
X8 VDD a_931_420# CS_OUT VDD sg13_lv_pmos ad=0.5508p pd=3.92u as=0.3078p ps=2u w=1.62u l=0.13u
X9 a_1033_98# a_523_98# a_931_98# VSS sg13_lv_nmos ad=0.1862p pd=1.36u as=0.1862p ps=1.36u w=0.98u l=0.13u
X10 VDD a_21_98# a_59_278# VDD sg13_lv_pmos ad=0.5508p pd=3.92u as=0.3078p ps=2u w=1.62u l=0.385u
X11 a_523_98# ADDR<0> VDD VDD sg13_lv_pmos ad=0.5508p pd=3.92u as=0.5508p ps=3.92u w=1.62u l=0.13u
X12 a_21_98# a_59_278# VSS VSS sg13_lv_nmos ad=0.1577p pd=1.21u as=0.1577p ps=1.21u w=0.83u l=0.13u
X13 VSS a_931_420# CS_OUT VSS sg13_lv_nmos ad=0.3332p pd=2.64u as=0.1862p ps=1.36u w=0.98u l=0.13u
X14 a_523_98# ADDR<0> VSS VSS sg13_lv_nmos ad=0.3332p pd=2.64u as=0.3332p ps=2.64u w=0.98u l=0.13u
X15 VSS a_59_278# a_21_98# VSS sg13_lv_nmos ad=0.1577p pd=1.21u as=0.2822p ps=2.34u w=0.83u l=0.13u
X16 a_59_278# a_21_98# VDD VDD sg13_lv_pmos ad=0.3078p pd=2u as=0.5508p ps=3.92u w=1.62u l=0.385u
.ends

.subckt RM_IHPSG13_1P_DEC00 CS ADDR<1> ADDR<0> CS_OUT VDD VSS
X0 a_931_98# a_727_98# VSS VSS sg13_lv_nmos ad=0.1862p pd=1.36u as=0.3332p ps=2.64u w=0.98u l=0.13u
X1 a_727_98# ADDR<1> VDD VDD sg13_lv_pmos ad=0.5508p pd=3.92u as=0.5508p ps=3.92u w=1.62u l=0.13u
X2 CS_OUT a_931_420# VSS VSS sg13_lv_nmos ad=0.1862p pd=1.36u as=0.3332p ps=2.64u w=0.98u l=0.13u
X3 a_931_420# a_727_98# VDD VDD sg13_lv_pmos ad=0.3078p pd=2u as=0.5508p ps=3.92u w=1.62u l=0.13u
X4 a_931_420# CS a_1033_98# VSS sg13_lv_nmos ad=0.3332p pd=2.64u as=0.1862p ps=1.36u w=0.98u l=0.13u
X5 VDD a_523_98# a_931_420# VDD sg13_lv_pmos ad=0.3078p pd=2u as=0.3078p ps=2u w=1.62u l=0.13u
X6 a_931_420# CS VDD VDD sg13_lv_pmos ad=0.5508p pd=3.92u as=0.3078p ps=2u w=1.62u l=0.13u
X7 CS_OUT a_931_420# VDD VDD sg13_lv_pmos ad=0.3078p pd=2u as=0.5508p ps=3.92u w=1.62u l=0.13u
X8 VSS a_59_278# a_21_98# VSS sg13_lv_nmos ad=0.2822p pd=2.34u as=0.1577p ps=1.21u w=0.83u l=0.13u
X9 VDD a_931_420# CS_OUT VDD sg13_lv_pmos ad=0.5508p pd=3.92u as=0.3078p ps=2u w=1.62u l=0.13u
X10 a_1033_98# a_523_98# a_931_98# VSS sg13_lv_nmos ad=0.1862p pd=1.36u as=0.1862p ps=1.36u w=0.98u l=0.13u
X11 a_727_98# ADDR<1> VSS VSS sg13_lv_nmos ad=0.3332p pd=2.64u as=0.3332p ps=2.64u w=0.98u l=0.13u
X12 VDD a_21_98# a_59_278# VDD sg13_lv_pmos ad=0.5508p pd=3.92u as=0.3078p ps=2u w=1.62u l=0.385u
X13 a_523_98# ADDR<0> VDD VDD sg13_lv_pmos ad=0.5508p pd=3.92u as=0.5508p ps=3.92u w=1.62u l=0.13u
X14 a_21_98# a_59_278# VSS VSS sg13_lv_nmos ad=0.1577p pd=1.21u as=0.1577p ps=1.21u w=0.83u l=0.13u
X15 VSS a_931_420# CS_OUT VSS sg13_lv_nmos ad=0.3332p pd=2.64u as=0.1862p ps=1.36u w=0.98u l=0.13u
X16 a_523_98# ADDR<0> VSS VSS sg13_lv_nmos ad=0.3332p pd=2.64u as=0.3332p ps=2.64u w=0.98u l=0.13u
X17 VSS a_59_278# a_21_98# VSS sg13_lv_nmos ad=0.1577p pd=1.21u as=0.2822p ps=2.34u w=0.83u l=0.13u
X18 a_59_278# a_21_98# VDD VDD sg13_lv_pmos ad=0.3078p pd=2u as=0.5508p ps=3.92u w=1.62u l=0.385u
.ends

.subckt RM_IHPSG13_1P_DEC03 ADDR<0> ADDR<1> CS VSS VDD CS_OUT
X0 a_931_98# ADDR<1> VSS VSS sg13_lv_nmos ad=0.1862p pd=1.36u as=0.3332p ps=2.64u w=0.98u l=0.13u
X1 CS_OUT a_931_420# VSS VSS sg13_lv_nmos ad=0.1862p pd=1.36u as=0.3332p ps=2.64u w=0.98u l=0.13u
X2 a_931_420# ADDR<1> VDD VDD sg13_lv_pmos ad=0.3078p pd=2u as=0.5508p ps=3.92u w=1.62u l=0.13u
X3 a_931_420# CS a_1033_98# VSS sg13_lv_nmos ad=0.3332p pd=2.64u as=0.1862p ps=1.36u w=0.98u l=0.13u
X4 VDD ADDR<0> a_931_420# VDD sg13_lv_pmos ad=0.3078p pd=2u as=0.3078p ps=2u w=1.62u l=0.13u
X5 a_931_420# CS VDD VDD sg13_lv_pmos ad=0.5508p pd=3.92u as=0.3078p ps=2u w=1.62u l=0.13u
X6 CS_OUT a_931_420# VDD VDD sg13_lv_pmos ad=0.3078p pd=2u as=0.5508p ps=3.92u w=1.62u l=0.13u
X7 VSS a_59_278# a_21_98# VSS sg13_lv_nmos ad=0.2822p pd=2.34u as=0.1577p ps=1.21u w=0.83u l=0.13u
X8 VDD a_931_420# CS_OUT VDD sg13_lv_pmos ad=0.5508p pd=3.92u as=0.3078p ps=2u w=1.62u l=0.13u
X9 a_1033_98# ADDR<0> a_931_98# VSS sg13_lv_nmos ad=0.1862p pd=1.36u as=0.1862p ps=1.36u w=0.98u l=0.13u
X10 VDD a_21_98# a_59_278# VDD sg13_lv_pmos ad=0.5508p pd=3.92u as=0.3078p ps=2u w=1.62u l=0.385u
X11 a_21_98# a_59_278# VSS VSS sg13_lv_nmos ad=0.1577p pd=1.21u as=0.1577p ps=1.21u w=0.83u l=0.13u
X12 VSS a_931_420# CS_OUT VSS sg13_lv_nmos ad=0.3332p pd=2.64u as=0.1862p ps=1.36u w=0.98u l=0.13u
X13 VSS a_59_278# a_21_98# VSS sg13_lv_nmos ad=0.1577p pd=1.21u as=0.2822p ps=2.34u w=0.83u l=0.13u
X14 a_59_278# a_21_98# VDD VDD sg13_lv_pmos ad=0.3078p pd=2u as=0.5508p ps=3.92u w=1.62u l=0.385u
.ends

.subckt RM_IHPSG13_1P_DEC01 ADDR<0> ADDR<1> CS VSS VDD CS_OUT
X0 a_931_98# a_727_98# VSS VSS sg13_lv_nmos ad=0.1862p pd=1.36u as=0.3332p ps=2.64u w=0.98u l=0.13u
X1 a_727_98# ADDR<1> VDD VDD sg13_lv_pmos ad=0.5508p pd=3.92u as=0.5508p ps=3.92u w=1.62u l=0.13u
X2 CS_OUT a_931_420# VSS VSS sg13_lv_nmos ad=0.1862p pd=1.36u as=0.3332p ps=2.64u w=0.98u l=0.13u
X3 a_931_420# a_727_98# VDD VDD sg13_lv_pmos ad=0.3078p pd=2u as=0.5508p ps=3.92u w=1.62u l=0.13u
X4 a_931_420# CS a_1033_98# VSS sg13_lv_nmos ad=0.3332p pd=2.64u as=0.1862p ps=1.36u w=0.98u l=0.13u
X5 VDD ADDR<0> a_931_420# VDD sg13_lv_pmos ad=0.3078p pd=2u as=0.3078p ps=2u w=1.62u l=0.13u
X6 a_931_420# CS VDD VDD sg13_lv_pmos ad=0.5508p pd=3.92u as=0.3078p ps=2u w=1.62u l=0.13u
X7 CS_OUT a_931_420# VDD VDD sg13_lv_pmos ad=0.3078p pd=2u as=0.5508p ps=3.92u w=1.62u l=0.13u
X8 VSS a_59_278# a_21_98# VSS sg13_lv_nmos ad=0.2822p pd=2.34u as=0.1577p ps=1.21u w=0.83u l=0.13u
X9 VDD a_931_420# CS_OUT VDD sg13_lv_pmos ad=0.5508p pd=3.92u as=0.3078p ps=2u w=1.62u l=0.13u
X10 a_1033_98# ADDR<0> a_931_98# VSS sg13_lv_nmos ad=0.1862p pd=1.36u as=0.1862p ps=1.36u w=0.98u l=0.13u
X11 a_727_98# ADDR<1> VSS VSS sg13_lv_nmos ad=0.3332p pd=2.64u as=0.3332p ps=2.64u w=0.98u l=0.13u
X12 VDD a_21_98# a_59_278# VDD sg13_lv_pmos ad=0.5508p pd=3.92u as=0.3078p ps=2u w=1.62u l=0.385u
X13 a_21_98# a_59_278# VSS VSS sg13_lv_nmos ad=0.1577p pd=1.21u as=0.1577p ps=1.21u w=0.83u l=0.13u
X14 VSS a_931_420# CS_OUT VSS sg13_lv_nmos ad=0.3332p pd=2.64u as=0.1862p ps=1.36u w=0.98u l=0.13u
X15 VSS a_59_278# a_21_98# VSS sg13_lv_nmos ad=0.1577p pd=1.21u as=0.2822p ps=2.34u w=0.83u l=0.13u
X16 a_59_278# a_21_98# VDD VDD sg13_lv_pmos ad=0.3078p pd=2u as=0.5508p ps=3.92u w=1.62u l=0.385u
.ends

.subckt RM_IHPSG13_1P_ROWDEC8 ADDR_N_I<7> ADDR_N_I<1> ADDR_N_I<0> ADDR_N_I<6> ADDR_N_I<5>
+ ADDR_N_I<3> ADDR_N_I<2> ADDR_N_I<4> CS_I ECLK_I WL_O<192> WL_O<193> WL_O<194> WL_O<195>
+ WL_O<200> WL_O<201> WL_O<202> WL_O<203> WL_O<204> WL_O<205> WL_O<206> WL_O<207>
+ WL_O<213> WL_O<214> WL_O<215> WL_O<216> WL_O<217> WL_O<230> WL_O<231> WL_O<232>
+ WL_O<233> WL_O<234> WL_O<235> WL_O<236> WL_O<237> WL_O<238> WL_O<239> WL_O<240>
+ WL_O<241> WL_O<242> WL_O<243> WL_O<244> WL_O<245> WL_O<246> WL_O<247> WL_O<132>
+ WL_O<133> WL_O<134> WL_O<135> WL_O<136> WL_O<137> WL_O<138> WL_O<139> WL_O<154>
+ WL_O<155> WL_O<156> WL_O<157> WL_O<158> WL_O<159> WL_O<170> WL_O<171> WL_O<172>
+ WL_O<173> WL_O<174> WL_O<175> WL_O<176> WL_O<177> WL_O<178> WL_O<185> WL_O<186>
+ WL_O<187> WL_O<188> WL_O<189> WL_O<190> WL_O<191> WL_O<70> WL_O<71> WL_O<72> WL_O<73>
+ WL_O<90> WL_O<100> WL_O<101> WL_O<109> WL_O<110> WL_O<111> WL_O<112> WL_O<113> WL_O<114>
+ WL_O<115> WL_O<116> WL_O<117> WL_O<118> WL_O<119> WL_O<10> WL_O<11> WL_O<12> WL_O<13>
+ WL_O<14> WL_O<15> WL_O<16> WL_O<17> WL_O<18> WL_O<19> WL_O<26> WL_O<27> WL_O<28>
+ WL_O<29> WL_O<30> WL_O<31> WL_O<32> WL_O<33> WL_O<34> WL_O<35> WL_O<36> WL_O<37>
+ WL_O<38> WL_O<39> WL_O<42> WL_O<43> WL_O<44> WL_O<45> WL_O<46> WL_O<47> WL_O<50>
+ WL_O<51> WL_O<52> WL_O<53> WL_O<54> WL_O<55> WL_O<56> RM_IHPSG13_1P_DEC_LE_tap_5/m3_0_3568#
+ WL_O<91> RM_IHPSG13_1P_DEC_LE_tap_6/m3_0_3568# WL_O<92> RM_IHPSG13_1P_DEC_LE_tap_0/m3_0_3364#
+ WL_O<93> WL_O<94> RM_IHPSG13_1P_DEC_LE_tap_10/m3_0_3364# WL_O<95> RM_IHPSG13_1P_DEC_LE_tap_7/m3_0_3568#
+ RM_IHPSG13_1P_DEC_LE_tap_1/m3_0_3364# RM_IHPSG13_1P_DEC_LE_tap_11/m3_0_3364# RM_IHPSG13_1P_DEC_LE_tap_8/m3_0_3568#
+ RM_IHPSG13_1P_DEC_LE_tap_2/m3_0_3364# RM_IHPSG13_1P_DEC_LE_tap_12/m3_0_3364# RM_IHPSG13_1P_DEC_LE_tap_9/m3_0_3568#
+ RM_IHPSG13_1P_DEC_LE_tap_3/m3_0_3364# WL_O<74> WL_O<75> RM_IHPSG13_1P_DEC_LE_tap_13/m3_0_3364#
+ WL_O<76> WL_O<77> RM_IHPSG13_1P_DEC_LE_tap_4/m3_0_3364# WL_O<96> WL_O<78> WL_O<97>
+ WL_O<48> WL_O<20> RM_IHPSG13_1P_DEC_LE_tap_14/m3_0_3364# WL_O<79> WL_O<98> RM_IHPSG13_1P_DEC_LE_tap_0/m3_0_3568#
+ WL_O<49> WL_O<21> RM_IHPSG13_1P_DEC_LE_tap_5/m3_0_3364# WL_O<99> WL_O<122> WL_O<22>
+ WL_O<64> WL_O<123> RM_IHPSG13_1P_DEC_LE_tap_10/m3_0_3568# WL_O<23> WL_O<65> WL_O<124>
+ WL_O<0> RM_IHPSG13_1P_DEC_LE_tap_1/m3_0_3568# WL_O<24> WL_O<66> WL_O<102> WL_O<1>
+ WL_O<125> RM_IHPSG13_1P_DEC_LE_tap_6/m3_0_3364# WL_O<25> WL_O<80> WL_O<40> WL_O<67>
+ WL_O<103> WL_O<2> WL_O<126> RM_IHPSG13_1P_DEC_LE_tap_11/m3_0_3568# WL_O<81> WL_O<41>
+ WL_O<68> WL_O<104> WL_O<127> WL_O<3> WL_O<140> WL_O<82> RM_IHPSG13_1P_DEC_LE_tap_2/m3_0_3568#
+ WL_O<160> WL_O<69> WL_O<144> WL_O<105> WL_O<4> WL_O<141> WL_O<83> WL_O<58> RM_IHPSG13_1P_DEC_LE_tap_7/m3_0_3364#
+ WL_O<161> WL_O<145> WL_O<5> WL_O<142> WL_O<57> WL_O<84> WL_O<59> WL_O<120> RM_IHPSG13_1P_DEC_LE_tap_12/m3_0_3568#
+ WL_O<162> WL_O<146> WL_O<6> WL_O<143> WL_O<85> WL_O<121> WL_O<60> WL_O<163> WL_O<147>
+ RM_IHPSG13_1P_DEC_LE_tap_3/m3_0_3568# WL_O<7> WL_O<86> WL_O<61> WL_O<224> WL_O<218>
+ WL_O<164> RM_IHPSG13_1P_DEC_LE_tap_8/m3_0_3364# WL_O<148> WL_O<179> WL_O<8> WL_O<87>
+ WL_O<250> WL_O<62> WL_O<225> WL_O<219> WL_O<165> WL_O<208> RM_IHPSG13_1P_DEC_LE_tap_13/m3_0_3568#
+ WL_O<149> WL_O<180> WL_O<9> WL_O<88> WL_O<251> WL_O<63> WL_O<226> WL_O<220> WL_O<166>
+ WL_O<209> WL_O<150> WL_O<181> WL_O<128> RM_IHPSG13_1P_DEC_LE_tap_4/m3_0_3568# WL_O<196>
+ WL_O<89> WL_O<252> WL_O<227> WL_O<221> WL_O<248> WL_O<167> WL_O<210> WL_O<151> WL_O<106>
+ WL_O<182> RM_IHPSG13_1P_DEC_LE_tap_9/m3_0_3364# WL_O<129> WL_O<197> WL_O<253> WL_O<228>
+ WL_O<222> WL_O<249> WL_O<168> WL_O<211> WL_O<152> WL_O<107> WL_O<183> WL_O<130>
+ RM_IHPSG13_1P_DEC_LE_tap_14/m3_0_3568# WL_O<198> WL_O<254> WL_O<229> WL_O<223> WL_O<169>
+ WL_O<212> WL_O<153> WL_O<108> VDD WL_O<184> WL_O<131> WL_O<199> WL_O<255> VSS
XRM_IHPSG13_1P_DEC_LE_l1empty_6 RM_IHPSG13_1P_DEC03_3/CS VDD VSS RM_IHPSG13_1P_DEC_LE_l1empty
XRM_IHPSG13_1P_DEC_LE_l2empty_11 VDD CS_I VSS RM_IHPSG13_1P_DEC_LE_l2empty
XRM_IHPSG13_1P_DEC_LE_l2empty_0 VDD CS_I VSS RM_IHPSG13_1P_DEC_LE_l2empty
XRM_IHPSG13_1P_DEC_LE_l1empty_7 RM_IHPSG13_1P_DEC03_4/CS VDD VSS RM_IHPSG13_1P_DEC_LE_l1empty
XRM_IHPSG13_1P_DEC_LE_l2empty_12 VDD CS_I VSS RM_IHPSG13_1P_DEC_LE_l2empty
XRM_IHPSG13_1P_DEC_LE_l2empty_1 VDD CS_I VSS RM_IHPSG13_1P_DEC_LE_l2empty
XRM_IHPSG13_1P_DEC_LE_l1empty_8 RM_IHPSG13_1P_DEC03_4/CS VDD VSS RM_IHPSG13_1P_DEC_LE_l1empty
XRM_IHPSG13_1P_DEC_LE_l2empty_13 VDD CS_I VSS RM_IHPSG13_1P_DEC_LE_l2empty
XRM_IHPSG13_1P_DEC_LE_l2empty_2 VDD CS_I VSS RM_IHPSG13_1P_DEC_LE_l2empty
XRM_IHPSG13_1P_DEC_LE_l1empty_9 RM_IHPSG13_1P_DEC03_4/CS VDD VSS RM_IHPSG13_1P_DEC_LE_l1empty
XRM_IHPSG13_1P_DEC_LE_l2empty_14 VDD CS_I VSS RM_IHPSG13_1P_DEC_LE_l2empty
XRM_IHPSG13_1P_DEC_LE_l2empty_3 VDD CS_I VSS RM_IHPSG13_1P_DEC_LE_l2empty
XRM_IHPSG13_1P_DEC04_0 RM_IHPSG13_1P_DEC04_1/ECLK_L_BOT RM_IHPSG13_1P_DEC04_1/ECLK_H_BOT
+ RM_IHPSG13_1P_DEC04_6/ECLK_H_TOP RM_IHPSG13_1P_DEC04_6/ECLK_L_TOP ADDR_N_I<3> ADDR_N_I<2>
+ ADDR_N_I<1> ADDR_N_I<0> VDD VSS WL_O<16> WL_O<17> WL_O<18> WL_O<19> WL_O<20> WL_O<21>
+ WL_O<22> WL_O<23> WL_O<24> WL_O<25> WL_O<26> WL_O<27> WL_O<28> WL_O<29> WL_O<30>
+ WL_O<31> RM_IHPSG13_1P_DEC04_0/CS RM_IHPSG13_1P_DEC04_9/m2_1382_0# ADDR_N_I<7> ADDR_N_I<5>
+ ADDR_N_I<6> RM_IHPSG13_1P_DEC04_9/m2_56_840# ADDR_N_I<4> RM_IHPSG13_1P_DEC04_9/m2_158_840#
+ RM_IHPSG13_1P_DEC04
XRM_IHPSG13_1P_DEC_LE_l2empty_4 VDD CS_I VSS RM_IHPSG13_1P_DEC_LE_l2empty
XRM_IHPSG13_1P_DEC04_1 RM_IHPSG13_1P_DEC04_3/ECLK_L_BOT RM_IHPSG13_1P_DEC04_3/ECLK_H_BOT
+ RM_IHPSG13_1P_DEC04_1/ECLK_H_BOT RM_IHPSG13_1P_DEC04_1/ECLK_L_BOT ADDR_N_I<3> ADDR_N_I<2>
+ ADDR_N_I<1> ADDR_N_I<0> VDD VSS WL_O<32> WL_O<33> WL_O<34> WL_O<35> WL_O<36> WL_O<37>
+ WL_O<38> WL_O<39> WL_O<40> WL_O<41> WL_O<42> WL_O<43> WL_O<44> WL_O<45> WL_O<46>
+ WL_O<47> RM_IHPSG13_1P_DEC04_1/CS RM_IHPSG13_1P_DEC04_9/m2_1382_0# ADDR_N_I<7> ADDR_N_I<5>
+ ADDR_N_I<6> RM_IHPSG13_1P_DEC04_9/m2_56_840# ADDR_N_I<4> RM_IHPSG13_1P_DEC04_9/m2_158_840#
+ RM_IHPSG13_1P_DEC04
XRM_IHPSG13_1P_DEC_LE_l2empty_5 VDD CS_I VSS RM_IHPSG13_1P_DEC_LE_l2empty
XRM_IHPSG13_1P_DEC04_2 RM_IHPSG13_1P_DEC04_4/ECLK_L_BOT RM_IHPSG13_1P_DEC04_4/ECLK_H_BOT
+ RM_IHPSG13_1P_DEC04_7/ECLK_H_TOP RM_IHPSG13_1P_DEC04_7/ECLK_L_TOP ADDR_N_I<3> ADDR_N_I<2>
+ ADDR_N_I<1> ADDR_N_I<0> VDD VSS WL_O<96> WL_O<97> WL_O<98> WL_O<99> WL_O<100> WL_O<101>
+ WL_O<102> WL_O<103> WL_O<104> WL_O<105> WL_O<106> WL_O<107> WL_O<108> WL_O<109>
+ WL_O<110> WL_O<111> RM_IHPSG13_1P_DEC04_2/CS RM_IHPSG13_1P_DEC04_9/m2_1382_0# ADDR_N_I<7>
+ ADDR_N_I<5> ADDR_N_I<6> RM_IHPSG13_1P_DEC04_9/m2_56_840# ADDR_N_I<4> RM_IHPSG13_1P_DEC04_9/m2_158_840#
+ RM_IHPSG13_1P_DEC04
XRM_IHPSG13_1P_DEC_LE_l2empty_6 VDD CS_I VSS RM_IHPSG13_1P_DEC_LE_l2empty
XRM_IHPSG13_1P_DEC04_3 RM_IHPSG13_1P_DEC04_5/ECLK_L_BOT RM_IHPSG13_1P_DEC04_5/ECLK_H_BOT
+ RM_IHPSG13_1P_DEC04_3/ECLK_H_BOT RM_IHPSG13_1P_DEC04_3/ECLK_L_BOT ADDR_N_I<3> ADDR_N_I<2>
+ ADDR_N_I<1> ADDR_N_I<0> VDD VSS WL_O<48> WL_O<49> WL_O<50> WL_O<51> WL_O<52> WL_O<53>
+ WL_O<54> WL_O<55> WL_O<56> WL_O<57> WL_O<58> WL_O<59> WL_O<60> WL_O<61> WL_O<62>
+ WL_O<63> RM_IHPSG13_1P_DEC04_3/CS RM_IHPSG13_1P_DEC04_9/m2_1382_0# ADDR_N_I<7> ADDR_N_I<5>
+ ADDR_N_I<6> RM_IHPSG13_1P_DEC04_9/m2_56_840# ADDR_N_I<4> RM_IHPSG13_1P_DEC04_9/m2_158_840#
+ RM_IHPSG13_1P_DEC04
XRM_IHPSG13_1P_DEC02_0 ADDR_N_I<4> ADDR_N_I<5> RM_IHPSG13_1P_DEC03_0/CS VSS VDD RM_IHPSG13_1P_DEC04_1/CS
+ RM_IHPSG13_1P_DEC02
XRM_IHPSG13_1P_DEC_LE_l2empty_7 VDD CS_I VSS RM_IHPSG13_1P_DEC_LE_l2empty
XRM_IHPSG13_1P_DEC02_1 ADDR_N_I<4> ADDR_N_I<5> RM_IHPSG13_1P_DEC03_1/CS VSS VDD RM_IHPSG13_1P_DEC04_2/CS
+ RM_IHPSG13_1P_DEC02
XRM_IHPSG13_1P_DEC04_4 RM_IHPSG13_1P_DEC04_4/ECLK_L_TOP RM_IHPSG13_1P_DEC04_4/ECLK_H_TOP
+ RM_IHPSG13_1P_DEC04_4/ECLK_H_BOT RM_IHPSG13_1P_DEC04_4/ECLK_L_BOT ADDR_N_I<3> ADDR_N_I<2>
+ ADDR_N_I<1> ADDR_N_I<0> VDD VSS WL_O<112> WL_O<113> WL_O<114> WL_O<115> WL_O<116>
+ WL_O<117> WL_O<118> WL_O<119> WL_O<120> WL_O<121> WL_O<122> WL_O<123> WL_O<124>
+ WL_O<125> WL_O<126> WL_O<127> RM_IHPSG13_1P_DEC04_4/CS RM_IHPSG13_1P_DEC04_9/m2_1382_0#
+ ADDR_N_I<7> ADDR_N_I<5> ADDR_N_I<6> RM_IHPSG13_1P_DEC04_9/m2_56_840# ADDR_N_I<4>
+ RM_IHPSG13_1P_DEC04_9/m2_158_840# RM_IHPSG13_1P_DEC04
XRM_IHPSG13_1P_DEC_LE_l1empty_10 RM_IHPSG13_1P_DEC03_3/CS VDD VSS RM_IHPSG13_1P_DEC_LE_l1empty
XRM_IHPSG13_1P_DEC_LE_l2empty_8 VDD CS_I VSS RM_IHPSG13_1P_DEC_LE_l2empty
XRM_IHPSG13_1P_DEC04_5 RM_IHPSG13_1P_DEC04_7/ECLK_L_BOT RM_IHPSG13_1P_DEC04_7/ECLK_H_BOT
+ RM_IHPSG13_1P_DEC04_5/ECLK_H_BOT RM_IHPSG13_1P_DEC04_5/ECLK_L_BOT ADDR_N_I<3> ADDR_N_I<2>
+ ADDR_N_I<1> ADDR_N_I<0> VDD VSS WL_O<64> WL_O<65> WL_O<66> WL_O<67> WL_O<68> WL_O<69>
+ WL_O<70> WL_O<71> WL_O<72> WL_O<73> WL_O<74> WL_O<75> WL_O<76> WL_O<77> WL_O<78>
+ WL_O<79> RM_IHPSG13_1P_DEC04_5/CS RM_IHPSG13_1P_DEC04_9/m2_1382_0# ADDR_N_I<7> ADDR_N_I<5>
+ ADDR_N_I<6> RM_IHPSG13_1P_DEC04_9/m2_56_840# ADDR_N_I<4> RM_IHPSG13_1P_DEC04_9/m2_158_840#
+ RM_IHPSG13_1P_DEC04
XRM_IHPSG13_1P_DEC02_2 ADDR_N_I<6> ADDR_N_I<7> CS_I VSS VDD RM_IHPSG13_1P_DEC03_4/CS
+ RM_IHPSG13_1P_DEC02
XRM_IHPSG13_1P_DEC_LE_l2empty_9 VDD CS_I VSS RM_IHPSG13_1P_DEC_LE_l2empty
XRM_IHPSG13_1P_DEC_LE_l1empty_11 RM_IHPSG13_1P_DEC03_3/CS VDD VSS RM_IHPSG13_1P_DEC_LE_l1empty
XRM_IHPSG13_1P_DEC04_6 RM_IHPSG13_1P_DEC04_6/ECLK_L_TOP RM_IHPSG13_1P_DEC04_6/ECLK_H_TOP
+ ECLK_I RM_IHPSG13_1P_DEC04_6/ECLK_L_BOT ADDR_N_I<3> ADDR_N_I<2> ADDR_N_I<1> ADDR_N_I<0>
+ VDD VSS WL_O<0> WL_O<1> WL_O<2> WL_O<3> WL_O<4> WL_O<5> WL_O<6> WL_O<7> WL_O<8>
+ WL_O<9> WL_O<10> WL_O<11> WL_O<12> WL_O<13> WL_O<14> WL_O<15> RM_IHPSG13_1P_DEC04_6/CS
+ RM_IHPSG13_1P_DEC04_9/m2_1382_0# ADDR_N_I<7> ADDR_N_I<5> ADDR_N_I<6> RM_IHPSG13_1P_DEC04_9/m2_56_840#
+ ADDR_N_I<4> RM_IHPSG13_1P_DEC04_9/m2_158_840# RM_IHPSG13_1P_DEC04
XRM_IHPSG13_1P_DEC02_3 ADDR_N_I<4> ADDR_N_I<5> RM_IHPSG13_1P_DEC03_4/CS VSS VDD RM_IHPSG13_1P_DEC04_10/CS
+ RM_IHPSG13_1P_DEC02
XRM_IHPSG13_1P_DEC00_0 RM_IHPSG13_1P_DEC03_0/CS ADDR_N_I<5> ADDR_N_I<4> RM_IHPSG13_1P_DEC04_6/CS
+ VDD VSS RM_IHPSG13_1P_DEC00
XRM_IHPSG13_1P_DEC04_7 RM_IHPSG13_1P_DEC04_7/ECLK_L_TOP RM_IHPSG13_1P_DEC04_7/ECLK_H_TOP
+ RM_IHPSG13_1P_DEC04_7/ECLK_H_BOT RM_IHPSG13_1P_DEC04_7/ECLK_L_BOT ADDR_N_I<3> ADDR_N_I<2>
+ ADDR_N_I<1> ADDR_N_I<0> VDD VSS WL_O<80> WL_O<81> WL_O<82> WL_O<83> WL_O<84> WL_O<85>
+ WL_O<86> WL_O<87> WL_O<88> WL_O<89> WL_O<90> WL_O<91> WL_O<92> WL_O<93> WL_O<94>
+ WL_O<95> RM_IHPSG13_1P_DEC04_7/CS RM_IHPSG13_1P_DEC04_9/m2_1382_0# ADDR_N_I<7> ADDR_N_I<5>
+ ADDR_N_I<6> RM_IHPSG13_1P_DEC04_9/m2_56_840# ADDR_N_I<4> RM_IHPSG13_1P_DEC04_9/m2_158_840#
+ RM_IHPSG13_1P_DEC04
XRM_IHPSG13_1P_DEC02_4 ADDR_N_I<4> ADDR_N_I<5> RM_IHPSG13_1P_DEC03_3/CS VSS VDD RM_IHPSG13_1P_DEC04_13/CS
+ RM_IHPSG13_1P_DEC02
XRM_IHPSG13_1P_DEC00_1 CS_I ADDR_N_I<7> ADDR_N_I<6> RM_IHPSG13_1P_DEC03_0/CS VDD VSS
+ RM_IHPSG13_1P_DEC00
XRM_IHPSG13_1P_DEC04_8 RM_IHPSG13_1P_DEC04_8/ECLK_L_TOP RM_IHPSG13_1P_DEC04_8/ECLK_H_TOP
+ RM_IHPSG13_1P_DEC04_8/ECLK_H_BOT RM_IHPSG13_1P_DEC04_8/ECLK_L_BOT ADDR_N_I<3> ADDR_N_I<2>
+ ADDR_N_I<1> ADDR_N_I<0> VDD VSS WL_O<240> WL_O<241> WL_O<242> WL_O<243> WL_O<244>
+ WL_O<245> WL_O<246> WL_O<247> WL_O<248> WL_O<249> WL_O<250> WL_O<251> WL_O<252>
+ WL_O<253> WL_O<254> WL_O<255> RM_IHPSG13_1P_DEC04_8/CS RM_IHPSG13_1P_DEC04_9/m2_1382_0#
+ ADDR_N_I<7> ADDR_N_I<5> ADDR_N_I<6> RM_IHPSG13_1P_DEC04_9/m2_56_840# ADDR_N_I<4>
+ RM_IHPSG13_1P_DEC04_9/m2_158_840# RM_IHPSG13_1P_DEC04
XRM_IHPSG13_1P_DEC00_2 RM_IHPSG13_1P_DEC03_1/CS ADDR_N_I<5> ADDR_N_I<4> RM_IHPSG13_1P_DEC04_5/CS
+ VDD VSS RM_IHPSG13_1P_DEC00
XRM_IHPSG13_1P_DEC04_9 RM_IHPSG13_1P_DEC04_9/ECLK_L_TOP RM_IHPSG13_1P_DEC04_9/ECLK_H_TOP
+ RM_IHPSG13_1P_DEC04_9/ECLK_H_BOT RM_IHPSG13_1P_DEC04_9/ECLK_L_BOT ADDR_N_I<3> ADDR_N_I<2>
+ ADDR_N_I<1> ADDR_N_I<0> VDD VSS WL_O<144> WL_O<145> WL_O<146> WL_O<147> WL_O<148>
+ WL_O<149> WL_O<150> WL_O<151> WL_O<152> WL_O<153> WL_O<154> WL_O<155> WL_O<156>
+ WL_O<157> WL_O<158> WL_O<159> RM_IHPSG13_1P_DEC04_9/CS RM_IHPSG13_1P_DEC04_9/m2_1382_0#
+ ADDR_N_I<7> ADDR_N_I<5> ADDR_N_I<6> RM_IHPSG13_1P_DEC04_9/m2_56_840# ADDR_N_I<4>
+ RM_IHPSG13_1P_DEC04_9/m2_158_840# RM_IHPSG13_1P_DEC04
XRM_IHPSG13_1P_DEC00_3 RM_IHPSG13_1P_DEC03_3/CS ADDR_N_I<5> ADDR_N_I<4> RM_IHPSG13_1P_DEC04_12/CS
+ VDD VSS RM_IHPSG13_1P_DEC00
XRM_IHPSG13_1P_DEC00_4 RM_IHPSG13_1P_DEC03_4/CS ADDR_N_I<5> ADDR_N_I<4> RM_IHPSG13_1P_DEC04_15/CS
+ VDD VSS RM_IHPSG13_1P_DEC00
XRM_IHPSG13_1P_DEC04_10 RM_IHPSG13_1P_DEC04_11/ECLK_L_BOT RM_IHPSG13_1P_DEC04_11/ECLK_H_BOT
+ RM_IHPSG13_1P_DEC04_9/ECLK_H_TOP RM_IHPSG13_1P_DEC04_9/ECLK_L_TOP ADDR_N_I<3> ADDR_N_I<2>
+ ADDR_N_I<1> ADDR_N_I<0> VDD VSS WL_O<160> WL_O<161> WL_O<162> WL_O<163> WL_O<164>
+ WL_O<165> WL_O<166> WL_O<167> WL_O<168> WL_O<169> WL_O<170> WL_O<171> WL_O<172>
+ WL_O<173> WL_O<174> WL_O<175> RM_IHPSG13_1P_DEC04_10/CS RM_IHPSG13_1P_DEC04_9/m2_1382_0#
+ ADDR_N_I<7> ADDR_N_I<5> ADDR_N_I<6> RM_IHPSG13_1P_DEC04_9/m2_56_840# ADDR_N_I<4>
+ RM_IHPSG13_1P_DEC04_9/m2_158_840# RM_IHPSG13_1P_DEC04
XRM_IHPSG13_1P_DEC04_11 RM_IHPSG13_1P_DEC04_12/ECLK_L_BOT RM_IHPSG13_1P_DEC04_12/ECLK_H_BOT
+ RM_IHPSG13_1P_DEC04_11/ECLK_H_BOT RM_IHPSG13_1P_DEC04_11/ECLK_L_BOT ADDR_N_I<3>
+ ADDR_N_I<2> ADDR_N_I<1> ADDR_N_I<0> VDD VSS WL_O<176> WL_O<177> WL_O<178> WL_O<179>
+ WL_O<180> WL_O<181> WL_O<182> WL_O<183> WL_O<184> WL_O<185> WL_O<186> WL_O<187>
+ WL_O<188> WL_O<189> WL_O<190> WL_O<191> RM_IHPSG13_1P_DEC04_11/CS RM_IHPSG13_1P_DEC04_9/m2_1382_0#
+ ADDR_N_I<7> ADDR_N_I<5> ADDR_N_I<6> RM_IHPSG13_1P_DEC04_9/m2_56_840# ADDR_N_I<4>
+ RM_IHPSG13_1P_DEC04_9/m2_158_840# RM_IHPSG13_1P_DEC04
XRM_IHPSG13_1P_DEC04_12 RM_IHPSG13_1P_DEC04_14/ECLK_L_BOT RM_IHPSG13_1P_DEC04_14/ECLK_H_BOT
+ RM_IHPSG13_1P_DEC04_12/ECLK_H_BOT RM_IHPSG13_1P_DEC04_12/ECLK_L_BOT ADDR_N_I<3>
+ ADDR_N_I<2> ADDR_N_I<1> ADDR_N_I<0> VDD VSS WL_O<192> WL_O<193> WL_O<194> WL_O<195>
+ WL_O<196> WL_O<197> WL_O<198> WL_O<199> WL_O<200> WL_O<201> WL_O<202> WL_O<203>
+ WL_O<204> WL_O<205> WL_O<206> WL_O<207> RM_IHPSG13_1P_DEC04_12/CS RM_IHPSG13_1P_DEC04_9/m2_1382_0#
+ ADDR_N_I<7> ADDR_N_I<5> ADDR_N_I<6> RM_IHPSG13_1P_DEC04_9/m2_56_840# ADDR_N_I<4>
+ RM_IHPSG13_1P_DEC04_9/m2_158_840# RM_IHPSG13_1P_DEC04
XRM_IHPSG13_1P_DEC04_13 RM_IHPSG13_1P_DEC04_8/ECLK_L_BOT RM_IHPSG13_1P_DEC04_8/ECLK_H_BOT
+ RM_IHPSG13_1P_DEC04_14/ECLK_H_TOP RM_IHPSG13_1P_DEC04_14/ECLK_L_TOP ADDR_N_I<3>
+ ADDR_N_I<2> ADDR_N_I<1> ADDR_N_I<0> VDD VSS WL_O<224> WL_O<225> WL_O<226> WL_O<227>
+ WL_O<228> WL_O<229> WL_O<230> WL_O<231> WL_O<232> WL_O<233> WL_O<234> WL_O<235>
+ WL_O<236> WL_O<237> WL_O<238> WL_O<239> RM_IHPSG13_1P_DEC04_13/CS RM_IHPSG13_1P_DEC04_9/m2_1382_0#
+ ADDR_N_I<7> ADDR_N_I<5> ADDR_N_I<6> RM_IHPSG13_1P_DEC04_9/m2_56_840# ADDR_N_I<4>
+ RM_IHPSG13_1P_DEC04_9/m2_158_840# RM_IHPSG13_1P_DEC04
XRM_IHPSG13_1P_DEC04_14 RM_IHPSG13_1P_DEC04_14/ECLK_L_TOP RM_IHPSG13_1P_DEC04_14/ECLK_H_TOP
+ RM_IHPSG13_1P_DEC04_14/ECLK_H_BOT RM_IHPSG13_1P_DEC04_14/ECLK_L_BOT ADDR_N_I<3>
+ ADDR_N_I<2> ADDR_N_I<1> ADDR_N_I<0> VDD VSS WL_O<208> WL_O<209> WL_O<210> WL_O<211>
+ WL_O<212> WL_O<213> WL_O<214> WL_O<215> WL_O<216> WL_O<217> WL_O<218> WL_O<219>
+ WL_O<220> WL_O<221> WL_O<222> WL_O<223> RM_IHPSG13_1P_DEC04_14/CS RM_IHPSG13_1P_DEC04_9/m2_1382_0#
+ ADDR_N_I<7> ADDR_N_I<5> ADDR_N_I<6> RM_IHPSG13_1P_DEC04_9/m2_56_840# ADDR_N_I<4>
+ RM_IHPSG13_1P_DEC04_9/m2_158_840# RM_IHPSG13_1P_DEC04
XRM_IHPSG13_1P_DEC04_15 RM_IHPSG13_1P_DEC04_9/ECLK_L_BOT RM_IHPSG13_1P_DEC04_9/ECLK_H_BOT
+ RM_IHPSG13_1P_DEC04_4/ECLK_H_TOP RM_IHPSG13_1P_DEC04_4/ECLK_L_TOP ADDR_N_I<3> ADDR_N_I<2>
+ ADDR_N_I<1> ADDR_N_I<0> VDD VSS WL_O<128> WL_O<129> WL_O<130> WL_O<131> WL_O<132>
+ WL_O<133> WL_O<134> WL_O<135> WL_O<136> WL_O<137> WL_O<138> WL_O<139> WL_O<140>
+ WL_O<141> WL_O<142> WL_O<143> RM_IHPSG13_1P_DEC04_15/CS RM_IHPSG13_1P_DEC04_9/m2_1382_0#
+ ADDR_N_I<7> ADDR_N_I<5> ADDR_N_I<6> RM_IHPSG13_1P_DEC04_9/m2_56_840# ADDR_N_I<4>
+ RM_IHPSG13_1P_DEC04_9/m2_158_840# RM_IHPSG13_1P_DEC04
XRM_IHPSG13_1P_DEC03_0 ADDR_N_I<4> ADDR_N_I<5> RM_IHPSG13_1P_DEC03_0/CS VSS VDD RM_IHPSG13_1P_DEC04_3/CS
+ RM_IHPSG13_1P_DEC03
XRM_IHPSG13_1P_DEC03_1 ADDR_N_I<4> ADDR_N_I<5> RM_IHPSG13_1P_DEC03_1/CS VSS VDD RM_IHPSG13_1P_DEC04_4/CS
+ RM_IHPSG13_1P_DEC03
XRM_IHPSG13_1P_DEC03_2 ADDR_N_I<6> ADDR_N_I<7> CS_I VSS VDD RM_IHPSG13_1P_DEC03_3/CS
+ RM_IHPSG13_1P_DEC03
XRM_IHPSG13_1P_DEC03_3 ADDR_N_I<4> ADDR_N_I<5> RM_IHPSG13_1P_DEC03_3/CS VSS VDD RM_IHPSG13_1P_DEC04_8/CS
+ RM_IHPSG13_1P_DEC03
XRM_IHPSG13_1P_DEC01_0 ADDR_N_I<6> ADDR_N_I<7> CS_I VSS VDD RM_IHPSG13_1P_DEC03_1/CS
+ RM_IHPSG13_1P_DEC01
XRM_IHPSG13_1P_DEC03_4 ADDR_N_I<4> ADDR_N_I<5> RM_IHPSG13_1P_DEC03_4/CS VSS VDD RM_IHPSG13_1P_DEC04_11/CS
+ RM_IHPSG13_1P_DEC03
XRM_IHPSG13_1P_DEC01_1 ADDR_N_I<4> ADDR_N_I<5> RM_IHPSG13_1P_DEC03_1/CS VSS VDD RM_IHPSG13_1P_DEC04_7/CS
+ RM_IHPSG13_1P_DEC01
XRM_IHPSG13_1P_DEC01_2 ADDR_N_I<4> ADDR_N_I<5> RM_IHPSG13_1P_DEC03_0/CS VSS VDD RM_IHPSG13_1P_DEC04_0/CS
+ RM_IHPSG13_1P_DEC01
XRM_IHPSG13_1P_DEC01_3 ADDR_N_I<4> ADDR_N_I<5> RM_IHPSG13_1P_DEC03_3/CS VSS VDD RM_IHPSG13_1P_DEC04_14/CS
+ RM_IHPSG13_1P_DEC01
XRM_IHPSG13_1P_DEC_LE_l1empty_0 RM_IHPSG13_1P_DEC03_1/CS VDD VSS RM_IHPSG13_1P_DEC_LE_l1empty
XRM_IHPSG13_1P_DEC01_4 ADDR_N_I<4> ADDR_N_I<5> RM_IHPSG13_1P_DEC03_4/CS VSS VDD RM_IHPSG13_1P_DEC04_9/CS
+ RM_IHPSG13_1P_DEC01
XRM_IHPSG13_1P_DEC_LE_l1empty_1 RM_IHPSG13_1P_DEC03_0/CS VDD VSS RM_IHPSG13_1P_DEC_LE_l1empty
XRM_IHPSG13_1P_DEC_LE_l1empty_2 RM_IHPSG13_1P_DEC03_0/CS VDD VSS RM_IHPSG13_1P_DEC_LE_l1empty
XRM_IHPSG13_1P_DEC_LE_l1empty_3 RM_IHPSG13_1P_DEC03_1/CS VDD VSS RM_IHPSG13_1P_DEC_LE_l1empty
XRM_IHPSG13_1P_DEC_LE_l1empty_4 RM_IHPSG13_1P_DEC03_1/CS VDD VSS RM_IHPSG13_1P_DEC_LE_l1empty
XRM_IHPSG13_1P_DEC_LE_l1empty_5 RM_IHPSG13_1P_DEC03_0/CS VDD VSS RM_IHPSG13_1P_DEC_LE_l1empty
XRM_IHPSG13_1P_DEC_LE_l2empty_10 VDD CS_I VSS RM_IHPSG13_1P_DEC_LE_l2empty
X0 a_293_35226# a_293_35712# VSS VSS sg13_lv_nmos ad=0.1577p pd=1.21u as=0.1577p ps=1.21u w=0.83u l=0.13u
X1 VDD a_905_17086# a_905_17572# VDD sg13_lv_pmos ad=0.3078p pd=2u as=0.3078p ps=2u w=1.62u l=0.385u
X2 a_905_46596# a_905_46110# VDD VDD sg13_lv_pmos ad=0.3078p pd=2u as=0.3078p ps=2u w=1.62u l=0.385u
X3 a_905_42968# a_905_42482# VDD VDD sg13_lv_pmos ad=0.3078p pd=2u as=0.3078p ps=2u w=1.62u l=0.385u
X4 VDD a_293_336# a_293_58# VDD sg13_lv_pmos ad=0.3078p pd=2u as=0.3078p ps=2u w=1.62u l=0.385u
X5 a_293_6202# a_293_6688# VSS VSS sg13_lv_nmos ad=0.1577p pd=1.21u as=0.1577p ps=1.21u w=0.83u l=0.13u
X6 VDD a_905_38854# a_905_39340# VDD sg13_lv_pmos ad=0.5508p pd=3.92u as=0.3078p ps=2u w=1.62u l=0.385u
X7 a_293_6202# a_293_6688# VSS VSS sg13_lv_nmos ad=0.1577p pd=1.21u as=0.2822p ps=2.34u w=0.83u l=0.13u
X8 a_905_53366# a_905_53852# VSS VSS sg13_lv_nmos ad=0.1577p pd=1.21u as=0.1577p ps=1.21u w=0.83u l=0.13u
X9 VSS a_293_35712# a_293_35226# VSS sg13_lv_nmos ad=0.1577p pd=1.21u as=0.1577p ps=1.21u w=0.83u l=0.13u
X10 VSS a_905_24828# a_905_24342# VSS sg13_lv_nmos ad=0.2822p pd=2.34u as=0.1577p ps=1.21u w=0.83u l=0.13u
X11 VSS a_293_10316# a_293_9830# VSS sg13_lv_nmos ad=0.1577p pd=1.21u as=0.1577p ps=1.21u w=0.83u l=0.13u
X12 VSS a_293_46596# a_293_46110# VSS sg13_lv_nmos ad=0.1577p pd=1.21u as=0.1577p ps=1.21u w=0.83u l=0.13u
X13 VSS a_905_24828# a_905_24342# VSS sg13_lv_nmos ad=0.1577p pd=1.21u as=0.1577p ps=1.21u w=0.83u l=0.13u
X14 a_905_336# a_905_58# VSS VSS sg13_lv_nmos ad=0.1577p pd=1.21u as=0.1577p ps=1.21u w=0.83u l=0.13u
X15 VDD a_905_56994# a_905_57480# VDD sg13_lv_pmos ad=0.3078p pd=2u as=0.3078p ps=2u w=1.62u l=0.385u
X16 a_905_42482# a_905_42968# VSS VSS sg13_lv_nmos ad=0.1577p pd=1.21u as=0.1577p ps=1.21u w=0.83u l=0.13u
X17 a_905_9830# a_905_10316# VSS VSS sg13_lv_nmos ad=0.1577p pd=1.21u as=0.1577p ps=1.21u w=0.83u l=0.13u
X18 VDD a_293_24342# a_293_24828# VDD sg13_lv_pmos ad=0.3078p pd=2u as=0.3078p ps=2u w=1.62u l=0.385u
X19 VSS a_293_3060# a_293_2574# VSS sg13_lv_nmos ad=0.1577p pd=1.21u as=0.1577p ps=1.21u w=0.83u l=0.13u
X20 VSS a_293_50224# a_293_49738# VSS sg13_lv_nmos ad=0.1577p pd=1.21u as=0.1577p ps=1.21u w=0.83u l=0.13u
X21 VDD a_905_49738# a_905_50224# VDD sg13_lv_pmos ad=0.3078p pd=2u as=0.3078p ps=2u w=1.62u l=0.385u
X22 a_905_46110# a_905_46596# VSS VSS sg13_lv_nmos ad=0.1577p pd=1.21u as=0.1577p ps=1.21u w=0.83u l=0.13u
X23 a_293_46596# a_293_46110# VDD VDD sg13_lv_pmos ad=0.3078p pd=2u as=0.5508p ps=3.92u w=1.62u l=0.385u
X24 VSS a_293_3060# a_293_2574# VSS sg13_lv_nmos ad=0.1577p pd=1.21u as=0.1577p ps=1.21u w=0.83u l=0.13u
X25 VDD a_293_13458# a_293_13944# VDD sg13_lv_pmos ad=0.3078p pd=2u as=0.3078p ps=2u w=1.62u l=0.385u
X26 a_293_32084# a_293_31598# VDD VDD sg13_lv_pmos ad=0.3078p pd=2u as=0.3078p ps=2u w=1.62u l=0.385u
X27 a_293_27970# a_293_28456# VSS VSS sg13_lv_nmos ad=0.1577p pd=1.21u as=0.1577p ps=1.21u w=0.83u l=0.13u
X28 a_905_49738# a_905_50224# VSS VSS sg13_lv_nmos ad=0.1577p pd=1.21u as=0.1577p ps=1.21u w=0.83u l=0.13u
X29 VSS a_293_28456# a_293_27970# VSS sg13_lv_nmos ad=0.1577p pd=1.21u as=0.1577p ps=1.21u w=0.83u l=0.13u
X30 a_905_32084# a_905_31598# VDD VDD sg13_lv_pmos ad=0.3078p pd=2u as=0.3078p ps=2u w=1.62u l=0.385u
X31 a_293_28456# a_293_27970# VDD VDD sg13_lv_pmos ad=0.3078p pd=2u as=0.3078p ps=2u w=1.62u l=0.385u
X32 a_293_9830# a_293_10316# VSS VSS sg13_lv_nmos ad=0.1577p pd=1.21u as=0.2822p ps=2.34u w=0.83u l=0.13u
X33 a_293_46110# a_293_46596# VSS VSS sg13_lv_nmos ad=0.1577p pd=1.21u as=0.2822p ps=2.34u w=0.83u l=0.13u
X34 VSS a_905_42968# a_905_42482# VSS sg13_lv_nmos ad=0.1577p pd=1.21u as=0.1577p ps=1.21u w=0.83u l=0.13u
X35 a_293_17086# a_293_17572# VSS VSS sg13_lv_nmos ad=0.1577p pd=1.21u as=0.1577p ps=1.21u w=0.83u l=0.13u
X36 a_905_28456# a_905_27970# VDD VDD sg13_lv_pmos ad=0.3078p pd=2u as=0.3078p ps=2u w=1.62u l=0.385u
X37 VDD a_293_53366# a_293_53852# VDD sg13_lv_pmos ad=0.3078p pd=2u as=0.3078p ps=2u w=1.62u l=0.385u
X38 a_293_49738# a_293_50224# VSS VSS sg13_lv_nmos ad=0.1577p pd=1.21u as=0.2822p ps=2.34u w=0.83u l=0.13u
X39 VDD a_905_42482# a_905_42968# VDD sg13_lv_pmos ad=0.3078p pd=2u as=0.3078p ps=2u w=1.62u l=0.385u
X40 VSS a_293_17572# a_293_17086# VSS sg13_lv_nmos ad=0.1577p pd=1.21u as=0.1577p ps=1.21u w=0.83u l=0.13u
X41 a_905_35226# a_905_35712# VSS VSS sg13_lv_nmos ad=0.1577p pd=1.21u as=0.1577p ps=1.21u w=0.83u l=0.13u
X42 a_293_20714# a_293_21200# VSS VSS sg13_lv_nmos ad=0.1577p pd=1.21u as=0.1577p ps=1.21u w=0.83u l=0.13u
X43 a_293_56994# a_293_57480# VSS VSS sg13_lv_nmos ad=0.1577p pd=1.21u as=0.1577p ps=1.21u w=0.83u l=0.13u
X44 a_293_32084# a_293_31598# VDD VDD sg13_lv_pmos ad=0.3078p pd=2u as=0.5508p ps=3.92u w=1.62u l=0.385u
X45 VDD a_293_35226# a_293_35712# VDD sg13_lv_pmos ad=0.3078p pd=2u as=0.3078p ps=2u w=1.62u l=0.385u
X46 a_293_10316# a_293_9830# VDD VDD sg13_lv_pmos ad=0.3078p pd=2u as=0.3078p ps=2u w=1.62u l=0.385u
X47 VDD a_905_24342# a_905_24828# VDD sg13_lv_pmos ad=0.5508p pd=3.92u as=0.3078p ps=2u w=1.62u l=0.385u
X48 VSS a_293_21200# a_293_20714# VSS sg13_lv_nmos ad=0.1577p pd=1.21u as=0.1577p ps=1.21u w=0.83u l=0.13u
X49 a_293_13458# a_293_13944# VSS VSS sg13_lv_nmos ad=0.1577p pd=1.21u as=0.1577p ps=1.21u w=0.83u l=0.13u
X50 a_905_336# a_905_58# VSS VSS sg13_lv_nmos ad=0.1577p pd=1.21u as=0.1577p ps=1.21u w=0.83u l=0.13u
X51 VSS a_905_10316# a_905_9830# VSS sg13_lv_nmos ad=0.2822p pd=2.34u as=0.1577p ps=1.21u w=0.83u l=0.13u
X52 VSS a_293_57480# a_293_56994# VSS sg13_lv_nmos ad=0.1577p pd=1.21u as=0.1577p ps=1.21u w=0.83u l=0.13u
X53 VSS a_905_46596# a_905_46110# VSS sg13_lv_nmos ad=0.2822p pd=2.34u as=0.1577p ps=1.21u w=0.83u l=0.13u
X54 VSS a_293_32084# a_293_31598# VSS sg13_lv_nmos ad=0.1577p pd=1.21u as=0.1577p ps=1.21u w=0.83u l=0.13u
X55 a_293_28456# a_293_27970# VDD VDD sg13_lv_pmos ad=0.3078p pd=2u as=0.5508p ps=3.92u w=1.62u l=0.385u
X56 VSS a_905_10316# a_905_9830# VSS sg13_lv_nmos ad=0.1577p pd=1.21u as=0.1577p ps=1.21u w=0.83u l=0.13u
X57 VSS a_905_46596# a_905_46110# VSS sg13_lv_nmos ad=0.1577p pd=1.21u as=0.1577p ps=1.21u w=0.83u l=0.13u
X58 VSS a_293_58# a_293_336# VSS sg13_lv_nmos ad=0.1577p pd=1.21u as=0.1577p ps=1.21u w=0.83u l=0.13u
X59 VSS a_293_13944# a_293_13458# VSS sg13_lv_nmos ad=0.1577p pd=1.21u as=0.1577p ps=1.21u w=0.83u l=0.13u
X60 VSS a_293_39340# a_293_38854# VSS sg13_lv_nmos ad=0.1577p pd=1.21u as=0.1577p ps=1.21u w=0.83u l=0.13u
X61 a_293_13944# a_293_13458# VDD VDD sg13_lv_pmos ad=0.3078p pd=2u as=0.3078p ps=2u w=1.62u l=0.385u
X62 VSS a_905_50224# a_905_49738# VSS sg13_lv_nmos ad=0.2822p pd=2.34u as=0.1577p ps=1.21u w=0.83u l=0.13u
X63 a_905_31598# a_905_32084# VSS VSS sg13_lv_nmos ad=0.1577p pd=1.21u as=0.1577p ps=1.21u w=0.83u l=0.13u
X64 VDD a_293_46110# a_293_46596# VDD sg13_lv_pmos ad=0.3078p pd=2u as=0.3078p ps=2u w=1.62u l=0.385u
X65 VSS a_293_53852# a_293_53366# VSS sg13_lv_nmos ad=0.1577p pd=1.21u as=0.1577p ps=1.21u w=0.83u l=0.13u
X66 VSS a_905_50224# a_905_49738# VSS sg13_lv_nmos ad=0.1577p pd=1.21u as=0.1577p ps=1.21u w=0.83u l=0.13u
X67 a_293_38854# a_293_39340# VSS VSS sg13_lv_nmos ad=0.1577p pd=1.21u as=0.1577p ps=1.21u w=0.83u l=0.13u
X68 a_905_27970# a_905_28456# VSS VSS sg13_lv_nmos ad=0.1577p pd=1.21u as=0.1577p ps=1.21u w=0.83u l=0.13u
X69 a_905_13944# a_905_13458# VDD VDD sg13_lv_pmos ad=0.3078p pd=2u as=0.3078p ps=2u w=1.62u l=0.385u
X70 VDD a_293_6202# a_293_6688# VDD sg13_lv_pmos ad=0.3078p pd=2u as=0.3078p ps=2u w=1.62u l=0.385u
X71 VDD a_293_6202# a_293_6688# VDD sg13_lv_pmos ad=0.3078p pd=2u as=0.3078p ps=2u w=1.62u l=0.385u
X72 a_905_53366# a_905_53852# VSS VSS sg13_lv_nmos ad=0.1577p pd=1.21u as=0.1577p ps=1.21u w=0.83u l=0.13u
X73 a_905_39340# a_905_38854# VDD VDD sg13_lv_pmos ad=0.3078p pd=2u as=0.3078p ps=2u w=1.62u l=0.385u
X74 a_293_3060# a_293_2574# VDD VDD sg13_lv_pmos ad=0.3078p pd=2u as=0.3078p ps=2u w=1.62u l=0.385u
X75 VDD a_905_53366# a_905_53852# VDD sg13_lv_pmos ad=0.5508p pd=3.92u as=0.3078p ps=2u w=1.62u l=0.385u
X76 a_905_58# a_905_336# VDD VDD sg13_lv_pmos ad=0.3078p pd=2u as=0.3078p ps=2u w=1.62u l=0.385u
X77 a_293_31598# a_293_32084# VSS VSS sg13_lv_nmos ad=0.1577p pd=1.21u as=0.2822p ps=2.34u w=0.83u l=0.13u
X78 VDD a_293_20714# a_293_21200# VDD sg13_lv_pmos ad=0.3078p pd=2u as=0.3078p ps=2u w=1.62u l=0.385u
X79 a_905_17086# a_905_17572# VSS VSS sg13_lv_nmos ad=0.1577p pd=1.21u as=0.1577p ps=1.21u w=0.83u l=0.13u
X80 VSS a_293_6688# a_293_6202# VSS sg13_lv_nmos ad=0.1577p pd=1.21u as=0.1577p ps=1.21u w=0.83u l=0.13u
X81 a_293_13944# a_293_13458# VDD VDD sg13_lv_pmos ad=0.3078p pd=2u as=0.5508p ps=3.92u w=1.62u l=0.385u
X82 a_905_38854# a_905_39340# VSS VSS sg13_lv_nmos ad=0.1577p pd=1.21u as=0.1577p ps=1.21u w=0.83u l=0.13u
X83 VDD a_293_17086# a_293_17572# VDD sg13_lv_pmos ad=0.3078p pd=2u as=0.3078p ps=2u w=1.62u l=0.385u
X84 VSS a_905_3060# a_905_2574# VSS sg13_lv_nmos ad=0.1577p pd=1.21u as=0.1577p ps=1.21u w=0.83u l=0.13u
X85 VSS a_293_6688# a_293_6202# VSS sg13_lv_nmos ad=0.1577p pd=1.21u as=0.1577p ps=1.21u w=0.83u l=0.13u
X86 a_293_35712# a_293_35226# VDD VDD sg13_lv_pmos ad=0.3078p pd=2u as=0.3078p ps=2u w=1.62u l=0.385u
X87 VSS a_293_24828# a_293_24342# VSS sg13_lv_nmos ad=0.1577p pd=1.21u as=0.1577p ps=1.21u w=0.83u l=0.13u
X88 a_905_20714# a_905_21200# VSS VSS sg13_lv_nmos ad=0.1577p pd=1.21u as=0.1577p ps=1.21u w=0.83u l=0.13u
X89 VDD a_905_336# a_905_58# VDD sg13_lv_pmos ad=0.3078p pd=2u as=0.3078p ps=2u w=1.62u l=0.385u
X90 a_905_56994# a_905_57480# VSS VSS sg13_lv_nmos ad=0.1577p pd=1.21u as=0.1577p ps=1.21u w=0.83u l=0.13u
X91 a_293_53366# a_293_53852# VSS VSS sg13_lv_nmos ad=0.1577p pd=1.21u as=0.2822p ps=2.34u w=0.83u l=0.13u
X92 VDD a_293_31598# a_293_32084# VDD sg13_lv_pmos ad=0.3078p pd=2u as=0.3078p ps=2u w=1.62u l=0.385u
X93 a_905_336# a_905_58# VSS VSS sg13_lv_nmos ad=0.1577p pd=1.21u as=0.1577p ps=1.21u w=0.83u l=0.13u
X94 a_293_42482# a_293_42968# VSS VSS sg13_lv_nmos ad=0.1577p pd=1.21u as=0.1577p ps=1.21u w=0.83u l=0.13u
X95 a_905_35712# a_905_35226# VDD VDD sg13_lv_pmos ad=0.3078p pd=2u as=0.3078p ps=2u w=1.62u l=0.385u
X96 a_293_24342# a_293_24828# VSS VSS sg13_lv_nmos ad=0.1577p pd=1.21u as=0.1577p ps=1.21u w=0.83u l=0.13u
X97 a_905_13458# a_905_13944# VSS VSS sg13_lv_nmos ad=0.1577p pd=1.21u as=0.1577p ps=1.21u w=0.83u l=0.13u
X98 VDD a_293_56994# a_293_57480# VDD sg13_lv_pmos ad=0.3078p pd=2u as=0.3078p ps=2u w=1.62u l=0.385u
X99 VDD a_905_46110# a_905_46596# VDD sg13_lv_pmos ad=0.5508p pd=3.92u as=0.3078p ps=2u w=1.62u l=0.385u
X100 VSS a_293_42968# a_293_42482# VSS sg13_lv_nmos ad=0.1577p pd=1.21u as=0.1577p ps=1.21u w=0.83u l=0.13u
X101 VSS a_905_32084# a_905_31598# VSS sg13_lv_nmos ad=0.2822p pd=2.34u as=0.1577p ps=1.21u w=0.83u l=0.13u
X102 VDD a_293_27970# a_293_28456# VDD sg13_lv_pmos ad=0.3078p pd=2u as=0.3078p ps=2u w=1.62u l=0.385u
X103 a_905_2574# a_905_3060# VSS VSS sg13_lv_nmos ad=0.1577p pd=1.21u as=0.1577p ps=1.21u w=0.83u l=0.13u
X104 VSS a_905_32084# a_905_31598# VSS sg13_lv_nmos ad=0.1577p pd=1.21u as=0.1577p ps=1.21u w=0.83u l=0.13u
X105 a_293_2574# a_293_3060# VSS VSS sg13_lv_nmos ad=0.1577p pd=1.21u as=0.1577p ps=1.21u w=0.83u l=0.13u
X106 VDD a_293_49738# a_293_50224# VDD sg13_lv_pmos ad=0.3078p pd=2u as=0.3078p ps=2u w=1.62u l=0.385u
X107 VSS a_905_39340# a_905_38854# VSS sg13_lv_nmos ad=0.1577p pd=1.21u as=0.1577p ps=1.21u w=0.83u l=0.13u
X108 VSS a_293_35712# a_293_35226# VSS sg13_lv_nmos ad=0.1577p pd=1.21u as=0.1577p ps=1.21u w=0.83u l=0.13u
X109 a_905_35226# a_905_35712# VSS VSS sg13_lv_nmos ad=0.1577p pd=1.21u as=0.1577p ps=1.21u w=0.83u l=0.13u
X110 VSS a_905_53852# a_905_53366# VSS sg13_lv_nmos ad=0.2822p pd=2.34u as=0.1577p ps=1.21u w=0.83u l=0.13u
X111 VDD a_905_38854# a_905_39340# VDD sg13_lv_pmos ad=0.3078p pd=2u as=0.3078p ps=2u w=1.62u l=0.385u
X112 a_293_35712# a_293_35226# VDD VDD sg13_lv_pmos ad=0.3078p pd=2u as=0.5508p ps=3.92u w=1.62u l=0.385u
X113 a_905_24342# a_905_24828# VSS VSS sg13_lv_nmos ad=0.1577p pd=1.21u as=0.1577p ps=1.21u w=0.83u l=0.13u
X114 VSS a_905_53852# a_905_53366# VSS sg13_lv_nmos ad=0.1577p pd=1.21u as=0.1577p ps=1.21u w=0.83u l=0.13u
X115 a_293_21200# a_293_20714# VDD VDD sg13_lv_pmos ad=0.3078p pd=2u as=0.3078p ps=2u w=1.62u l=0.385u
X116 a_905_24828# a_905_24342# VDD VDD sg13_lv_pmos ad=0.3078p pd=2u as=0.3078p ps=2u w=1.62u l=0.385u
X117 VSS a_293_58# a_293_336# VSS sg13_lv_nmos ad=0.1577p pd=1.21u as=0.1577p ps=1.21u w=0.83u l=0.13u
X118 VDD a_905_9830# a_905_10316# VDD sg13_lv_pmos ad=0.5508p pd=3.92u as=0.3078p ps=2u w=1.62u l=0.385u
X119 VDD a_905_9830# a_905_10316# VDD sg13_lv_pmos ad=0.3078p pd=2u as=0.3078p ps=2u w=1.62u l=0.385u
X120 a_293_35226# a_293_35712# VSS VSS sg13_lv_nmos ad=0.1577p pd=1.21u as=0.2822p ps=2.34u w=0.83u l=0.13u
X121 a_905_21200# a_905_20714# VDD VDD sg13_lv_pmos ad=0.3078p pd=2u as=0.3078p ps=2u w=1.62u l=0.385u
X122 a_293_17572# a_293_17086# VDD VDD sg13_lv_pmos ad=0.3078p pd=2u as=0.3078p ps=2u w=1.62u l=0.385u
X123 VDD a_293_42482# a_293_42968# VDD sg13_lv_pmos ad=0.3078p pd=2u as=0.3078p ps=2u w=1.62u l=0.385u
X124 VDD a_905_31598# a_905_32084# VDD sg13_lv_pmos ad=0.5508p pd=3.92u as=0.3078p ps=2u w=1.62u l=0.385u
X125 VSS a_293_28456# a_293_27970# VSS sg13_lv_nmos ad=0.1577p pd=1.21u as=0.1577p ps=1.21u w=0.83u l=0.13u
X126 VDD a_293_13458# a_293_13944# VDD sg13_lv_pmos ad=0.3078p pd=2u as=0.3078p ps=2u w=1.62u l=0.385u
X127 a_905_27970# a_905_28456# VSS VSS sg13_lv_nmos ad=0.1577p pd=1.21u as=0.1577p ps=1.21u w=0.83u l=0.13u
X128 VSS a_905_24828# a_905_24342# VSS sg13_lv_nmos ad=0.1577p pd=1.21u as=0.1577p ps=1.21u w=0.83u l=0.13u
X129 a_905_17572# a_905_17086# VDD VDD sg13_lv_pmos ad=0.3078p pd=2u as=0.3078p ps=2u w=1.62u l=0.385u
X130 VDD a_905_336# a_905_58# VDD sg13_lv_pmos ad=0.5508p pd=3.92u as=0.3078p ps=2u w=1.62u l=0.385u
X131 VSS a_293_10316# a_293_9830# VSS sg13_lv_nmos ad=0.1577p pd=1.21u as=0.1577p ps=1.21u w=0.83u l=0.13u
X132 VSS a_293_46596# a_293_46110# VSS sg13_lv_nmos ad=0.1577p pd=1.21u as=0.1577p ps=1.21u w=0.83u l=0.13u
X133 VDD a_905_27970# a_905_28456# VDD sg13_lv_pmos ad=0.5508p pd=3.92u as=0.3078p ps=2u w=1.62u l=0.385u
X134 a_293_57480# a_293_56994# VDD VDD sg13_lv_pmos ad=0.3078p pd=2u as=0.3078p ps=2u w=1.62u l=0.385u
X135 a_905_42482# a_905_42968# VSS VSS sg13_lv_nmos ad=0.1577p pd=1.21u as=0.1577p ps=1.21u w=0.83u l=0.13u
X136 a_293_10316# a_293_9830# VDD VDD sg13_lv_pmos ad=0.3078p pd=2u as=0.5508p ps=3.92u w=1.62u l=0.385u
X137 a_293_21200# a_293_20714# VDD VDD sg13_lv_pmos ad=0.3078p pd=2u as=0.5508p ps=3.92u w=1.62u l=0.385u
X138 VSS a_293_17572# a_293_17086# VSS sg13_lv_nmos ad=0.1577p pd=1.21u as=0.1577p ps=1.21u w=0.83u l=0.13u
X139 VDD a_905_2574# a_905_3060# VDD sg13_lv_pmos ad=0.5508p pd=3.92u as=0.3078p ps=2u w=1.62u l=0.385u
X140 a_905_6688# a_905_6202# VDD VDD sg13_lv_pmos ad=0.3078p pd=2u as=0.3078p ps=2u w=1.62u l=0.385u
X141 a_293_9830# a_293_10316# VSS VSS sg13_lv_nmos ad=0.1577p pd=1.21u as=0.1577p ps=1.21u w=0.83u l=0.13u
X142 a_905_57480# a_905_56994# VDD VDD sg13_lv_pmos ad=0.3078p pd=2u as=0.3078p ps=2u w=1.62u l=0.385u
X143 a_905_53852# a_905_53366# VDD VDD sg13_lv_pmos ad=0.3078p pd=2u as=0.3078p ps=2u w=1.62u l=0.385u
X144 a_293_50224# a_293_49738# VDD VDD sg13_lv_pmos ad=0.3078p pd=2u as=0.3078p ps=2u w=1.62u l=0.385u
X145 a_293_46110# a_293_46596# VSS VSS sg13_lv_nmos ad=0.1577p pd=1.21u as=0.1577p ps=1.21u w=0.83u l=0.13u
X146 VDD a_905_2574# a_905_3060# VDD sg13_lv_pmos ad=0.3078p pd=2u as=0.3078p ps=2u w=1.62u l=0.385u
X147 VSS a_293_50224# a_293_49738# VSS sg13_lv_nmos ad=0.1577p pd=1.21u as=0.1577p ps=1.21u w=0.83u l=0.13u
X148 a_905_17086# a_905_17572# VSS VSS sg13_lv_nmos ad=0.1577p pd=1.21u as=0.1577p ps=1.21u w=0.83u l=0.13u
X149 VSS a_905_35712# a_905_35226# VSS sg13_lv_nmos ad=0.2822p pd=2.34u as=0.1577p ps=1.21u w=0.83u l=0.13u
X150 a_293_27970# a_293_28456# VSS VSS sg13_lv_nmos ad=0.1577p pd=1.21u as=0.2822p ps=2.34u w=0.83u l=0.13u
X151 VSS a_293_21200# a_293_20714# VSS sg13_lv_nmos ad=0.1577p pd=1.21u as=0.1577p ps=1.21u w=0.83u l=0.13u
X152 a_293_17572# a_293_17086# VDD VDD sg13_lv_pmos ad=0.3078p pd=2u as=0.5508p ps=3.92u w=1.62u l=0.385u
X153 a_905_58# a_905_336# VDD VDD sg13_lv_pmos ad=0.3078p pd=2u as=0.3078p ps=2u w=1.62u l=0.385u
X154 VSS a_293_57480# a_293_56994# VSS sg13_lv_nmos ad=0.1577p pd=1.21u as=0.1577p ps=1.21u w=0.83u l=0.13u
X155 a_293_49738# a_293_50224# VSS VSS sg13_lv_nmos ad=0.1577p pd=1.21u as=0.1577p ps=1.21u w=0.83u l=0.13u
X156 a_905_50224# a_905_49738# VDD VDD sg13_lv_pmos ad=0.3078p pd=2u as=0.3078p ps=2u w=1.62u l=0.385u
X157 VSS a_905_35712# a_905_35226# VSS sg13_lv_nmos ad=0.1577p pd=1.21u as=0.1577p ps=1.21u w=0.83u l=0.13u
X158 a_905_6688# a_905_6202# VDD VDD sg13_lv_pmos ad=0.3078p pd=2u as=0.3078p ps=2u w=1.62u l=0.385u
X159 VSS a_293_13944# a_293_13458# VSS sg13_lv_nmos ad=0.1577p pd=1.21u as=0.1577p ps=1.21u w=0.83u l=0.13u
X160 VSS a_905_6688# a_905_6202# VSS sg13_lv_nmos ad=0.1577p pd=1.21u as=0.1577p ps=1.21u w=0.83u l=0.13u
X161 VDD a_293_35226# a_293_35712# VDD sg13_lv_pmos ad=0.3078p pd=2u as=0.3078p ps=2u w=1.62u l=0.385u
X162 VDD a_905_24342# a_905_24828# VDD sg13_lv_pmos ad=0.3078p pd=2u as=0.3078p ps=2u w=1.62u l=0.385u
X163 a_905_20714# a_905_21200# VSS VSS sg13_lv_nmos ad=0.1577p pd=1.21u as=0.1577p ps=1.21u w=0.83u l=0.13u
X164 a_905_56994# a_905_57480# VSS VSS sg13_lv_nmos ad=0.1577p pd=1.21u as=0.1577p ps=1.21u w=0.83u l=0.13u
X165 a_293_57480# a_293_56994# VDD VDD sg13_lv_pmos ad=0.3078p pd=2u as=0.5508p ps=3.92u w=1.62u l=0.385u
X166 VSS a_905_58# a_905_336# VSS sg13_lv_nmos ad=0.1577p pd=1.21u as=0.1577p ps=1.21u w=0.83u l=0.13u
X167 a_293_3060# a_293_2574# VDD VDD sg13_lv_pmos ad=0.3078p pd=2u as=0.5508p ps=3.92u w=1.62u l=0.385u
X168 a_905_9830# a_905_10316# VSS VSS sg13_lv_nmos ad=0.1577p pd=1.21u as=0.1577p ps=1.21u w=0.83u l=0.13u
X169 a_905_46110# a_905_46596# VSS VSS sg13_lv_nmos ad=0.1577p pd=1.21u as=0.1577p ps=1.21u w=0.83u l=0.13u
X170 a_293_17086# a_293_17572# VSS VSS sg13_lv_nmos ad=0.1577p pd=1.21u as=0.2822p ps=2.34u w=0.83u l=0.13u
X171 a_905_13458# a_905_13944# VSS VSS sg13_lv_nmos ad=0.1577p pd=1.21u as=0.1577p ps=1.21u w=0.83u l=0.13u
X172 a_293_42968# a_293_42482# VDD VDD sg13_lv_pmos ad=0.3078p pd=2u as=0.3078p ps=2u w=1.62u l=0.385u
X173 a_293_38854# a_293_39340# VSS VSS sg13_lv_nmos ad=0.1577p pd=1.21u as=0.1577p ps=1.21u w=0.83u l=0.13u
X174 a_905_6202# a_905_6688# VSS VSS sg13_lv_nmos ad=0.1577p pd=1.21u as=0.1577p ps=1.21u w=0.83u l=0.13u
X175 VDD a_905_13458# a_905_13944# VDD sg13_lv_pmos ad=0.5508p pd=3.92u as=0.3078p ps=2u w=1.62u l=0.385u
X176 a_293_50224# a_293_49738# VDD VDD sg13_lv_pmos ad=0.3078p pd=2u as=0.5508p ps=3.92u w=1.62u l=0.385u
X177 a_905_46596# a_905_46110# VDD VDD sg13_lv_pmos ad=0.3078p pd=2u as=0.3078p ps=2u w=1.62u l=0.385u
X178 a_293_336# a_293_58# VSS VSS sg13_lv_nmos ad=0.1577p pd=1.21u as=0.2822p ps=2.34u w=0.83u l=0.13u
X179 a_905_49738# a_905_50224# VSS VSS sg13_lv_nmos ad=0.1577p pd=1.21u as=0.1577p ps=1.21u w=0.83u l=0.13u
X180 a_905_2574# a_905_3060# VSS VSS sg13_lv_nmos ad=0.1577p pd=1.21u as=0.1577p ps=1.21u w=0.83u l=0.13u
X181 VSS a_905_3060# a_905_2574# VSS sg13_lv_nmos ad=0.1577p pd=1.21u as=0.1577p ps=1.21u w=0.83u l=0.13u
X182 a_293_6202# a_293_6688# VSS VSS sg13_lv_nmos ad=0.1577p pd=1.21u as=0.1577p ps=1.21u w=0.83u l=0.13u
X183 a_905_42968# a_905_42482# VDD VDD sg13_lv_pmos ad=0.3078p pd=2u as=0.3078p ps=2u w=1.62u l=0.385u
X184 VSS a_293_39340# a_293_38854# VSS sg13_lv_nmos ad=0.1577p pd=1.21u as=0.1577p ps=1.21u w=0.83u l=0.13u
X185 VSS a_905_28456# a_905_27970# VSS sg13_lv_nmos ad=0.2822p pd=2.34u as=0.1577p ps=1.21u w=0.83u l=0.13u
X186 a_293_20714# a_293_21200# VSS VSS sg13_lv_nmos ad=0.1577p pd=1.21u as=0.2822p ps=2.34u w=0.83u l=0.13u
X187 VSS a_293_58# a_293_336# VSS sg13_lv_nmos ad=0.1577p pd=1.21u as=0.1577p ps=1.21u w=0.83u l=0.13u
X188 a_293_56994# a_293_57480# VSS VSS sg13_lv_nmos ad=0.1577p pd=1.21u as=0.2822p ps=2.34u w=0.83u l=0.13u
X189 VSS a_905_28456# a_905_27970# VSS sg13_lv_nmos ad=0.1577p pd=1.21u as=0.1577p ps=1.21u w=0.83u l=0.13u
X190 a_293_13458# a_293_13944# VSS VSS sg13_lv_nmos ad=0.1577p pd=1.21u as=0.2822p ps=2.34u w=0.83u l=0.13u
X191 VSS a_905_10316# a_905_9830# VSS sg13_lv_nmos ad=0.1577p pd=1.21u as=0.1577p ps=1.21u w=0.83u l=0.13u
X192 VDD a_905_53366# a_905_53852# VDD sg13_lv_pmos ad=0.3078p pd=2u as=0.3078p ps=2u w=1.62u l=0.385u
X193 VSS a_905_46596# a_905_46110# VSS sg13_lv_nmos ad=0.1577p pd=1.21u as=0.1577p ps=1.21u w=0.83u l=0.13u
X194 VSS a_293_32084# a_293_31598# VSS sg13_lv_nmos ad=0.1577p pd=1.21u as=0.1577p ps=1.21u w=0.83u l=0.13u
X195 VSS a_293_3060# a_293_2574# VSS sg13_lv_nmos ad=0.1577p pd=1.21u as=0.1577p ps=1.21u w=0.83u l=0.13u
X196 VDD a_293_20714# a_293_21200# VDD sg13_lv_pmos ad=0.3078p pd=2u as=0.3078p ps=2u w=1.62u l=0.385u
X197 VSS a_905_17572# a_905_17086# VSS sg13_lv_nmos ad=0.2822p pd=2.34u as=0.1577p ps=1.21u w=0.83u l=0.13u
X198 a_293_42968# a_293_42482# VDD VDD sg13_lv_pmos ad=0.3078p pd=2u as=0.5508p ps=3.92u w=1.62u l=0.385u
X199 a_293_31598# a_293_32084# VSS VSS sg13_lv_nmos ad=0.1577p pd=1.21u as=0.1577p ps=1.21u w=0.83u l=0.13u
X200 VSS a_905_17572# a_905_17086# VSS sg13_lv_nmos ad=0.1577p pd=1.21u as=0.1577p ps=1.21u w=0.83u l=0.13u
X201 VSS a_905_50224# a_905_49738# VSS sg13_lv_nmos ad=0.1577p pd=1.21u as=0.1577p ps=1.21u w=0.83u l=0.13u
X202 VSS a_293_53852# a_293_53366# VSS sg13_lv_nmos ad=0.1577p pd=1.21u as=0.1577p ps=1.21u w=0.83u l=0.13u
X203 VDD a_905_35226# a_905_35712# VDD sg13_lv_pmos ad=0.5508p pd=3.92u as=0.3078p ps=2u w=1.62u l=0.385u
X204 a_293_24342# a_293_24828# VSS VSS sg13_lv_nmos ad=0.1577p pd=1.21u as=0.1577p ps=1.21u w=0.83u l=0.13u
X205 VSS a_905_21200# a_905_20714# VSS sg13_lv_nmos ad=0.2822p pd=2.34u as=0.1577p ps=1.21u w=0.83u l=0.13u
X206 VDD a_293_17086# a_293_17572# VDD sg13_lv_pmos ad=0.3078p pd=2u as=0.3078p ps=2u w=1.62u l=0.385u
X207 VSS a_905_57480# a_905_56994# VSS sg13_lv_nmos ad=0.2822p pd=2.34u as=0.1577p ps=1.21u w=0.83u l=0.13u
X208 VSS a_293_42968# a_293_42482# VSS sg13_lv_nmos ad=0.1577p pd=1.21u as=0.1577p ps=1.21u w=0.83u l=0.13u
X209 a_905_32084# a_905_31598# VDD VDD sg13_lv_pmos ad=0.3078p pd=2u as=0.3078p ps=2u w=1.62u l=0.385u
X210 VSS a_905_21200# a_905_20714# VSS sg13_lv_nmos ad=0.1577p pd=1.21u as=0.1577p ps=1.21u w=0.83u l=0.13u
X211 VSS a_905_57480# a_905_56994# VSS sg13_lv_nmos ad=0.1577p pd=1.21u as=0.1577p ps=1.21u w=0.83u l=0.13u
X212 VDD a_293_38854# a_293_39340# VDD sg13_lv_pmos ad=0.3078p pd=2u as=0.3078p ps=2u w=1.62u l=0.385u
X213 VSS a_293_24828# a_293_24342# VSS sg13_lv_nmos ad=0.1577p pd=1.21u as=0.1577p ps=1.21u w=0.83u l=0.13u
X214 VSS a_905_13944# a_905_13458# VSS sg13_lv_nmos ad=0.2822p pd=2.34u as=0.1577p ps=1.21u w=0.83u l=0.13u
X215 a_293_53366# a_293_53852# VSS VSS sg13_lv_nmos ad=0.1577p pd=1.21u as=0.1577p ps=1.21u w=0.83u l=0.13u
X216 VSS a_905_58# a_905_336# VSS sg13_lv_nmos ad=0.1577p pd=1.21u as=0.1577p ps=1.21u w=0.83u l=0.13u
X217 a_905_42482# a_905_42968# VSS VSS sg13_lv_nmos ad=0.1577p pd=1.21u as=0.1577p ps=1.21u w=0.83u l=0.13u
X218 a_905_28456# a_905_27970# VDD VDD sg13_lv_pmos ad=0.3078p pd=2u as=0.3078p ps=2u w=1.62u l=0.385u
X219 VSS a_905_13944# a_905_13458# VSS sg13_lv_nmos ad=0.1577p pd=1.21u as=0.1577p ps=1.21u w=0.83u l=0.13u
X220 VDD a_293_56994# a_293_57480# VDD sg13_lv_pmos ad=0.3078p pd=2u as=0.3078p ps=2u w=1.62u l=0.385u
X221 VDD a_905_46110# a_905_46596# VDD sg13_lv_pmos ad=0.3078p pd=2u as=0.3078p ps=2u w=1.62u l=0.385u
X222 a_905_31598# a_905_32084# VSS VSS sg13_lv_nmos ad=0.1577p pd=1.21u as=0.1577p ps=1.21u w=0.83u l=0.13u
X223 a_905_38854# a_905_39340# VSS VSS sg13_lv_nmos ad=0.1577p pd=1.21u as=0.1577p ps=1.21u w=0.83u l=0.13u
X224 VDD a_293_49738# a_293_50224# VDD sg13_lv_pmos ad=0.3078p pd=2u as=0.3078p ps=2u w=1.62u l=0.385u
X225 VDD a_293_9830# a_293_10316# VDD sg13_lv_pmos ad=0.3078p pd=2u as=0.3078p ps=2u w=1.62u l=0.385u
X226 a_905_53366# a_905_53852# VSS VSS sg13_lv_nmos ad=0.1577p pd=1.21u as=0.1577p ps=1.21u w=0.83u l=0.13u
X227 a_293_42482# a_293_42968# VSS VSS sg13_lv_nmos ad=0.1577p pd=1.21u as=0.2822p ps=2.34u w=0.83u l=0.13u
X228 VDD a_905_20714# a_905_21200# VDD sg13_lv_pmos ad=0.5508p pd=3.92u as=0.3078p ps=2u w=1.62u l=0.385u
X229 VDD a_293_9830# a_293_10316# VDD sg13_lv_pmos ad=0.3078p pd=2u as=0.3078p ps=2u w=1.62u l=0.385u
X230 a_293_58# a_293_336# VDD VDD sg13_lv_pmos ad=0.3078p pd=2u as=0.5508p ps=3.92u w=1.62u l=0.385u
X231 VSS a_905_32084# a_905_31598# VSS sg13_lv_nmos ad=0.1577p pd=1.21u as=0.1577p ps=1.21u w=0.83u l=0.13u
X232 VDD a_905_17086# a_905_17572# VDD sg13_lv_pmos ad=0.5508p pd=3.92u as=0.3078p ps=2u w=1.62u l=0.385u
X233 a_293_336# a_293_58# VSS VSS sg13_lv_nmos ad=0.1577p pd=1.21u as=0.1577p ps=1.21u w=0.83u l=0.13u
X234 VSS a_293_35712# a_293_35226# VSS sg13_lv_nmos ad=0.1577p pd=1.21u as=0.1577p ps=1.21u w=0.83u l=0.13u
X235 a_905_13944# a_905_13458# VDD VDD sg13_lv_pmos ad=0.3078p pd=2u as=0.3078p ps=2u w=1.62u l=0.385u
X236 VDD a_293_42482# a_293_42968# VDD sg13_lv_pmos ad=0.3078p pd=2u as=0.3078p ps=2u w=1.62u l=0.385u
X237 VDD a_905_31598# a_905_32084# VDD sg13_lv_pmos ad=0.3078p pd=2u as=0.3078p ps=2u w=1.62u l=0.385u
X238 VSS a_905_53852# a_905_53366# VSS sg13_lv_nmos ad=0.1577p pd=1.21u as=0.1577p ps=1.21u w=0.83u l=0.13u
X239 a_293_39340# a_293_38854# VDD VDD sg13_lv_pmos ad=0.3078p pd=2u as=0.3078p ps=2u w=1.62u l=0.385u
X240 a_293_35226# a_293_35712# VSS VSS sg13_lv_nmos ad=0.1577p pd=1.21u as=0.1577p ps=1.21u w=0.83u l=0.13u
X241 a_905_24342# a_905_24828# VSS VSS sg13_lv_nmos ad=0.1577p pd=1.21u as=0.1577p ps=1.21u w=0.83u l=0.13u
X242 a_293_6688# a_293_6202# VDD VDD sg13_lv_pmos ad=0.3078p pd=2u as=0.3078p ps=2u w=1.62u l=0.385u
X243 a_905_6202# a_905_6688# VSS VSS sg13_lv_nmos ad=0.1577p pd=1.21u as=0.1577p ps=1.21u w=0.83u l=0.13u
X244 VSS a_905_6688# a_905_6202# VSS sg13_lv_nmos ad=0.1577p pd=1.21u as=0.1577p ps=1.21u w=0.83u l=0.13u
X245 a_293_9830# a_293_10316# VSS VSS sg13_lv_nmos ad=0.1577p pd=1.21u as=0.1577p ps=1.21u w=0.83u l=0.13u
X246 VDD a_905_56994# a_905_57480# VDD sg13_lv_pmos ad=0.5508p pd=3.92u as=0.3078p ps=2u w=1.62u l=0.385u
X247 a_293_46110# a_293_46596# VSS VSS sg13_lv_nmos ad=0.1577p pd=1.21u as=0.1577p ps=1.21u w=0.83u l=0.13u
X248 VSS a_905_42968# a_905_42482# VSS sg13_lv_nmos ad=0.2822p pd=2.34u as=0.1577p ps=1.21u w=0.83u l=0.13u
X249 VDD a_293_2574# a_293_3060# VDD sg13_lv_pmos ad=0.3078p pd=2u as=0.3078p ps=2u w=1.62u l=0.385u
X250 VDD a_293_2574# a_293_3060# VDD sg13_lv_pmos ad=0.3078p pd=2u as=0.3078p ps=2u w=1.62u l=0.385u
X251 a_905_39340# a_905_38854# VDD VDD sg13_lv_pmos ad=0.3078p pd=2u as=0.3078p ps=2u w=1.62u l=0.385u
X252 VDD a_905_27970# a_905_28456# VDD sg13_lv_pmos ad=0.3078p pd=2u as=0.3078p ps=2u w=1.62u l=0.385u
X253 VDD a_293_24342# a_293_24828# VDD sg13_lv_pmos ad=0.3078p pd=2u as=0.3078p ps=2u w=1.62u l=0.385u
X254 VSS a_905_42968# a_905_42482# VSS sg13_lv_nmos ad=0.1577p pd=1.21u as=0.1577p ps=1.21u w=0.83u l=0.13u
X255 VSS a_293_10316# a_293_9830# VSS sg13_lv_nmos ad=0.1577p pd=1.21u as=0.1577p ps=1.21u w=0.83u l=0.13u
X256 VDD a_905_49738# a_905_50224# VDD sg13_lv_pmos ad=0.5508p pd=3.92u as=0.3078p ps=2u w=1.62u l=0.385u
X257 VSS a_293_46596# a_293_46110# VSS sg13_lv_nmos ad=0.1577p pd=1.21u as=0.1577p ps=1.21u w=0.83u l=0.13u
X258 a_293_49738# a_293_50224# VSS VSS sg13_lv_nmos ad=0.1577p pd=1.21u as=0.1577p ps=1.21u w=0.83u l=0.13u
X259 VSS a_905_3060# a_905_2574# VSS sg13_lv_nmos ad=0.2822p pd=2.34u as=0.1577p ps=1.21u w=0.83u l=0.13u
X260 VSS a_293_6688# a_293_6202# VSS sg13_lv_nmos ad=0.1577p pd=1.21u as=0.1577p ps=1.21u w=0.83u l=0.13u
X261 VSS a_293_28456# a_293_27970# VSS sg13_lv_nmos ad=0.1577p pd=1.21u as=0.1577p ps=1.21u w=0.83u l=0.13u
X262 a_905_2574# a_905_3060# VSS VSS sg13_lv_nmos ad=0.1577p pd=1.21u as=0.1577p ps=1.21u w=0.83u l=0.13u
X263 VSS a_293_50224# a_293_49738# VSS sg13_lv_nmos ad=0.1577p pd=1.21u as=0.1577p ps=1.21u w=0.83u l=0.13u
X264 a_905_35226# a_905_35712# VSS VSS sg13_lv_nmos ad=0.1577p pd=1.21u as=0.1577p ps=1.21u w=0.83u l=0.13u
X265 a_293_39340# a_293_38854# VDD VDD sg13_lv_pmos ad=0.3078p pd=2u as=0.5508p ps=3.92u w=1.62u l=0.385u
X266 a_905_35712# a_905_35226# VDD VDD sg13_lv_pmos ad=0.3078p pd=2u as=0.3078p ps=2u w=1.62u l=0.385u
X267 a_293_27970# a_293_28456# VSS VSS sg13_lv_nmos ad=0.1577p pd=1.21u as=0.1577p ps=1.21u w=0.83u l=0.13u
X268 VSS a_293_17572# a_293_17086# VSS sg13_lv_nmos ad=0.1577p pd=1.21u as=0.1577p ps=1.21u w=0.83u l=0.13u
X269 VDD a_293_53366# a_293_53852# VDD sg13_lv_pmos ad=0.3078p pd=2u as=0.3078p ps=2u w=1.62u l=0.385u
X270 VDD a_905_42482# a_905_42968# VDD sg13_lv_pmos ad=0.5508p pd=3.92u as=0.3078p ps=2u w=1.62u l=0.385u
X271 VSS a_293_39340# a_293_38854# VSS sg13_lv_nmos ad=0.1577p pd=1.21u as=0.1577p ps=1.21u w=0.83u l=0.13u
X272 a_293_2574# a_293_3060# VSS VSS sg13_lv_nmos ad=0.1577p pd=1.21u as=0.1577p ps=1.21u w=0.83u l=0.13u
X273 VDD a_905_13458# a_905_13944# VDD sg13_lv_pmos ad=0.3078p pd=2u as=0.3078p ps=2u w=1.62u l=0.385u
X274 a_293_2574# a_293_3060# VSS VSS sg13_lv_nmos ad=0.1577p pd=1.21u as=0.2822p ps=2.34u w=0.83u l=0.13u
X275 a_905_38854# a_905_39340# VSS VSS sg13_lv_nmos ad=0.1577p pd=1.21u as=0.1577p ps=1.21u w=0.83u l=0.13u
X276 VSS a_905_35712# a_905_35226# VSS sg13_lv_nmos ad=0.1577p pd=1.21u as=0.1577p ps=1.21u w=0.83u l=0.13u
X277 VSS a_293_21200# a_293_20714# VSS sg13_lv_nmos ad=0.1577p pd=1.21u as=0.1577p ps=1.21u w=0.83u l=0.13u
X278 a_293_17086# a_293_17572# VSS VSS sg13_lv_nmos ad=0.1577p pd=1.21u as=0.1577p ps=1.21u w=0.83u l=0.13u
X279 a_905_27970# a_905_28456# VSS VSS sg13_lv_nmos ad=0.1577p pd=1.21u as=0.1577p ps=1.21u w=0.83u l=0.13u
X280 VSS a_905_58# a_905_336# VSS sg13_lv_nmos ad=0.2822p pd=2.34u as=0.1577p ps=1.21u w=0.83u l=0.13u
X281 VSS a_293_57480# a_293_56994# VSS sg13_lv_nmos ad=0.1577p pd=1.21u as=0.1577p ps=1.21u w=0.83u l=0.13u
X282 a_293_58# a_293_336# VDD VDD sg13_lv_pmos ad=0.3078p pd=2u as=0.3078p ps=2u w=1.62u l=0.385u
X283 a_293_24828# a_293_24342# VDD VDD sg13_lv_pmos ad=0.3078p pd=2u as=0.3078p ps=2u w=1.62u l=0.385u
X284 a_293_20714# a_293_21200# VSS VSS sg13_lv_nmos ad=0.1577p pd=1.21u as=0.1577p ps=1.21u w=0.83u l=0.13u
X285 VSS a_293_13944# a_293_13458# VSS sg13_lv_nmos ad=0.1577p pd=1.21u as=0.1577p ps=1.21u w=0.83u l=0.13u
X286 a_293_336# a_293_58# VSS VSS sg13_lv_nmos ad=0.1577p pd=1.21u as=0.1577p ps=1.21u w=0.83u l=0.13u
X287 a_905_9830# a_905_10316# VSS VSS sg13_lv_nmos ad=0.1577p pd=1.21u as=0.1577p ps=1.21u w=0.83u l=0.13u
X288 a_293_56994# a_293_57480# VSS VSS sg13_lv_nmos ad=0.1577p pd=1.21u as=0.1577p ps=1.21u w=0.83u l=0.13u
X289 a_905_46110# a_905_46596# VSS VSS sg13_lv_nmos ad=0.1577p pd=1.21u as=0.1577p ps=1.21u w=0.83u l=0.13u
X290 a_293_31598# a_293_32084# VSS VSS sg13_lv_nmos ad=0.1577p pd=1.21u as=0.1577p ps=1.21u w=0.83u l=0.13u
X291 a_905_10316# a_905_9830# VDD VDD sg13_lv_pmos ad=0.3078p pd=2u as=0.3078p ps=2u w=1.62u l=0.385u
X292 a_293_13458# a_293_13944# VSS VSS sg13_lv_nmos ad=0.1577p pd=1.21u as=0.1577p ps=1.21u w=0.83u l=0.13u
X293 a_293_38854# a_293_39340# VSS VSS sg13_lv_nmos ad=0.1577p pd=1.21u as=0.2822p ps=2.34u w=0.83u l=0.13u
X294 a_905_24828# a_905_24342# VDD VDD sg13_lv_pmos ad=0.3078p pd=2u as=0.3078p ps=2u w=1.62u l=0.385u
X295 a_905_21200# a_905_20714# VDD VDD sg13_lv_pmos ad=0.3078p pd=2u as=0.3078p ps=2u w=1.62u l=0.385u
X296 a_905_17086# a_905_17572# VSS VSS sg13_lv_nmos ad=0.1577p pd=1.21u as=0.1577p ps=1.21u w=0.83u l=0.13u
X297 VDD a_293_46110# a_293_46596# VDD sg13_lv_pmos ad=0.3078p pd=2u as=0.3078p ps=2u w=1.62u l=0.385u
X298 VSS a_293_32084# a_293_31598# VSS sg13_lv_nmos ad=0.1577p pd=1.21u as=0.1577p ps=1.21u w=0.83u l=0.13u
X299 VDD a_293_336# a_293_58# VDD sg13_lv_pmos ad=0.3078p pd=2u as=0.3078p ps=2u w=1.62u l=0.385u
X300 a_905_49738# a_905_50224# VSS VSS sg13_lv_nmos ad=0.1577p pd=1.21u as=0.1577p ps=1.21u w=0.83u l=0.13u
X301 a_293_53366# a_293_53852# VSS VSS sg13_lv_nmos ad=0.1577p pd=1.21u as=0.1577p ps=1.21u w=0.83u l=0.13u
X302 VSS a_905_28456# a_905_27970# VSS sg13_lv_nmos ad=0.1577p pd=1.21u as=0.1577p ps=1.21u w=0.83u l=0.13u
X303 VSS a_293_24828# a_293_24342# VSS sg13_lv_nmos ad=0.1577p pd=1.21u as=0.1577p ps=1.21u w=0.83u l=0.13u
X304 a_905_17572# a_905_17086# VDD VDD sg13_lv_pmos ad=0.3078p pd=2u as=0.3078p ps=2u w=1.62u l=0.385u
X305 a_905_10316# a_905_9830# VDD VDD sg13_lv_pmos ad=0.3078p pd=2u as=0.3078p ps=2u w=1.62u l=0.385u
X306 VDD a_905_35226# a_905_35712# VDD sg13_lv_pmos ad=0.3078p pd=2u as=0.3078p ps=2u w=1.62u l=0.385u
X307 a_905_20714# a_905_21200# VSS VSS sg13_lv_nmos ad=0.1577p pd=1.21u as=0.1577p ps=1.21u w=0.83u l=0.13u
X308 a_905_56994# a_905_57480# VSS VSS sg13_lv_nmos ad=0.1577p pd=1.21u as=0.1577p ps=1.21u w=0.83u l=0.13u
X309 a_905_24342# a_905_24828# VSS VSS sg13_lv_nmos ad=0.1577p pd=1.21u as=0.1577p ps=1.21u w=0.83u l=0.13u
X310 VSS a_293_53852# a_293_53366# VSS sg13_lv_nmos ad=0.1577p pd=1.21u as=0.1577p ps=1.21u w=0.83u l=0.13u
X311 VDD a_293_38854# a_293_39340# VDD sg13_lv_pmos ad=0.3078p pd=2u as=0.3078p ps=2u w=1.62u l=0.385u
X312 a_293_24828# a_293_24342# VDD VDD sg13_lv_pmos ad=0.3078p pd=2u as=0.5508p ps=3.92u w=1.62u l=0.385u
X313 VDD a_905_6202# a_905_6688# VDD sg13_lv_pmos ad=0.5508p pd=3.92u as=0.3078p ps=2u w=1.62u l=0.385u
X314 a_905_13458# a_905_13944# VSS VSS sg13_lv_nmos ad=0.1577p pd=1.21u as=0.1577p ps=1.21u w=0.83u l=0.13u
X315 a_905_57480# a_905_56994# VDD VDD sg13_lv_pmos ad=0.3078p pd=2u as=0.3078p ps=2u w=1.62u l=0.385u
X316 a_293_53852# a_293_53366# VDD VDD sg13_lv_pmos ad=0.3078p pd=2u as=0.3078p ps=2u w=1.62u l=0.385u
X317 VDD a_905_6202# a_905_6688# VDD sg13_lv_pmos ad=0.3078p pd=2u as=0.3078p ps=2u w=1.62u l=0.385u
X318 VSS a_905_17572# a_905_17086# VSS sg13_lv_nmos ad=0.1577p pd=1.21u as=0.1577p ps=1.21u w=0.83u l=0.13u
X319 a_905_3060# a_905_2574# VDD VDD sg13_lv_pmos ad=0.3078p pd=2u as=0.3078p ps=2u w=1.62u l=0.385u
X320 a_905_53852# a_905_53366# VDD VDD sg13_lv_pmos ad=0.3078p pd=2u as=0.3078p ps=2u w=1.62u l=0.385u
X321 VSS a_905_39340# a_905_38854# VSS sg13_lv_nmos ad=0.2822p pd=2.34u as=0.1577p ps=1.21u w=0.83u l=0.13u
X322 a_905_50224# a_905_49738# VDD VDD sg13_lv_pmos ad=0.3078p pd=2u as=0.3078p ps=2u w=1.62u l=0.385u
X323 VSS a_905_39340# a_905_38854# VSS sg13_lv_nmos ad=0.1577p pd=1.21u as=0.1577p ps=1.21u w=0.83u l=0.13u
X324 a_293_24342# a_293_24828# VSS VSS sg13_lv_nmos ad=0.1577p pd=1.21u as=0.2822p ps=2.34u w=0.83u l=0.13u
X325 VSS a_905_21200# a_905_20714# VSS sg13_lv_nmos ad=0.1577p pd=1.21u as=0.1577p ps=1.21u w=0.83u l=0.13u
X326 VSS a_905_6688# a_905_6202# VSS sg13_lv_nmos ad=0.2822p pd=2.34u as=0.1577p ps=1.21u w=0.83u l=0.13u
X327 VDD a_293_31598# a_293_32084# VDD sg13_lv_pmos ad=0.3078p pd=2u as=0.3078p ps=2u w=1.62u l=0.385u
X328 a_905_3060# a_905_2574# VDD VDD sg13_lv_pmos ad=0.3078p pd=2u as=0.3078p ps=2u w=1.62u l=0.385u
X329 a_905_6202# a_905_6688# VSS VSS sg13_lv_nmos ad=0.1577p pd=1.21u as=0.1577p ps=1.21u w=0.83u l=0.13u
X330 VSS a_905_57480# a_905_56994# VSS sg13_lv_nmos ad=0.1577p pd=1.21u as=0.1577p ps=1.21u w=0.83u l=0.13u
X331 VSS a_293_42968# a_293_42482# VSS sg13_lv_nmos ad=0.1577p pd=1.21u as=0.1577p ps=1.21u w=0.83u l=0.13u
X332 a_293_6688# a_293_6202# VDD VDD sg13_lv_pmos ad=0.3078p pd=2u as=0.5508p ps=3.92u w=1.62u l=0.385u
X333 VDD a_905_20714# a_905_21200# VDD sg13_lv_pmos ad=0.3078p pd=2u as=0.3078p ps=2u w=1.62u l=0.385u
X334 VSS a_905_13944# a_905_13458# VSS sg13_lv_nmos ad=0.1577p pd=1.21u as=0.1577p ps=1.21u w=0.83u l=0.13u
X335 a_293_53852# a_293_53366# VDD VDD sg13_lv_pmos ad=0.3078p pd=2u as=0.5508p ps=3.92u w=1.62u l=0.385u
X336 a_293_46596# a_293_46110# VDD VDD sg13_lv_pmos ad=0.3078p pd=2u as=0.3078p ps=2u w=1.62u l=0.385u
X337 a_293_42482# a_293_42968# VSS VSS sg13_lv_nmos ad=0.1577p pd=1.21u as=0.1577p ps=1.21u w=0.83u l=0.13u
X338 VDD a_293_27970# a_293_28456# VDD sg13_lv_pmos ad=0.3078p pd=2u as=0.3078p ps=2u w=1.62u l=0.385u
X339 a_905_31598# a_905_32084# VSS VSS sg13_lv_nmos ad=0.1577p pd=1.21u as=0.1577p ps=1.21u w=0.83u l=0.13u
.ends

.subckt RM_IHPSG13_1P_ROWREG8 ADDR_N_O<5> BIST_EN_I ADDR_N_O<0> ADDR_N_O<1> ADDR_N_O<2>
+ ADDR_N_O<3> ADDR_I<7> ADDR_I<0> ADDR_I<1> ADDR_I<2> ADDR_N_O<4> BIST_ADDR_I<0> BIST_ADDR_I<1>
+ BIST_ADDR_I<2> BIST_ADDR_I<3> ADDR_N_O<6> ADDR_N_O<7> BIST_ADDR_I<4> BIST_ADDR_I<5>
+ BIST_ADDR_I<6> BIST_ADDR_I<7> ADDR_I<3> ADDR_I<4> ADDR_I<5> ADDR_I<6> RM_IHPSG13_1P_ROWREG0_0/m3_n1122_n273#
+ RM_IHPSG13_1P_ROWREG0_0/m2_6482_n2520# VSS ACLK_N_I RM_IHPSG13_1P_ROWREG0_0/m2_4442_n2520#
+ RM_IHPSG13_1P_ROWREG0_0/m2_4340_n2520# RM_IHPSG13_1P_ROWREG0_0/m2_1178_n2520# RM_IHPSG13_1P_ROWREG0_0/m2_4544_n449#
+ VDD
X0 a_13_n675# a_n285_n675# a_n89_n675# VDD sg13_lv_pmos ad=0.14927p pd=1.355u as=0.18525p ps=1.355u w=0.975u l=0.13u
X1 a_2563_n1200# ACLK_N_I a_1989_n1403# VDD sg13_lv_pmos ad=0.1881p pd=1.37u as=0.1511p ps=1.37u w=0.99u l=0.13u
X2 a_4271_n1344# a_4271_n1622# VSS VSS sg13_lv_nmos ad=0.1577p pd=1.21u as=0.1577p ps=1.21u w=0.83u l=0.13u
X3 a_4501_n675# BIST_EN_I a_4399_n675# VDD sg13_lv_pmos ad=0.18715p pd=1.365u as=0.18715p ps=1.365u w=0.985u l=0.13u
X4 a_2971_n1952# a_2639_n2394# VSS VSS sg13_lv_nmos ad=91.2f pd=0.86u as=91.2f ps=0.86u w=0.48u l=0.13u
X5 VSS a_5291_n680# a_5215_n272# VSS sg13_lv_nmos ad=91.2f pd=0.86u as=91.2f ps=0.86u w=0.48u l=0.13u
X6 a_1989_n1403# a_2401_n1030# a_2359_n1198# VDD sg13_lv_pmos ad=0.1511p pd=1.37u as=91.2f ps=0.86u w=0.48u l=0.13u
X7 VSS a_6107_n1622# a_6107_n1344# VSS sg13_lv_nmos ad=0.1577p pd=1.21u as=0.1577p ps=1.21u w=0.83u l=0.13u
X8 a_5725_n678# a_4815_n675# a_5623_n312# VSS sg13_lv_nmos ad=0.13375p pd=1.23u as=0.1783p ps=1.44u w=0.85u l=0.13u
X9 a_n497_n1522# BIST_EN_I a_n599_n1522# VSS sg13_lv_nmos ad=0.1064p pd=0.94u as=0.1064p ps=0.94u w=0.56u l=0.13u
X10 VSS a_5495_n1622# a_5495_n1344# VSS sg13_lv_nmos ad=0.1577p pd=1.21u as=0.1577p ps=1.21u w=0.83u l=0.13u
X11 a_4603_n1950# BIST_EN_I a_4501_n2355# VSS sg13_lv_nmos ad=0.1064p pd=0.94u as=0.1064p ps=0.94u w=0.56u l=0.13u
X12 a_115_n582# ACLK_N_I a_13_n675# VDD sg13_lv_pmos ad=91.2f pd=0.86u as=0.14927p ps=1.355u w=0.48u l=0.13u
X13 a_2401_n746# ACLK_N_I VSS VSS sg13_lv_nmos ad=0.1683p pd=1.67u as=0.13717p ps=1.25u w=0.495u l=0.13u
X14 a_1619_n1620# a_1989_n1403# VSS VSS sg13_lv_nmos ad=0.2397p pd=2.09u as=0.13395p ps=1.085u w=0.705u l=0.13u
X15 a_3787_n1522# a_3624_n991# a_3251_n1620# VSS sg13_lv_nmos ad=0.1064p pd=0.94u as=0.1064p ps=0.94u w=0.56u l=0.13u
X16 VDD a_1619_n2460# ADDR_N_O<0> VDD sg13_lv_pmos ad=0.3078p pd=2u as=0.3078p ps=2u w=1.62u l=0.13u
X17 a_n599_n2355# BIST_EN_I a_n701_n2355# VDD sg13_lv_pmos ad=0.18715p pd=1.365u as=0.18715p ps=1.365u w=0.985u l=0.13u
X18 VDD a_1041_n2424# ADDR_N_O<1> VDD sg13_lv_pmos ad=0.3078p pd=2u as=0.3078p ps=2u w=1.62u l=0.13u
X19 a_2563_n1950# a_2401_n2426# a_1989_n2053# VSS sg13_lv_nmos ad=0.1783p pd=1.44u as=0.13375p ps=1.23u w=0.85u l=0.13u
X20 VDD ACLK_N_I a_n285_n2355# VDD sg13_lv_pmos ad=0.14812p pd=1.355u as=0.1632p ps=1.64u w=0.48u l=0.13u
X21 a_5291_n680# a_5113_n675# VDD VDD sg13_lv_pmos ad=0.1632p pd=1.64u as=91.2f ps=0.86u w=0.48u l=0.13u
X22 a_5113_n2355# a_4815_n2355# a_5011_n2355# VDD sg13_lv_pmos ad=0.14927p pd=1.355u as=0.18525p ps=1.355u w=0.975u l=0.13u
X23 VDD ADDR_I<0> a_3787_n2355# VDD sg13_lv_pmos ad=0.16165p pd=1.365u as=0.18715p ps=1.365u w=0.985u l=0.13u
X24 a_2838_n2085# ACLK_N_I a_2971_n2262# VDD sg13_lv_pmos ad=0.14927p pd=1.355u as=91.2f ps=0.86u w=0.48u l=0.13u
X25 a_2971_n272# a_2639_n714# VSS VSS sg13_lv_nmos ad=91.2f pd=0.86u as=91.2f ps=0.86u w=0.48u l=0.13u
X26 a_625_n1580# ACLK_N_I a_523_n1200# VDD sg13_lv_pmos ad=0.1511p pd=1.37u as=0.1881p ps=1.37u w=0.99u l=0.13u
X27 VSS ACLK_N_I a_4815_n2355# VSS sg13_lv_nmos ad=0.13717p pd=1.25u as=0.1683p ps=1.67u w=0.495u l=0.13u
X28 VSS a_191_n680# a_115_n272# VSS sg13_lv_nmos ad=91.2f pd=0.86u as=91.2f ps=0.86u w=0.48u l=0.13u
X29 a_5113_n675# a_4815_n675# a_5011_n675# VDD sg13_lv_pmos ad=0.14927p pd=1.355u as=0.18525p ps=1.355u w=0.975u l=0.13u
X30 a_625_n678# a_n285_n675# a_523_n312# VSS sg13_lv_nmos ad=0.13375p pd=1.23u as=0.1783p ps=1.44u w=0.85u l=0.13u
X31 a_5495_n1622# a_5495_n1344# VDD VDD sg13_lv_pmos ad=0.3078p pd=2u as=0.3078p ps=2u w=1.62u l=0.385u
X32 a_115_n1194# ACLK_N_I a_13_n1582# VDD sg13_lv_pmos ad=91.2f pd=0.86u as=0.14927p ps=1.355u w=0.48u l=0.13u
X33 VDD a_803_n1620# a_727_n1198# VDD sg13_lv_pmos ad=91.2f pd=0.86u as=91.2f ps=0.86u w=0.48u l=0.13u
X34 VSS BIST_EN_I a_4203_n2355# VSS sg13_lv_nmos ad=0.1064p pd=0.94u as=0.1904p ps=1.8u w=0.56u l=0.13u
X35 VDD a_1041_n744# ADDR_N_O<5> VDD sg13_lv_pmos ad=0.3078p pd=2u as=0.3078p ps=2u w=1.62u l=0.13u
X36 a_5903_n677# a_5725_n678# VSS VSS sg13_lv_nmos ad=0.1632p pd=1.64u as=91.2f ps=0.86u w=0.48u l=0.13u
X37 a_191_n1540# a_13_n1582# VDD VDD sg13_lv_pmos ad=0.1632p pd=1.64u as=91.2f ps=0.86u w=0.48u l=0.13u
X38 a_5495_n1622# a_5495_n1344# VDD VDD sg13_lv_pmos ad=0.3078p pd=2u as=0.3078p ps=2u w=1.62u l=0.385u
X39 a_625_n2358# a_n285_n2355# a_523_n1992# VSS sg13_lv_nmos ad=0.13375p pd=1.23u as=0.1783p ps=1.44u w=0.85u l=0.13u
X40 VSS a_2639_n2394# a_2563_n1950# VSS sg13_lv_nmos ad=0.289p pd=2.38u as=0.1783p ps=1.44u w=0.85u l=0.13u
X41 ADDR_N_O<3> a_1619_n780# VSS VSS sg13_lv_nmos ad=0.13395p pd=1.085u as=0.13395p ps=1.085u w=0.705u l=0.13u
X42 VSS a_1989_n373# a_2163_n746# VSS sg13_lv_nmos ad=91.2f pd=0.86u as=0.1632p ps=1.64u w=0.48u l=0.13u
X43 ADDR_N_O<2> a_1619_n1620# VDD VDD sg13_lv_pmos ad=0.3078p pd=2u as=0.3078p ps=2u w=1.62u l=0.13u
X44 VDD a_4271_n1344# a_4271_n1622# VDD sg13_lv_pmos ad=0.3078p pd=2u as=0.3078p ps=2u w=1.62u l=0.385u
X45 VSS a_1989_n2053# a_2163_n2426# VSS sg13_lv_nmos ad=91.2f pd=0.86u as=0.1632p ps=1.64u w=0.48u l=0.13u
X46 VSS a_1041_n744# ADDR_N_O<5> VSS sg13_lv_nmos ad=0.13395p pd=1.085u as=0.13395p ps=1.085u w=0.705u l=0.13u
X47 a_191_n680# a_13_n675# VDD VDD sg13_lv_pmos ad=0.1632p pd=1.64u as=91.2f ps=0.86u w=0.48u l=0.13u
X48 ADDR_N_O<4> a_1041_n1582# VDD VDD sg13_lv_pmos ad=0.3078p pd=2u as=0.3078p ps=2u w=1.62u l=0.13u
X49 a_5495_n1344# a_5495_n1622# VSS VSS sg13_lv_nmos ad=0.1577p pd=1.21u as=0.1577p ps=1.21u w=0.83u l=0.13u
X50 a_n599_n675# a_n897_n675# a_n701_n270# VSS sg13_lv_nmos ad=0.1064p pd=0.94u as=0.1064p ps=0.94u w=0.56u l=0.13u
X51 a_803_n2357# a_625_n2358# VSS VSS sg13_lv_nmos ad=0.1632p pd=1.64u as=91.2f ps=0.86u w=0.48u l=0.13u
X52 VSS a_1619_n2460# ADDR_N_O<0> VSS sg13_lv_nmos ad=0.13395p pd=1.085u as=0.13395p ps=1.085u w=0.705u l=0.13u
X53 VSS a_1041_n2424# ADDR_N_O<1> VSS sg13_lv_nmos ad=0.13395p pd=1.085u as=0.13395p ps=1.085u w=0.705u l=0.13u
X54 VSS a_625_n2358# a_1041_n2424# VSS sg13_lv_nmos ad=0.13395p pd=1.085u as=0.2397p ps=2.09u w=0.705u l=0.13u
X55 VSS ADDR_I<3> a_3787_n270# VSS sg13_lv_nmos ad=0.1064p pd=0.94u as=0.1064p ps=0.94u w=0.56u l=0.13u
X56 ADDR_N_O<2> a_1619_n1620# VSS VSS sg13_lv_nmos ad=0.13395p pd=1.085u as=0.13395p ps=1.085u w=0.705u l=0.13u
X57 VSS a_2838_n1371# a_2639_n1574# VSS sg13_lv_nmos ad=91.2f pd=0.86u as=0.1632p ps=1.64u w=0.48u l=0.13u
X58 a_115_n1952# a_n285_n2355# a_13_n2355# VSS sg13_lv_nmos ad=91.2f pd=0.86u as=0.13605p ps=1.25u w=0.48u l=0.13u
X59 a_191_n2360# a_13_n2355# VSS VSS sg13_lv_nmos ad=0.1632p pd=1.64u as=91.2f ps=0.86u w=0.48u l=0.13u
X60 ADDR_N_O<6> a_6141_n2424# VDD VDD sg13_lv_pmos ad=0.3078p pd=2u as=0.3078p ps=2u w=1.62u l=0.13u
X61 a_n701_n675# ADDR_I<5> VDD VDD sg13_lv_pmos ad=0.18715p pd=1.365u as=0.16165p ps=1.365u w=0.985u l=0.13u
X62 a_3583_n270# BIST_ADDR_I<3> VSS VSS sg13_lv_nmos ad=0.1064p pd=0.94u as=0.1904p ps=1.8u w=0.56u l=0.13u
X63 a_2838_n1371# ACLK_N_I a_2971_n1194# VDD sg13_lv_pmos ad=0.14927p pd=1.355u as=91.2f ps=0.86u w=0.48u l=0.13u
X64 ADDR_N_O<7> a_6141_n744# VDD VDD sg13_lv_pmos ad=0.3078p pd=2u as=0.3078p ps=2u w=1.62u l=0.13u
X65 a_13_n1582# ACLK_N_I a_n89_n1582# VSS sg13_lv_nmos ad=0.13605p pd=1.25u as=0.1653p ps=1.25u w=0.87u l=0.13u
X66 VSS a_5725_n678# a_6141_n744# VSS sg13_lv_nmos ad=0.13395p pd=1.085u as=0.2397p ps=2.09u w=0.705u l=0.13u
X67 ADDR_N_O<7> a_6141_n744# VSS VSS sg13_lv_nmos ad=0.13395p pd=1.085u as=0.13395p ps=1.085u w=0.705u l=0.13u
X68 VDD BIST_ADDR_I<6> a_4603_n2355# VDD sg13_lv_pmos ad=0.3349p pd=2.65u as=0.18715p ps=1.365u w=0.985u l=0.13u
X69 a_3624_n749# BIST_EN_I VDD VDD sg13_lv_pmos ad=0.2193p pd=1.97u as=0.16165p ps=1.365u w=0.645u l=0.13u
X70 a_13_n675# ACLK_N_I a_n89_n272# VSS sg13_lv_nmos ad=0.13605p pd=1.25u as=0.1653p ps=1.25u w=0.87u l=0.13u
X71 a_3251_n711# a_3624_n749# a_3583_n675# VDD sg13_lv_pmos ad=0.18715p pd=1.365u as=0.18715p ps=1.365u w=0.985u l=0.13u
X72 a_n89_n1582# a_n599_n1522# VSS VSS sg13_lv_nmos ad=0.1653p pd=1.25u as=0.13717p ps=1.25u w=0.87u l=0.13u
X73 VSS a_4883_n1622# a_4883_n1344# VSS sg13_lv_nmos ad=0.1577p pd=1.21u as=0.1577p ps=1.21u w=0.83u l=0.13u
X74 a_5113_n2355# ACLK_N_I a_5011_n1952# VSS sg13_lv_nmos ad=0.13605p pd=1.25u as=0.1653p ps=1.25u w=0.87u l=0.13u
X75 ADDR_N_O<1> a_1041_n2424# VSS VSS sg13_lv_nmos ad=0.13395p pd=1.085u as=0.13395p ps=1.085u w=0.705u l=0.13u
X76 a_2401_n1030# ACLK_N_I VSS VSS sg13_lv_nmos ad=0.1683p pd=1.67u as=0.13717p ps=1.25u w=0.495u l=0.13u
X77 a_n599_n2355# a_n897_n2355# a_n701_n1950# VSS sg13_lv_nmos ad=0.1064p pd=0.94u as=0.1064p ps=0.94u w=0.56u l=0.13u
X78 a_2838_n2085# a_2401_n2426# a_2971_n1952# VSS sg13_lv_nmos ad=0.13605p pd=1.25u as=91.2f ps=0.86u w=0.48u l=0.13u
X79 VDD a_3251_n711# a_3175_n675# VDD sg13_lv_pmos ad=0.14812p pd=1.355u as=0.18525p ps=1.355u w=0.975u l=0.13u
X80 a_n701_n1202# ADDR_I<4> VDD VDD sg13_lv_pmos ad=0.18715p pd=1.365u as=0.16165p ps=1.365u w=0.985u l=0.13u
X81 VSS a_1619_n1620# ADDR_N_O<2> VSS sg13_lv_nmos ad=0.13395p pd=1.085u as=0.13395p ps=1.085u w=0.705u l=0.13u
X82 VSS a_1989_n1403# a_2163_n1506# VSS sg13_lv_nmos ad=91.2f pd=0.86u as=0.1632p ps=1.64u w=0.48u l=0.13u
X83 VSS a_2639_n1574# a_2563_n1580# VSS sg13_lv_nmos ad=0.289p pd=2.38u as=0.1783p ps=1.44u w=0.85u l=0.13u
X84 VSS ADDR_I<0> a_3787_n1950# VSS sg13_lv_nmos ad=0.1064p pd=0.94u as=0.1064p ps=0.94u w=0.56u l=0.13u
X85 VDD a_2639_n2394# a_2563_n2358# VDD sg13_lv_pmos ad=0.3366p pd=2.66u as=0.1881p ps=1.37u w=0.99u l=0.13u
X86 a_4501_n675# a_4203_n675# a_4399_n270# VSS sg13_lv_nmos ad=0.1064p pd=0.94u as=0.1064p ps=0.94u w=0.56u l=0.13u
X87 a_5903_n677# a_5725_n678# VDD VDD sg13_lv_pmos ad=0.1632p pd=1.64u as=91.2f ps=0.86u w=0.48u l=0.13u
X88 VSS a_1041_n1582# ADDR_N_O<4> VSS sg13_lv_nmos ad=0.13395p pd=1.085u as=0.13395p ps=1.085u w=0.705u l=0.13u
X89 VDD a_5495_n1344# a_5495_n1622# VDD sg13_lv_pmos ad=0.3078p pd=2u as=0.3078p ps=2u w=1.62u l=0.385u
X90 VDD a_1989_n373# a_2163_n746# VDD sg13_lv_pmos ad=91.2f pd=0.86u as=0.1632p ps=1.64u w=0.48u l=0.13u
X91 a_803_n1620# a_625_n1580# VSS VSS sg13_lv_nmos ad=0.1632p pd=1.64u as=91.2f ps=0.86u w=0.48u l=0.13u
X92 a_3583_n1202# BIST_ADDR_I<2> VDD VDD sg13_lv_pmos ad=0.18715p pd=1.365u as=0.3349p ps=2.65u w=0.985u l=0.13u
X93 a_5827_n1950# ACLK_N_I a_5725_n2358# VSS sg13_lv_nmos ad=91.2f pd=0.86u as=0.13375p ps=1.23u w=0.48u l=0.13u
X94 a_115_n272# a_n285_n675# a_13_n675# VSS sg13_lv_nmos ad=91.2f pd=0.86u as=0.13605p ps=1.25u w=0.48u l=0.13u
X95 a_4399_n2355# ADDR_I<6> VDD VDD sg13_lv_pmos ad=0.18715p pd=1.365u as=0.16165p ps=1.365u w=0.985u l=0.13u
X96 VSS ACLK_N_I a_n285_n675# VSS sg13_lv_nmos ad=0.13717p pd=1.25u as=0.1683p ps=1.67u w=0.495u l=0.13u
X97 a_4603_n675# a_4203_n675# a_4501_n675# VDD sg13_lv_pmos ad=0.18715p pd=1.365u as=0.18715p ps=1.365u w=0.985u l=0.13u
X98 VDD ACLK_N_I a_4815_n675# VDD sg13_lv_pmos ad=0.14812p pd=1.355u as=0.1632p ps=1.64u w=0.48u l=0.13u
X99 a_5291_n680# a_5113_n675# VSS VSS sg13_lv_nmos ad=0.1632p pd=1.64u as=91.2f ps=0.86u w=0.48u l=0.13u
X100 a_5113_n675# ACLK_N_I a_5011_n272# VSS sg13_lv_nmos ad=0.13605p pd=1.25u as=0.1653p ps=1.25u w=0.87u l=0.13u
X101 a_5623_n1992# a_5291_n2360# VSS VSS sg13_lv_nmos ad=0.1783p pd=1.44u as=0.289p ps=2.38u w=0.85u l=0.13u
X102 a_5827_n270# ACLK_N_I a_5725_n678# VSS sg13_lv_nmos ad=91.2f pd=0.86u as=0.13375p ps=1.23u w=0.48u l=0.13u
X103 VDD a_1989_n2053# a_2163_n2426# VDD sg13_lv_pmos ad=91.2f pd=0.86u as=0.1632p ps=1.64u w=0.48u l=0.13u
X104 a_5623_n312# a_5291_n680# VSS VSS sg13_lv_nmos ad=0.1783p pd=1.44u as=0.289p ps=2.38u w=0.85u l=0.13u
X105 VDD BIST_ADDR_I<4> a_n497_n1202# VDD sg13_lv_pmos ad=0.3349p pd=2.65u as=0.18715p ps=1.365u w=0.985u l=0.13u
X106 a_2401_n2426# ACLK_N_I VSS VSS sg13_lv_nmos ad=0.1683p pd=1.67u as=0.13717p ps=1.25u w=0.495u l=0.13u
X107 VSS a_191_n1540# a_115_n1504# VSS sg13_lv_nmos ad=91.2f pd=0.86u as=91.2f ps=0.86u w=0.48u l=0.13u
X108 a_3624_n991# BIST_EN_I VDD VDD sg13_lv_pmos ad=0.2193p pd=1.97u as=0.16165p ps=1.365u w=0.645u l=0.13u
X109 VDD a_4883_n1344# a_4883_n1622# VDD sg13_lv_pmos ad=0.3078p pd=2u as=0.3078p ps=2u w=1.62u l=0.385u
X110 a_803_n2357# a_625_n2358# VDD VDD sg13_lv_pmos ad=0.1632p pd=1.64u as=91.2f ps=0.86u w=0.48u l=0.13u
X111 a_5215_n582# ACLK_N_I a_5113_n675# VDD sg13_lv_pmos ad=91.2f pd=0.86u as=0.14927p ps=1.355u w=0.48u l=0.13u
X112 VSS a_4883_n1622# a_4883_n1344# VSS sg13_lv_nmos ad=0.1577p pd=1.21u as=0.1577p ps=1.21u w=0.83u l=0.13u
X113 VSS a_6141_n2424# ADDR_N_O<6> VSS sg13_lv_nmos ad=0.13395p pd=1.085u as=0.13395p ps=1.085u w=0.705u l=0.13u
X114 VDD a_2639_n1574# a_2563_n1200# VDD sg13_lv_pmos ad=0.3366p pd=2.66u as=0.1881p ps=1.37u w=0.99u l=0.13u
X115 VSS a_4271_n1622# a_4271_n1344# VSS sg13_lv_nmos ad=0.1577p pd=1.21u as=0.1577p ps=1.21u w=0.83u l=0.13u
X116 a_1619_n2460# a_1989_n2053# VSS VSS sg13_lv_nmos ad=0.2397p pd=2.09u as=0.13395p ps=1.085u w=0.705u l=0.13u
X117 a_191_n680# a_13_n675# VSS VSS sg13_lv_nmos ad=0.1632p pd=1.64u as=91.2f ps=0.86u w=0.48u l=0.13u
X118 a_6107_n1344# a_6107_n1622# VSS VSS sg13_lv_nmos ad=0.1577p pd=1.21u as=0.1577p ps=1.21u w=0.83u l=0.13u
X119 a_727_n270# ACLK_N_I a_625_n678# VSS sg13_lv_nmos ad=91.2f pd=0.86u as=0.13375p ps=1.23u w=0.48u l=0.13u
X120 a_n599_n1522# a_n897_n1522# a_n701_n1522# VSS sg13_lv_nmos ad=0.1064p pd=0.94u as=0.1064p ps=0.94u w=0.56u l=0.13u
X121 a_6107_n1344# a_6107_n1622# VSS VSS sg13_lv_nmos ad=0.1577p pd=1.21u as=0.1577p ps=1.21u w=0.83u l=0.13u
X122 VSS BIST_ADDR_I<6> a_4603_n1950# VSS sg13_lv_nmos ad=0.1904p pd=1.8u as=0.1064p ps=0.94u w=0.56u l=0.13u
X123 VDD a_1619_n780# ADDR_N_O<3> VDD sg13_lv_pmos ad=0.3078p pd=2u as=0.3078p ps=2u w=1.62u l=0.13u
X124 VSS ADDR_I<2> a_3787_n1522# VSS sg13_lv_nmos ad=0.1064p pd=0.94u as=0.1064p ps=0.94u w=0.56u l=0.13u
X125 a_5215_n2262# ACLK_N_I a_5113_n2355# VDD sg13_lv_pmos ad=91.2f pd=0.86u as=0.14927p ps=1.355u w=0.48u l=0.13u
X126 ADDR_N_O<0> a_1619_n2460# VDD VDD sg13_lv_pmos ad=0.3078p pd=2u as=0.3078p ps=2u w=1.62u l=0.13u
X127 a_523_n312# a_191_n680# VSS VSS sg13_lv_nmos ad=0.1783p pd=1.44u as=0.289p ps=2.38u w=0.85u l=0.13u
X128 VSS a_1619_n780# ADDR_N_O<3> VSS sg13_lv_nmos ad=0.13395p pd=1.085u as=0.13395p ps=1.085u w=0.705u l=0.13u
X129 a_2359_n270# a_2163_n746# VSS VSS sg13_lv_nmos ad=91.2f pd=0.86u as=91.2f ps=0.86u w=0.48u l=0.13u
X130 VDD a_625_n678# a_1041_n744# VDD sg13_lv_pmos ad=0.3078p pd=2u as=0.5508p ps=3.92u w=1.62u l=0.13u
X131 ADDR_N_O<5> a_1041_n744# VDD VDD sg13_lv_pmos ad=0.3078p pd=2u as=0.3078p ps=2u w=1.62u l=0.13u
X132 a_2563_n1580# a_2401_n1030# a_1989_n1403# VSS sg13_lv_nmos ad=0.1783p pd=1.44u as=0.13375p ps=1.23u w=0.85u l=0.13u
X133 a_n701_n2355# ADDR_I<1> VDD VDD sg13_lv_pmos ad=0.18715p pd=1.365u as=0.16165p ps=1.365u w=0.985u l=0.13u
X134 ADDR_N_O<1> a_1041_n2424# VDD VDD sg13_lv_pmos ad=0.3078p pd=2u as=0.3078p ps=2u w=1.62u l=0.13u
X135 ADDR_N_O<3> a_1619_n780# VSS VSS sg13_lv_nmos ad=0.13395p pd=1.085u as=0.13395p ps=1.085u w=0.705u l=0.13u
X136 a_3624_n2429# BIST_EN_I VDD VDD sg13_lv_pmos ad=0.2193p pd=1.97u as=0.16165p ps=1.365u w=0.645u l=0.13u
X137 a_n701_n270# ADDR_I<5> VSS VSS sg13_lv_nmos ad=0.1064p pd=0.94u as=0.1064p ps=0.94u w=0.56u l=0.13u
X138 a_3583_n2355# BIST_ADDR_I<0> VDD VDD sg13_lv_pmos ad=0.18715p pd=1.365u as=0.3349p ps=2.65u w=0.985u l=0.13u
X139 ADDR_N_O<5> a_1041_n744# VSS VSS sg13_lv_nmos ad=0.13395p pd=1.085u as=0.13395p ps=1.085u w=0.705u l=0.13u
X140 a_5623_n2358# a_5291_n2360# VDD VDD sg13_lv_pmos ad=0.1881p pd=1.37u as=0.3366p ps=2.66u w=0.99u l=0.13u
X141 a_4271_n1344# a_4271_n1622# VSS VSS sg13_lv_nmos ad=0.1577p pd=1.21u as=0.2822p ps=2.34u w=0.83u l=0.13u
X142 a_3175_n2355# a_2401_n2426# a_2838_n2085# VDD sg13_lv_pmos ad=0.18525p pd=1.355u as=0.14927p ps=1.355u w=0.975u l=0.13u
X143 a_5827_n578# a_4815_n675# a_5725_n678# VDD sg13_lv_pmos ad=91.2f pd=0.86u as=0.1511p ps=1.37u w=0.48u l=0.13u
X144 VDD a_1989_n1403# a_2163_n1506# VDD sg13_lv_pmos ad=91.2f pd=0.86u as=0.1632p ps=1.64u w=0.48u l=0.13u
X145 a_5827_n2258# a_4815_n2355# a_5725_n2358# VDD sg13_lv_pmos ad=91.2f pd=0.86u as=0.1511p ps=1.37u w=0.48u l=0.13u
X146 VDD BIST_EN_I a_n897_n675# VDD sg13_lv_pmos ad=0.16165p pd=1.365u as=0.2193p ps=1.97u w=0.645u l=0.13u
X147 VSS a_3251_n711# a_3175_n272# VSS sg13_lv_nmos ad=0.13717p pd=1.25u as=0.1653p ps=1.25u w=0.87u l=0.13u
X148 a_3251_n711# BIST_EN_I a_3583_n270# VSS sg13_lv_nmos ad=0.1064p pd=0.94u as=0.1064p ps=0.94u w=0.56u l=0.13u
X149 a_3624_n749# BIST_EN_I VSS VSS sg13_lv_nmos ad=0.1904p pd=1.8u as=0.1064p ps=0.94u w=0.56u l=0.13u
X150 VDD a_6107_n1344# a_6107_n1622# VDD sg13_lv_pmos ad=0.5508p pd=3.92u as=0.3078p ps=2u w=1.62u l=0.385u
X151 a_4399_n1950# ADDR_I<6> VSS VSS sg13_lv_nmos ad=0.1064p pd=0.94u as=0.1064p ps=0.94u w=0.56u l=0.13u
X152 VDD a_6141_n744# ADDR_N_O<7> VDD sg13_lv_pmos ad=0.3078p pd=2u as=0.3078p ps=2u w=1.62u l=0.13u
X153 a_803_n1620# a_625_n1580# VDD VDD sg13_lv_pmos ad=0.1632p pd=1.64u as=91.2f ps=0.86u w=0.48u l=0.13u
X154 a_4883_n1622# a_4883_n1344# VDD VDD sg13_lv_pmos ad=0.3078p pd=2u as=0.3078p ps=2u w=1.62u l=0.385u
X155 VDD a_5291_n2360# a_5215_n2262# VDD sg13_lv_pmos ad=91.2f pd=0.86u as=91.2f ps=0.86u w=0.48u l=0.13u
X156 VSS a_6141_n744# ADDR_N_O<7> VSS sg13_lv_nmos ad=0.2397p pd=2.09u as=0.13395p ps=1.085u w=0.705u l=0.13u
X157 VDD BIST_ADDR_I<5> a_n497_n675# VDD sg13_lv_pmos ad=0.3349p pd=2.65u as=0.18715p ps=1.365u w=0.985u l=0.13u
X158 a_n89_n675# a_n599_n675# VDD VDD sg13_lv_pmos ad=0.18525p pd=1.355u as=0.14812p ps=1.355u w=0.975u l=0.13u
X159 a_1619_n780# a_1989_n373# VDD VDD sg13_lv_pmos ad=0.5508p pd=3.92u as=0.3078p ps=2u w=1.62u l=0.13u
X160 VDD a_1619_n1620# ADDR_N_O<2> VDD sg13_lv_pmos ad=0.3078p pd=2u as=0.3078p ps=2u w=1.62u l=0.13u
X161 a_625_n1580# a_n285_n1582# a_523_n1538# VSS sg13_lv_nmos ad=0.13375p pd=1.23u as=0.1783p ps=1.44u w=0.85u l=0.13u
X162 VDD BIST_ADDR_I<1> a_n497_n2355# VDD sg13_lv_pmos ad=0.3349p pd=2.65u as=0.18715p ps=1.365u w=0.985u l=0.13u
X163 a_2359_n1950# a_2163_n2426# VSS VSS sg13_lv_nmos ad=91.2f pd=0.86u as=91.2f ps=0.86u w=0.48u l=0.13u
X164 VDD a_1041_n1582# ADDR_N_O<4> VDD sg13_lv_pmos ad=0.3078p pd=2u as=0.3078p ps=2u w=1.62u l=0.13u
X165 a_2838_n405# ACLK_N_I a_2971_n582# VDD sg13_lv_pmos ad=0.14927p pd=1.355u as=91.2f ps=0.86u w=0.48u l=0.13u
X166 VDD a_625_n1580# a_1041_n1582# VDD sg13_lv_pmos ad=0.3078p pd=2u as=0.5508p ps=3.92u w=1.62u l=0.13u
X167 ADDR_N_O<0> a_1619_n2460# VSS VSS sg13_lv_nmos ad=0.13395p pd=1.085u as=0.13395p ps=1.085u w=0.705u l=0.13u
X168 VDD a_3251_n2391# a_3175_n2355# VDD sg13_lv_pmos ad=0.14812p pd=1.355u as=0.18525p ps=1.355u w=0.975u l=0.13u
X169 a_727_n578# a_n285_n675# a_625_n678# VDD sg13_lv_pmos ad=91.2f pd=0.86u as=0.1511p ps=1.37u w=0.48u l=0.13u
X170 a_2401_n746# ACLK_N_I VDD VDD sg13_lv_pmos ad=0.1632p pd=1.64u as=0.14812p ps=1.355u w=0.48u l=0.13u
X171 a_2971_n1504# a_2639_n1574# VSS VSS sg13_lv_nmos ad=91.2f pd=0.86u as=91.2f ps=0.86u w=0.48u l=0.13u
X172 VDD a_6141_n2424# ADDR_N_O<6> VDD sg13_lv_pmos ad=0.5508p pd=3.92u as=0.3078p ps=2u w=1.62u l=0.13u
X173 a_4603_n270# BIST_EN_I a_4501_n675# VSS sg13_lv_nmos ad=0.1064p pd=0.94u as=0.1064p ps=0.94u w=0.56u l=0.13u
X174 a_2359_n578# a_2163_n746# VDD VDD sg13_lv_pmos ad=91.2f pd=0.86u as=91.2f ps=0.86u w=0.48u l=0.13u
X175 VDD a_6107_n1344# a_6107_n1622# VDD sg13_lv_pmos ad=0.3078p pd=2u as=0.3078p ps=2u w=1.62u l=0.385u
X176 VDD a_5725_n2358# a_6141_n2424# VDD sg13_lv_pmos ad=0.3078p pd=2u as=0.5508p ps=3.92u w=1.62u l=0.13u
X177 a_5011_n675# a_4501_n675# VDD VDD sg13_lv_pmos ad=0.18525p pd=1.355u as=0.14812p ps=1.355u w=0.975u l=0.13u
X178 a_5495_n1344# a_5495_n1622# VSS VSS sg13_lv_nmos ad=0.1577p pd=1.21u as=0.1577p ps=1.21u w=0.83u l=0.13u
X179 VDD BIST_ADDR_I<7> a_4603_n675# VDD sg13_lv_pmos ad=0.3349p pd=2.65u as=0.18715p ps=1.365u w=0.985u l=0.13u
X180 VSS ACLK_N_I a_n285_n1582# VSS sg13_lv_nmos ad=0.13717p pd=1.25u as=0.1683p ps=1.67u w=0.495u l=0.13u
X181 ADDR_N_O<4> a_1041_n1582# VDD VDD sg13_lv_pmos ad=0.3078p pd=2u as=0.3078p ps=2u w=1.62u l=0.13u
X182 a_3175_n1200# a_2401_n1030# a_2838_n1371# VDD sg13_lv_pmos ad=0.18525p pd=1.355u as=0.14927p ps=1.355u w=0.975u l=0.13u
X183 a_4883_n1344# a_4883_n1622# VSS VSS sg13_lv_nmos ad=0.1577p pd=1.21u as=0.1577p ps=1.21u w=0.83u l=0.13u
X184 a_727_n1950# ACLK_N_I a_625_n2358# VSS sg13_lv_nmos ad=91.2f pd=0.86u as=0.13375p ps=1.23u w=0.48u l=0.13u
X185 a_5215_n1952# a_4815_n2355# a_5113_n2355# VSS sg13_lv_nmos ad=91.2f pd=0.86u as=0.13605p ps=1.25u w=0.48u l=0.13u
X186 VSS a_1619_n2460# ADDR_N_O<0> VSS sg13_lv_nmos ad=0.13395p pd=1.085u as=0.13395p ps=1.085u w=0.705u l=0.13u
X187 a_5215_n272# a_4815_n675# a_5113_n675# VSS sg13_lv_nmos ad=91.2f pd=0.86u as=0.13605p ps=1.25u w=0.48u l=0.13u
X188 VSS a_1041_n2424# ADDR_N_O<1> VSS sg13_lv_nmos ad=0.13395p pd=1.085u as=0.13395p ps=1.085u w=0.705u l=0.13u
X189 VDD BIST_EN_I a_4203_n675# VDD sg13_lv_pmos ad=0.16165p pd=1.365u as=0.2193p ps=1.97u w=0.645u l=0.13u
X190 VSS a_5495_n1622# a_5495_n1344# VSS sg13_lv_nmos ad=0.1577p pd=1.21u as=0.1577p ps=1.21u w=0.83u l=0.13u
X191 a_n701_n1950# ADDR_I<1> VSS VSS sg13_lv_nmos ad=0.1064p pd=0.94u as=0.1064p ps=0.94u w=0.56u l=0.13u
X192 a_3175_n1952# ACLK_N_I a_2838_n2085# VSS sg13_lv_nmos ad=0.1653p pd=1.25u as=0.13605p ps=1.25u w=0.87u l=0.13u
X193 VSS a_5903_n677# a_5827_n270# VSS sg13_lv_nmos ad=91.2f pd=0.86u as=91.2f ps=0.86u w=0.48u l=0.13u
X194 ADDR_N_O<2> a_1619_n1620# VSS VSS sg13_lv_nmos ad=0.13395p pd=1.085u as=0.13395p ps=1.085u w=0.705u l=0.13u
X195 a_2359_n1506# a_2163_n1506# VSS VSS sg13_lv_nmos ad=91.2f pd=0.86u as=91.2f ps=0.86u w=0.48u l=0.13u
X196 ADDR_N_O<6> a_6141_n2424# VDD VDD sg13_lv_pmos ad=0.3078p pd=2u as=0.3078p ps=2u w=1.62u l=0.13u
X197 a_3624_n2429# BIST_EN_I VSS VSS sg13_lv_nmos ad=0.1904p pd=1.8u as=0.1064p ps=0.94u w=0.56u l=0.13u
X198 ADDR_N_O<4> a_1041_n1582# VSS VSS sg13_lv_nmos ad=0.13395p pd=1.085u as=0.13395p ps=1.085u w=0.705u l=0.13u
X199 VSS a_5903_n2357# a_5827_n1950# VSS sg13_lv_nmos ad=91.2f pd=0.86u as=91.2f ps=0.86u w=0.48u l=0.13u
X200 a_3583_n1950# BIST_ADDR_I<0> VSS VSS sg13_lv_nmos ad=0.1064p pd=0.94u as=0.1904p ps=1.8u w=0.56u l=0.13u
X201 a_3251_n1620# a_3624_n991# a_3583_n1202# VDD sg13_lv_pmos ad=0.18715p pd=1.365u as=0.18715p ps=1.365u w=0.985u l=0.13u
X202 a_523_n1992# a_191_n2360# VSS VSS sg13_lv_nmos ad=0.1783p pd=1.44u as=0.289p ps=2.38u w=0.85u l=0.13u
X203 VDD ACLK_N_I a_4815_n2355# VDD sg13_lv_pmos ad=0.14812p pd=1.355u as=0.1632p ps=1.64u w=0.48u l=0.13u
X204 VDD a_2838_n2085# a_2639_n2394# VDD sg13_lv_pmos ad=91.2f pd=0.86u as=0.1632p ps=1.64u w=0.48u l=0.13u
X205 a_4501_n2355# BIST_EN_I a_4399_n2355# VDD sg13_lv_pmos ad=0.18715p pd=1.365u as=0.18715p ps=1.365u w=0.985u l=0.13u
X206 VDD a_3251_n1620# a_3175_n1200# VDD sg13_lv_pmos ad=0.14812p pd=1.355u as=0.18525p ps=1.355u w=0.975u l=0.13u
X207 VSS a_5291_n2360# a_5215_n1952# VSS sg13_lv_nmos ad=91.2f pd=0.86u as=91.2f ps=0.86u w=0.48u l=0.13u
X208 a_2401_n1030# ACLK_N_I VDD VDD sg13_lv_pmos ad=0.1632p pd=1.64u as=0.14812p ps=1.355u w=0.48u l=0.13u
X209 VSS BIST_ADDR_I<1> a_n497_n1950# VSS sg13_lv_nmos ad=0.1904p pd=1.8u as=0.1064p ps=0.94u w=0.56u l=0.13u
X210 VSS ACLK_N_I a_n285_n2355# VSS sg13_lv_nmos ad=0.13717p pd=1.25u as=0.1683p ps=1.67u w=0.495u l=0.13u
X211 VSS a_3251_n2391# a_3175_n1952# VSS sg13_lv_nmos ad=0.13717p pd=1.25u as=0.1653p ps=1.25u w=0.87u l=0.13u
X212 VSS a_803_n677# a_727_n270# VSS sg13_lv_nmos ad=91.2f pd=0.86u as=91.2f ps=0.86u w=0.48u l=0.13u
X213 ADDR_N_O<3> a_1619_n780# VDD VDD sg13_lv_pmos ad=0.3078p pd=2u as=0.3078p ps=2u w=1.62u l=0.13u
X214 a_5623_n678# a_5291_n680# VDD VDD sg13_lv_pmos ad=0.1881p pd=1.37u as=0.3366p ps=2.66u w=0.99u l=0.13u
X215 VDD BIST_EN_I a_n897_n1522# VDD sg13_lv_pmos ad=0.16165p pd=1.365u as=0.2193p ps=1.97u w=0.645u l=0.13u
X216 a_4883_n1622# a_4883_n1344# VDD VDD sg13_lv_pmos ad=0.3078p pd=2u as=0.3078p ps=2u w=1.62u l=0.385u
X217 a_2359_n2258# a_2163_n2426# VDD VDD sg13_lv_pmos ad=91.2f pd=0.86u as=91.2f ps=0.86u w=0.48u l=0.13u
X218 VDD a_1041_n744# ADDR_N_O<5> VDD sg13_lv_pmos ad=0.3078p pd=2u as=0.3078p ps=2u w=1.62u l=0.13u
X219 a_n497_n1202# a_n897_n1522# a_n599_n1522# VDD sg13_lv_pmos ad=0.18715p pd=1.365u as=0.18715p ps=1.365u w=0.985u l=0.13u
X220 a_115_n1504# a_n285_n1582# a_13_n1582# VSS sg13_lv_nmos ad=91.2f pd=0.86u as=0.13605p ps=1.25u w=0.48u l=0.13u
X221 a_191_n1540# a_13_n1582# VSS VSS sg13_lv_nmos ad=0.1632p pd=1.64u as=91.2f ps=0.86u w=0.48u l=0.13u
X222 a_1989_n373# ACLK_N_I a_2359_n270# VSS sg13_lv_nmos ad=0.13375p pd=1.23u as=91.2f ps=0.86u w=0.48u l=0.13u
X223 VSS a_2639_n714# a_2563_n270# VSS sg13_lv_nmos ad=0.289p pd=2.38u as=0.1783p ps=1.44u w=0.85u l=0.13u
X224 a_3787_n1202# BIST_EN_I a_3251_n1620# VDD sg13_lv_pmos ad=0.18715p pd=1.365u as=0.18715p ps=1.365u w=0.985u l=0.13u
X225 a_6107_n1622# a_6107_n1344# VDD VDD sg13_lv_pmos ad=0.3078p pd=2u as=0.3078p ps=2u w=1.62u l=0.385u
X226 VSS BIST_EN_I a_n897_n675# VSS sg13_lv_nmos ad=0.1064p pd=0.94u as=0.1904p ps=1.8u w=0.56u l=0.13u
X227 a_n89_n272# a_n599_n675# VSS VSS sg13_lv_nmos ad=0.1653p pd=1.25u as=0.13717p ps=1.25u w=0.87u l=0.13u
X228 VDD a_2838_n405# a_2639_n714# VDD sg13_lv_pmos ad=91.2f pd=0.86u as=0.1632p ps=1.64u w=0.48u l=0.13u
X229 a_727_n1506# ACLK_N_I a_625_n1580# VSS sg13_lv_nmos ad=91.2f pd=0.86u as=0.13375p ps=1.23u w=0.48u l=0.13u
X230 VDD a_4883_n1344# a_4883_n1622# VDD sg13_lv_pmos ad=0.3078p pd=2u as=0.3078p ps=2u w=1.62u l=0.385u
X231 a_1619_n1620# a_1989_n1403# VDD VDD sg13_lv_pmos ad=0.5508p pd=3.92u as=0.3078p ps=2u w=1.62u l=0.13u
X232 ADDR_N_O<6> a_6141_n2424# VSS VSS sg13_lv_nmos ad=0.13395p pd=1.085u as=0.13395p ps=1.085u w=0.705u l=0.13u
X233 VSS a_1041_n744# ADDR_N_O<5> VSS sg13_lv_nmos ad=0.13395p pd=1.085u as=0.13395p ps=1.085u w=0.705u l=0.13u
X234 a_4271_n1344# a_4271_n1622# VSS VSS sg13_lv_nmos ad=0.1577p pd=1.21u as=0.1577p ps=1.21u w=0.83u l=0.13u
X235 VSS BIST_ADDR_I<5> a_n497_n270# VSS sg13_lv_nmos ad=0.1904p pd=1.8u as=0.1064p ps=0.94u w=0.56u l=0.13u
X236 VDD a_5903_n677# a_5827_n578# VDD sg13_lv_pmos ad=91.2f pd=0.86u as=91.2f ps=0.86u w=0.48u l=0.13u
X237 VSS a_6107_n1622# a_6107_n1344# VSS sg13_lv_nmos ad=0.2822p pd=2.34u as=0.1577p ps=1.21u w=0.83u l=0.13u
X238 a_n701_n1522# ADDR_I<4> VSS VSS sg13_lv_nmos ad=0.1064p pd=0.94u as=0.1064p ps=0.94u w=0.56u l=0.13u
X239 VSS a_6107_n1622# a_6107_n1344# VSS sg13_lv_nmos ad=0.1577p pd=1.21u as=0.1577p ps=1.21u w=0.83u l=0.13u
X240 a_523_n678# a_191_n680# VDD VDD sg13_lv_pmos ad=0.1881p pd=1.37u as=0.3366p ps=2.66u w=0.99u l=0.13u
X241 a_2838_n405# a_2401_n746# a_2971_n272# VSS sg13_lv_nmos ad=0.13605p pd=1.25u as=91.2f ps=0.86u w=0.48u l=0.13u
X242 a_2563_n678# ACLK_N_I a_1989_n373# VDD sg13_lv_pmos ad=0.1881p pd=1.37u as=0.1511p ps=1.37u w=0.99u l=0.13u
X243 ADDR_N_O<7> a_6141_n744# VDD VDD sg13_lv_pmos ad=0.3078p pd=2u as=0.3078p ps=2u w=1.62u l=0.13u
X244 VDD a_2838_n1371# a_2639_n1574# VDD sg13_lv_pmos ad=91.2f pd=0.86u as=0.1632p ps=1.64u w=0.48u l=0.13u
X245 VDD a_1619_n2460# ADDR_N_O<0> VDD sg13_lv_pmos ad=0.3078p pd=2u as=0.3078p ps=2u w=1.62u l=0.13u
X246 a_523_n2358# a_191_n2360# VDD VDD sg13_lv_pmos ad=0.1881p pd=1.37u as=0.3366p ps=2.66u w=0.99u l=0.13u
X247 VDD a_5725_n678# a_6141_n744# VDD sg13_lv_pmos ad=0.3078p pd=2u as=0.5508p ps=3.92u w=1.62u l=0.13u
X248 a_523_n1538# a_191_n1540# VSS VSS sg13_lv_nmos ad=0.1783p pd=1.44u as=0.289p ps=2.38u w=0.85u l=0.13u
X249 a_2838_n1371# a_2401_n1030# a_2971_n1504# VSS sg13_lv_nmos ad=0.13605p pd=1.25u as=91.2f ps=0.86u w=0.48u l=0.13u
X250 a_3624_n991# BIST_EN_I VSS VSS sg13_lv_nmos ad=0.1904p pd=1.8u as=0.1064p ps=0.94u w=0.56u l=0.13u
X251 VDD a_1041_n2424# ADDR_N_O<1> VDD sg13_lv_pmos ad=0.3078p pd=2u as=0.3078p ps=2u w=1.62u l=0.13u
X252 a_n497_n675# a_n897_n675# a_n599_n675# VDD sg13_lv_pmos ad=0.18715p pd=1.365u as=0.18715p ps=1.365u w=0.985u l=0.13u
X253 a_3583_n1522# BIST_ADDR_I<2> VSS VSS sg13_lv_nmos ad=0.1064p pd=0.94u as=0.1904p ps=1.8u w=0.56u l=0.13u
X254 VDD BIST_EN_I a_n897_n2355# VDD sg13_lv_pmos ad=0.16165p pd=1.365u as=0.2193p ps=1.97u w=0.645u l=0.13u
X255 VDD ACLK_N_I a_n285_n675# VDD sg13_lv_pmos ad=0.14812p pd=1.355u as=0.1632p ps=1.64u w=0.48u l=0.13u
X256 VDD a_625_n2358# a_1041_n2424# VDD sg13_lv_pmos ad=0.3078p pd=2u as=0.5508p ps=3.92u w=1.62u l=0.13u
X257 a_727_n2258# a_n285_n2355# a_625_n2358# VDD sg13_lv_pmos ad=91.2f pd=0.86u as=0.1511p ps=1.37u w=0.48u l=0.13u
X258 a_5011_n272# a_4501_n675# VSS VSS sg13_lv_nmos ad=0.1653p pd=1.25u as=0.13717p ps=1.25u w=0.87u l=0.13u
X259 ADDR_N_O<7> a_6141_n744# VSS VSS sg13_lv_nmos ad=0.13395p pd=1.085u as=0.13395p ps=1.085u w=0.705u l=0.13u
X260 a_5725_n2358# ACLK_N_I a_5623_n2358# VDD sg13_lv_pmos ad=0.1511p pd=1.37u as=0.1881p ps=1.37u w=0.99u l=0.13u
X261 a_3251_n2391# a_3624_n2429# a_3583_n2355# VDD sg13_lv_pmos ad=0.18715p pd=1.365u as=0.18715p ps=1.365u w=0.985u l=0.13u
X262 VSS a_4271_n1622# a_4271_n1344# VSS sg13_lv_nmos ad=0.1577p pd=1.21u as=0.1577p ps=1.21u w=0.83u l=0.13u
X263 VDD a_191_n2360# a_115_n2262# VDD sg13_lv_pmos ad=91.2f pd=0.86u as=91.2f ps=0.86u w=0.48u l=0.13u
X264 a_3787_n675# BIST_EN_I a_3251_n711# VDD sg13_lv_pmos ad=0.18715p pd=1.365u as=0.18715p ps=1.365u w=0.985u l=0.13u
X265 VSS a_4271_n1622# a_4271_n1344# VSS sg13_lv_nmos ad=0.1577p pd=1.21u as=0.1577p ps=1.21u w=0.83u l=0.13u
X266 VSS a_2838_n2085# a_2639_n2394# VSS sg13_lv_nmos ad=91.2f pd=0.86u as=0.1632p ps=1.64u w=0.48u l=0.13u
X267 VDD a_803_n677# a_727_n578# VDD sg13_lv_pmos ad=91.2f pd=0.86u as=91.2f ps=0.86u w=0.48u l=0.13u
X268 a_3175_n675# a_2401_n746# a_2838_n405# VDD sg13_lv_pmos ad=0.18525p pd=1.355u as=0.14927p ps=1.355u w=0.975u l=0.13u
X269 a_2359_n1198# a_2163_n1506# VDD VDD sg13_lv_pmos ad=91.2f pd=0.86u as=91.2f ps=0.86u w=0.48u l=0.13u
X270 a_6107_n1344# a_6107_n1622# VSS VSS sg13_lv_nmos ad=0.1577p pd=1.21u as=0.1577p ps=1.21u w=0.83u l=0.13u
X271 VDD a_5903_n2357# a_5827_n2258# VDD sg13_lv_pmos ad=91.2f pd=0.86u as=91.2f ps=0.86u w=0.48u l=0.13u
X272 a_1989_n373# a_2401_n746# a_2359_n578# VDD sg13_lv_pmos ad=0.1511p pd=1.37u as=91.2f ps=0.86u w=0.48u l=0.13u
X273 VSS BIST_ADDR_I<7> a_4603_n270# VSS sg13_lv_nmos ad=0.1904p pd=1.8u as=0.1064p ps=0.94u w=0.56u l=0.13u
X274 VSS BIST_ADDR_I<4> a_n497_n1522# VSS sg13_lv_nmos ad=0.1904p pd=1.8u as=0.1064p ps=0.94u w=0.56u l=0.13u
X275 a_13_n2355# a_n285_n2355# a_n89_n2355# VDD sg13_lv_pmos ad=0.14927p pd=1.355u as=0.18525p ps=1.355u w=0.975u l=0.13u
X276 a_4501_n2355# a_4203_n2355# a_4399_n1950# VSS sg13_lv_nmos ad=0.1064p pd=0.94u as=0.1064p ps=0.94u w=0.56u l=0.13u
X277 a_5291_n2360# a_5113_n2355# VDD VDD sg13_lv_pmos ad=0.1632p pd=1.64u as=91.2f ps=0.86u w=0.48u l=0.13u
X278 VSS BIST_EN_I a_4203_n675# VSS sg13_lv_nmos ad=0.1064p pd=0.94u as=0.1904p ps=1.8u w=0.56u l=0.13u
X279 a_n497_n2355# a_n897_n2355# a_n599_n2355# VDD sg13_lv_pmos ad=0.18715p pd=1.365u as=0.18715p ps=1.365u w=0.985u l=0.13u
X280 ADDR_N_O<1> a_1041_n2424# VDD VDD sg13_lv_pmos ad=0.3078p pd=2u as=0.3078p ps=2u w=1.62u l=0.13u
X281 a_1989_n2053# ACLK_N_I a_2359_n1950# VSS sg13_lv_nmos ad=0.13375p pd=1.23u as=91.2f ps=0.86u w=0.48u l=0.13u
X282 a_5903_n2357# a_5725_n2358# VSS VSS sg13_lv_nmos ad=0.1632p pd=1.64u as=91.2f ps=0.86u w=0.48u l=0.13u
X283 ADDR_N_O<2> a_1619_n1620# VDD VDD sg13_lv_pmos ad=0.3078p pd=2u as=0.3078p ps=2u w=1.62u l=0.13u
X284 a_n89_n2355# a_n599_n2355# VDD VDD sg13_lv_pmos ad=0.18525p pd=1.355u as=0.14812p ps=1.355u w=0.975u l=0.13u
X285 a_3787_n2355# BIST_EN_I a_3251_n2391# VDD sg13_lv_pmos ad=0.18715p pd=1.365u as=0.18715p ps=1.365u w=0.985u l=0.13u
X286 a_2401_n2426# ACLK_N_I VDD VDD sg13_lv_pmos ad=0.1632p pd=1.64u as=0.14812p ps=1.355u w=0.48u l=0.13u
X287 a_523_n1200# a_191_n1540# VDD VDD sg13_lv_pmos ad=0.1881p pd=1.37u as=0.3366p ps=2.66u w=0.99u l=0.13u
X288 a_4399_n675# ADDR_I<7> VDD VDD sg13_lv_pmos ad=0.18715p pd=1.365u as=0.16165p ps=1.365u w=0.985u l=0.13u
X289 VDD a_191_n1540# a_115_n1194# VDD sg13_lv_pmos ad=91.2f pd=0.86u as=91.2f ps=0.86u w=0.48u l=0.13u
X290 a_727_n1198# a_n285_n1582# a_625_n1580# VDD sg13_lv_pmos ad=91.2f pd=0.86u as=0.1511p ps=1.37u w=0.48u l=0.13u
X291 VDD a_4271_n1344# a_4271_n1622# VDD sg13_lv_pmos ad=0.3078p pd=2u as=0.3078p ps=2u w=1.62u l=0.385u
X292 VDD a_1619_n1620# ADDR_N_O<2> VDD sg13_lv_pmos ad=0.3078p pd=2u as=0.3078p ps=2u w=1.62u l=0.13u
X293 VDD a_1041_n1582# ADDR_N_O<4> VDD sg13_lv_pmos ad=0.3078p pd=2u as=0.3078p ps=2u w=1.62u l=0.13u
X294 VSS a_5495_n1622# a_5495_n1344# VSS sg13_lv_nmos ad=0.1577p pd=1.21u as=0.1577p ps=1.21u w=0.83u l=0.13u
X295 VSS a_2838_n405# a_2639_n714# VSS sg13_lv_nmos ad=91.2f pd=0.86u as=0.1632p ps=1.64u w=0.48u l=0.13u
X296 VDD a_5291_n680# a_5215_n582# VDD sg13_lv_pmos ad=91.2f pd=0.86u as=91.2f ps=0.86u w=0.48u l=0.13u
X297 VSS a_4883_n1622# a_4883_n1344# VSS sg13_lv_nmos ad=0.1577p pd=1.21u as=0.1577p ps=1.21u w=0.83u l=0.13u
X298 VSS a_803_n2357# a_727_n1950# VSS sg13_lv_nmos ad=91.2f pd=0.86u as=91.2f ps=0.86u w=0.48u l=0.13u
X299 ADDR_N_O<0> a_1619_n2460# VSS VSS sg13_lv_nmos ad=0.13395p pd=1.085u as=0.13395p ps=1.085u w=0.705u l=0.13u
X300 VSS BIST_EN_I a_n897_n2355# VSS sg13_lv_nmos ad=0.1064p pd=0.94u as=0.1904p ps=1.8u w=0.56u l=0.13u
X301 ADDR_N_O<1> a_1041_n2424# VSS VSS sg13_lv_nmos ad=0.13395p pd=1.085u as=0.13395p ps=1.085u w=0.705u l=0.13u
X302 a_803_n677# a_625_n678# VSS VSS sg13_lv_nmos ad=0.1632p pd=1.64u as=91.2f ps=0.86u w=0.48u l=0.13u
X303 VSS ACLK_N_I a_4815_n675# VSS sg13_lv_nmos ad=0.13717p pd=1.25u as=0.1683p ps=1.67u w=0.495u l=0.13u
X304 a_5725_n678# ACLK_N_I a_5623_n678# VDD sg13_lv_pmos ad=0.1511p pd=1.37u as=0.1881p ps=1.37u w=0.99u l=0.13u
X305 VSS a_1619_n1620# ADDR_N_O<2> VSS sg13_lv_nmos ad=0.13395p pd=1.085u as=0.13395p ps=1.085u w=0.705u l=0.13u
X306 a_3175_n1582# ACLK_N_I a_2838_n1371# VSS sg13_lv_nmos ad=0.1653p pd=1.25u as=0.13605p ps=1.25u w=0.87u l=0.13u
X307 a_5495_n1344# a_5495_n1622# VSS VSS sg13_lv_nmos ad=0.1577p pd=1.21u as=0.1577p ps=1.21u w=0.83u l=0.13u
X308 a_5725_n2358# a_4815_n2355# a_5623_n1992# VSS sg13_lv_nmos ad=0.13375p pd=1.23u as=0.1783p ps=1.44u w=0.85u l=0.13u
X309 ADDR_N_O<3> a_1619_n780# VDD VDD sg13_lv_pmos ad=0.3078p pd=2u as=0.3078p ps=2u w=1.62u l=0.13u
X310 VDD a_1619_n780# ADDR_N_O<3> VDD sg13_lv_pmos ad=0.3078p pd=2u as=0.3078p ps=2u w=1.62u l=0.13u
X311 a_13_n1582# a_n285_n1582# a_n89_n1200# VDD sg13_lv_pmos ad=0.14927p pd=1.355u as=0.18525p ps=1.355u w=0.975u l=0.13u
X312 VSS a_1041_n1582# ADDR_N_O<4> VSS sg13_lv_nmos ad=0.13395p pd=1.085u as=0.13395p ps=1.085u w=0.705u l=0.13u
X313 a_1989_n1403# ACLK_N_I a_2359_n1506# VSS sg13_lv_nmos ad=0.13375p pd=1.23u as=91.2f ps=0.86u w=0.48u l=0.13u
X314 VSS a_191_n2360# a_115_n1952# VSS sg13_lv_nmos ad=91.2f pd=0.86u as=91.2f ps=0.86u w=0.48u l=0.13u
X315 VDD a_6141_n2424# ADDR_N_O<6> VDD sg13_lv_pmos ad=0.3078p pd=2u as=0.3078p ps=2u w=1.62u l=0.13u
X316 a_2563_n270# a_2401_n746# a_1989_n373# VSS sg13_lv_nmos ad=0.1783p pd=1.44u as=0.13375p ps=1.23u w=0.85u l=0.13u
X317 VSS a_625_n1580# a_1041_n1582# VSS sg13_lv_nmos ad=0.13395p pd=1.085u as=0.2397p ps=2.09u w=0.705u l=0.13u
X318 a_3251_n2391# BIST_EN_I a_3583_n1950# VSS sg13_lv_nmos ad=0.1064p pd=0.94u as=0.1064p ps=0.94u w=0.56u l=0.13u
X319 a_13_n2355# ACLK_N_I a_n89_n1952# VSS sg13_lv_nmos ad=0.13605p pd=1.25u as=0.1653p ps=1.25u w=0.87u l=0.13u
X320 a_5011_n2355# a_4501_n2355# VDD VDD sg13_lv_pmos ad=0.18525p pd=1.355u as=0.14812p ps=1.355u w=0.975u l=0.13u
X321 a_2971_n2262# a_2639_n2394# VDD VDD sg13_lv_pmos ad=91.2f pd=0.86u as=91.2f ps=0.86u w=0.48u l=0.13u
X322 a_1619_n2460# a_1989_n2053# VDD VDD sg13_lv_pmos ad=0.5508p pd=3.92u as=0.3078p ps=2u w=1.62u l=0.13u
X323 ADDR_N_O<5> a_1041_n744# VDD VDD sg13_lv_pmos ad=0.3078p pd=2u as=0.3078p ps=2u w=1.62u l=0.13u
X324 a_2971_n582# a_2639_n714# VDD VDD sg13_lv_pmos ad=91.2f pd=0.86u as=91.2f ps=0.86u w=0.48u l=0.13u
X325 a_n89_n1200# a_n599_n1522# VDD VDD sg13_lv_pmos ad=0.18525p pd=1.355u as=0.14812p ps=1.355u w=0.975u l=0.13u
X326 a_4603_n2355# a_4203_n2355# a_4501_n2355# VDD sg13_lv_pmos ad=0.18715p pd=1.365u as=0.18715p ps=1.365u w=0.985u l=0.13u
X327 ADDR_N_O<5> a_1041_n744# VSS VSS sg13_lv_nmos ad=0.13395p pd=1.085u as=0.13395p ps=1.085u w=0.705u l=0.13u
X328 VSS a_1619_n780# ADDR_N_O<3> VSS sg13_lv_nmos ad=0.13395p pd=1.085u as=0.13395p ps=1.085u w=0.705u l=0.13u
X329 a_5291_n2360# a_5113_n2355# VSS VSS sg13_lv_nmos ad=0.1632p pd=1.64u as=91.2f ps=0.86u w=0.48u l=0.13u
X330 a_n497_n270# BIST_EN_I a_n599_n675# VSS sg13_lv_nmos ad=0.1064p pd=0.94u as=0.1064p ps=0.94u w=0.56u l=0.13u
X331 VSS a_625_n678# a_1041_n744# VSS sg13_lv_nmos ad=0.13395p pd=1.085u as=0.2397p ps=2.09u w=0.705u l=0.13u
X332 VDD a_191_n680# a_115_n582# VDD sg13_lv_pmos ad=91.2f pd=0.86u as=91.2f ps=0.86u w=0.48u l=0.13u
X333 VDD ACLK_N_I a_n285_n1582# VDD sg13_lv_pmos ad=0.14812p pd=1.355u as=0.1632p ps=1.64u w=0.48u l=0.13u
X334 a_4883_n1344# a_4883_n1622# VSS VSS sg13_lv_nmos ad=0.1577p pd=1.21u as=0.1577p ps=1.21u w=0.83u l=0.13u
X335 a_n89_n1952# a_n599_n2355# VSS VSS sg13_lv_nmos ad=0.1653p pd=1.25u as=0.13717p ps=1.25u w=0.87u l=0.13u
X336 a_625_n678# ACLK_N_I a_523_n678# VDD sg13_lv_pmos ad=0.1511p pd=1.37u as=0.1881p ps=1.37u w=0.99u l=0.13u
X337 a_3175_n272# ACLK_N_I a_2838_n405# VSS sg13_lv_nmos ad=0.1653p pd=1.25u as=0.13605p ps=1.25u w=0.87u l=0.13u
X338 VSS a_3251_n1620# a_3175_n1582# VSS sg13_lv_nmos ad=0.13717p pd=1.25u as=0.1653p ps=1.25u w=0.87u l=0.13u
X339 a_n497_n1950# BIST_EN_I a_n599_n2355# VSS sg13_lv_nmos ad=0.1064p pd=0.94u as=0.1064p ps=0.94u w=0.56u l=0.13u
X340 VDD a_2639_n714# a_2563_n678# VDD sg13_lv_pmos ad=0.3366p pd=2.66u as=0.1881p ps=1.37u w=0.99u l=0.13u
X341 VDD a_6141_n744# ADDR_N_O<7> VDD sg13_lv_pmos ad=0.5508p pd=3.92u as=0.3078p ps=2u w=1.62u l=0.13u
X342 a_n599_n1522# BIST_EN_I a_n701_n1202# VDD sg13_lv_pmos ad=0.18715p pd=1.365u as=0.18715p ps=1.365u w=0.985u l=0.13u
X343 VDD a_5495_n1344# a_5495_n1622# VDD sg13_lv_pmos ad=0.3078p pd=2u as=0.3078p ps=2u w=1.62u l=0.385u
X344 a_5903_n2357# a_5725_n2358# VDD VDD sg13_lv_pmos ad=0.1632p pd=1.64u as=91.2f ps=0.86u w=0.48u l=0.13u
X345 a_3787_n1950# a_3624_n2429# a_3251_n2391# VSS sg13_lv_nmos ad=0.1064p pd=0.94u as=0.1064p ps=0.94u w=0.56u l=0.13u
X346 a_2563_n2358# ACLK_N_I a_1989_n2053# VDD sg13_lv_pmos ad=0.1881p pd=1.37u as=0.1511p ps=1.37u w=0.99u l=0.13u
X347 a_1989_n2053# a_2401_n2426# a_2359_n2258# VDD sg13_lv_pmos ad=0.1511p pd=1.37u as=91.2f ps=0.86u w=0.48u l=0.13u
X348 a_3787_n270# a_3624_n749# a_3251_n711# VSS sg13_lv_nmos ad=0.1064p pd=0.94u as=0.1064p ps=0.94u w=0.56u l=0.13u
X349 ADDR_N_O<4> a_1041_n1582# VSS VSS sg13_lv_nmos ad=0.13395p pd=1.085u as=0.13395p ps=1.085u w=0.705u l=0.13u
X350 a_4271_n1622# a_4271_n1344# VDD VDD sg13_lv_pmos ad=0.3078p pd=2u as=0.3078p ps=2u w=1.62u l=0.385u
X351 a_n599_n675# BIST_EN_I a_n701_n675# VDD sg13_lv_pmos ad=0.18715p pd=1.365u as=0.18715p ps=1.365u w=0.985u l=0.13u
X352 VSS a_803_n1620# a_727_n1506# VSS sg13_lv_nmos ad=91.2f pd=0.86u as=91.2f ps=0.86u w=0.48u l=0.13u
X353 VDD ADDR_I<2> a_3787_n1202# VDD sg13_lv_pmos ad=0.16165p pd=1.365u as=0.18715p ps=1.365u w=0.985u l=0.13u
X354 VSS a_6141_n744# ADDR_N_O<7> VSS sg13_lv_nmos ad=0.13395p pd=1.085u as=0.13395p ps=1.085u w=0.705u l=0.13u
X355 a_6107_n1622# a_6107_n1344# VDD VDD sg13_lv_pmos ad=0.3078p pd=2u as=0.3078p ps=2u w=1.62u l=0.385u
X356 VSS a_6141_n2424# ADDR_N_O<6> VSS sg13_lv_nmos ad=0.2397p pd=2.09u as=0.13395p ps=1.085u w=0.705u l=0.13u
X357 VDD BIST_EN_I a_4203_n2355# VDD sg13_lv_pmos ad=0.16165p pd=1.365u as=0.2193p ps=1.97u w=0.645u l=0.13u
X358 a_1619_n780# a_1989_n373# VSS VSS sg13_lv_nmos ad=0.2397p pd=2.09u as=0.13395p ps=1.085u w=0.705u l=0.13u
X359 VDD ADDR_I<3> a_3787_n675# VDD sg13_lv_pmos ad=0.16165p pd=1.365u as=0.18715p ps=1.365u w=0.985u l=0.13u
X360 VSS a_5725_n2358# a_6141_n2424# VSS sg13_lv_nmos ad=0.13395p pd=1.085u as=0.2397p ps=2.09u w=0.705u l=0.13u
X361 a_803_n677# a_625_n678# VDD VDD sg13_lv_pmos ad=0.1632p pd=1.64u as=91.2f ps=0.86u w=0.48u l=0.13u
X362 a_3583_n675# BIST_ADDR_I<3> VDD VDD sg13_lv_pmos ad=0.18715p pd=1.365u as=0.3349p ps=2.65u w=0.985u l=0.13u
X363 VSS BIST_EN_I a_n897_n1522# VSS sg13_lv_nmos ad=0.1064p pd=0.94u as=0.1904p ps=1.8u w=0.56u l=0.13u
X364 a_2971_n1194# a_2639_n1574# VDD VDD sg13_lv_pmos ad=91.2f pd=0.86u as=91.2f ps=0.86u w=0.48u l=0.13u
X365 a_625_n2358# ACLK_N_I a_523_n2358# VDD sg13_lv_pmos ad=0.1511p pd=1.37u as=0.1881p ps=1.37u w=0.99u l=0.13u
X366 a_4271_n1622# a_4271_n1344# VDD VDD sg13_lv_pmos ad=0.3078p pd=2u as=0.5508p ps=3.92u w=1.62u l=0.385u
X367 ADDR_N_O<0> a_1619_n2460# VDD VDD sg13_lv_pmos ad=0.3078p pd=2u as=0.3078p ps=2u w=1.62u l=0.13u
X368 a_4399_n270# ADDR_I<7> VSS VSS sg13_lv_nmos ad=0.1064p pd=0.94u as=0.1064p ps=0.94u w=0.56u l=0.13u
X369 a_3251_n1620# BIST_EN_I a_3583_n1522# VSS sg13_lv_nmos ad=0.1064p pd=0.94u as=0.1064p ps=0.94u w=0.56u l=0.13u
X370 VDD a_803_n2357# a_727_n2258# VDD sg13_lv_pmos ad=91.2f pd=0.86u as=91.2f ps=0.86u w=0.48u l=0.13u
X371 a_4883_n1344# a_4883_n1622# VSS VSS sg13_lv_nmos ad=0.1577p pd=1.21u as=0.1577p ps=1.21u w=0.83u l=0.13u
X372 ADDR_N_O<6> a_6141_n2424# VSS VSS sg13_lv_nmos ad=0.13395p pd=1.085u as=0.13395p ps=1.085u w=0.705u l=0.13u
X373 a_5011_n1952# a_4501_n2355# VSS VSS sg13_lv_nmos ad=0.1653p pd=1.25u as=0.13717p ps=1.25u w=0.87u l=0.13u
X374 a_191_n2360# a_13_n2355# VDD VDD sg13_lv_pmos ad=0.1632p pd=1.64u as=91.2f ps=0.86u w=0.48u l=0.13u
X375 a_115_n2262# ACLK_N_I a_13_n2355# VDD sg13_lv_pmos ad=91.2f pd=0.86u as=0.14927p ps=1.355u w=0.48u l=0.13u
.ends

.subckt RM_IHPSG13_1P_BLDRV VDD VSS PRE_N WR_ZERO WR_ONE SEL_P BLC BLT BLC_SEL BLT_SEL
+ VDD_uq0
X0 VSS SEL_P a_115_n294# VSS sg13_lv_nmos ad=0.1862p pd=1.36u as=0.1862p ps=1.36u w=0.98u l=0.13u
X1 a_89_945# SEL_P VSS VSS sg13_lv_nmos ad=0.5831p pd=3.15u as=0.1862p ps=1.36u w=0.98u l=0.13u
X2 VDD_uq0 SEL_P a_21_n294# VDD_uq0 sg13_lv_pmos ad=0.3078p pd=2u as=0.3078p ps=2u w=1.62u l=0.13u
X3 VDD a_21_n294# BLT VDD sg13_lv_pmos ad=0.285p pd=1.88u as=0.285p ps=1.88u w=1.5u l=0.13u
X4 a_115_n294# WR_ONE a_21_n294# VSS sg13_lv_nmos ad=0.1862p pd=1.36u as=0.3332p ps=2.64u w=0.98u l=0.13u
X5 a_21_n294# WR_ONE VDD_uq0 VDD_uq0 sg13_lv_pmos ad=0.3078p pd=2u as=0.5508p ps=3.92u w=1.62u l=0.13u
X6 VSS a_21_1865# BLT VSS sg13_lv_nmos ad=0.4579p pd=2.79u as=0.4579p ps=2.79u w=2.41u l=0.13u
X7 a_319_n294# SEL_P VSS VSS sg13_lv_nmos ad=0.1862p pd=1.36u as=0.1862p ps=1.36u w=0.98u l=0.13u
X8 VDD PRE_N BLT VDD sg13_lv_pmos ad=0.285p pd=1.88u as=0.285p ps=1.88u w=1.5u l=0.13u
X9 a_293_60# SEL_P VDD_uq0 VDD_uq0 sg13_lv_pmos ad=0.3078p pd=2u as=0.3078p ps=2u w=1.62u l=0.13u
X10 BLT a_89_945# BLT_SEL VDD sg13_lv_pmos ad=0.285p pd=1.88u as=0.51p ps=3.68u w=1.5u l=0.13u
X11 BLT a_21_1865# VSS VSS sg13_lv_nmos ad=0.4579p pd=2.79u as=0.8194p ps=5.5u w=2.41u l=0.13u
X12 BLC a_293_60# VDD VDD sg13_lv_pmos ad=0.285p pd=1.88u as=0.285p ps=1.88u w=1.5u l=0.13u
X13 VSS a_293_60# a_21_1865# VSS sg13_lv_nmos ad=0.1862p pd=1.36u as=0.3332p ps=2.64u w=0.98u l=0.13u
X14 BLT PRE_N VDD VDD sg13_lv_pmos ad=0.285p pd=1.88u as=0.51p ps=3.68u w=1.5u l=0.13u
X15 BLC a_115_98# VSS VSS sg13_lv_nmos ad=0.4579p pd=2.79u as=0.4579p ps=2.79u w=2.41u l=0.13u
X16 a_293_60# WR_ZERO a_319_n294# VSS sg13_lv_nmos ad=0.3332p pd=2.64u as=0.1862p ps=1.36u w=0.98u l=0.13u
X17 BLC PRE_N VDD VDD sg13_lv_pmos ad=0.285p pd=1.88u as=0.285p ps=1.88u w=1.5u l=0.13u
X18 VDD a_293_60# a_21_1865# VDD sg13_lv_pmos ad=0.3078p pd=2u as=0.5508p ps=3.92u w=1.62u l=0.13u
X19 VDD_uq0 WR_ZERO a_293_60# VDD_uq0 sg13_lv_pmos ad=0.5508p pd=3.92u as=0.3078p ps=2u w=1.62u l=0.13u
X20 a_89_945# SEL_P VDD VDD sg13_lv_pmos ad=0.9639p pd=4.43u as=0.3078p ps=2u w=1.62u l=0.13u
X21 BLC_SEL a_89_945# BLC VDD sg13_lv_pmos ad=0.51p pd=3.68u as=0.285p ps=1.88u w=1.5u l=0.13u
X22 VSS a_115_98# BLC VSS sg13_lv_nmos ad=0.8194p pd=5.5u as=0.4579p ps=2.79u w=2.41u l=0.13u
X23 a_115_98# a_21_n294# VSS VSS sg13_lv_nmos ad=0.3332p pd=2.64u as=0.3332p ps=2.64u w=0.98u l=0.13u
X24 VDD PRE_N BLC VDD sg13_lv_pmos ad=0.51p pd=3.68u as=0.285p ps=1.88u w=1.5u l=0.13u
X25 a_115_98# a_21_n294# VDD VDD sg13_lv_pmos ad=0.5508p pd=3.92u as=0.5508p ps=3.92u w=1.62u l=0.13u
.ends

.subckt RM_IHPSG13_1P_COLCTRL2 A_BLT<0> A_BIST_DW_I A_BLC<3> A_DW_I A_BLT<1> A_BLT<2>
+ A_BLC<0> A_BIST_BM_I A_DR_O A_BLC<2> A_BLC<1> A_BLT<3> A_BM_I A_TIEH_O A_WCLK_B_R
+ A_ADDR_DEC<3> A_WCLK_L A_DCLK_L A_WCLK_B_L A_WCLK_R A_DCLK_R A_RCLK_L A_ADDR_DEC<1>
+ A_RCLK_B_L A_RCLK_B_R A_ADDR_DEC<2> A_DCLK_B_R A_ADDR_DEC<0> A_RCLK_R A_BIST_EN_I
+ A_DCLK_B_L m3_0_n5090# m3_0_n4988# VSS m3_0_n5294# m3_0_n4478# m3_0_n5192# VDD
XRM_IHPSG13_1P_BLDRV_0[0] VDD VSS RM_IHPSG13_1P_BLDRV_1[1]/PRE_N RM_IHPSG13_1P_BLDRV_1[1]/WR_ZERO
+ RM_IHPSG13_1P_BLDRV_1[1]/WR_ONE A_ADDR_DEC<0> A_BLC<0> A_BLT<0> RM_IHPSG13_1P_BLDRV_1[1]/BLC_SEL
+ RM_IHPSG13_1P_BLDRV_1[1]/BLT_SEL VDD RM_IHPSG13_1P_BLDRV
XRM_IHPSG13_1P_BLDRV_0[1] VDD VSS RM_IHPSG13_1P_BLDRV_1[1]/PRE_N RM_IHPSG13_1P_BLDRV_1[1]/WR_ZERO
+ RM_IHPSG13_1P_BLDRV_1[1]/WR_ONE A_ADDR_DEC<2> A_BLC<2> A_BLT<2> RM_IHPSG13_1P_BLDRV_1[1]/BLC_SEL
+ RM_IHPSG13_1P_BLDRV_1[1]/BLT_SEL VDD RM_IHPSG13_1P_BLDRV
XRM_IHPSG13_1P_BLDRV_1[0] VDD VSS RM_IHPSG13_1P_BLDRV_1[1]/PRE_N RM_IHPSG13_1P_BLDRV_1[1]/WR_ZERO
+ RM_IHPSG13_1P_BLDRV_1[1]/WR_ONE A_ADDR_DEC<3> A_BLC<3> A_BLT<3> RM_IHPSG13_1P_BLDRV_1[1]/BLC_SEL
+ RM_IHPSG13_1P_BLDRV_1[1]/BLT_SEL VDD RM_IHPSG13_1P_BLDRV
XRM_IHPSG13_1P_BLDRV_1[1] VDD VSS RM_IHPSG13_1P_BLDRV_1[1]/PRE_N RM_IHPSG13_1P_BLDRV_1[1]/WR_ZERO
+ RM_IHPSG13_1P_BLDRV_1[1]/WR_ONE A_ADDR_DEC<1> A_BLC<1> A_BLT<1> RM_IHPSG13_1P_BLDRV_1[1]/BLC_SEL
+ RM_IHPSG13_1P_BLDRV_1[1]/BLT_SEL VDD RM_IHPSG13_1P_BLDRV
X0 VDD a_1313_n4980# RM_IHPSG13_1P_BLDRV_1[1]/PRE_N VDD sg13_lv_pmos ad=0.5508p pd=3.92u as=0.3078p ps=2u w=1.62u l=0.13u
X1 VDD A_BIST_BM_I a_523_n9075# VDD sg13_lv_pmos ad=0.3349p pd=2.65u as=0.18715p ps=1.365u w=0.985u l=0.13u
X2 VDD a_225_n6984# a_263_n7064# VDD sg13_lv_pmos ad=0.3078p pd=2u as=0.3078p ps=2u w=1.62u l=0.385u
X3 a_931_n9075# a_421_n9075# VDD VDD sg13_lv_pmos ad=0.18525p pd=1.355u as=0.14812p ps=1.355u w=0.975u l=0.13u
X4 VDD a_154_n4732# a_21_n4942# VDD sg13_lv_pmos ad=0.2508p pd=2u as=0.1634p ps=1.24u w=0.86u l=0.13u
X5 VSS a_154_n4732# a_115_n4942# VSS sg13_lv_nmos ad=0.1502p pd=1.36u as=95f ps=0.88u w=0.5u l=0.13u
X6 VSS a_1619_n4980# a_1313_n4980# VSS sg13_lv_nmos ad=0.1502p pd=1.36u as=0.3332p ps=2.64u w=0.98u l=0.13u
X7 a_225_n6984# a_263_n7064# VSS VSS sg13_lv_nmos ad=0.1577p pd=1.21u as=0.1577p ps=1.21u w=0.83u l=0.13u
X8 VSS a_1313_n8340# a_1237_n8302# VSS sg13_lv_nmos ad=0.13717p pd=1.25u as=0.1653p ps=1.25u w=0.87u l=0.13u
X9 a_900_n8091# a_463_n7750# a_1033_n8224# VSS sg13_lv_nmos ad=0.13605p pd=1.25u as=91.2f ps=0.86u w=0.48u l=0.13u
X10 a_1645_n8242# A_BIST_DW_I VSS VSS sg13_lv_nmos ad=0.1064p pd=0.94u as=0.1904p ps=1.8u w=0.56u l=0.13u
X11 VSS a_599_n7024# a_599_n7500# VSS sg13_lv_nmos ad=0.1577p pd=1.21u as=0.1577p ps=1.21u w=0.83u l=0.13u
X12 VDD a_89_n8340# a_21_n8302# VDD sg13_lv_pmos ad=0.5508p pd=3.92u as=0.5508p ps=3.92u w=1.62u l=0.13u
X13 a_319_n9075# A_BM_I VDD VDD sg13_lv_pmos ad=0.18715p pd=1.365u as=0.16165p ps=1.365u w=0.985u l=0.13u
X14 a_1619_n4980# A_RCLK_B_R VDD VDD sg13_lv_pmos ad=0.1634p pd=1.24u as=0.2508p ps=2u w=0.86u l=0.13u
X15 a_1747_n4942# A_RCLK_B_R VSS VSS sg13_lv_nmos ad=95f pd=0.88u as=0.1502p ps=1.36u w=0.5u l=0.13u
X16 VDD a_481_n5378# a_293_n6660# VDD sg13_lv_pmos ad=0.171p pd=1.28u as=0.306p ps=2.48u w=0.9u l=0.13u
X17 a_1925_n7500# a_1925_n7024# VSS VSS sg13_lv_nmos ad=0.1577p pd=1.21u as=0.1577p ps=1.21u w=0.83u l=0.13u
X18 RM_IHPSG13_1P_BLDRV_1[1]/PRE_N a_1313_n4980# VSS VSS sg13_lv_nmos ad=0.31725p pd=2.31u as=0.2397p ps=2.09u w=0.705u l=0.13u
X19 a_1747_n8978# a_735_n9075# a_1645_n9078# VDD sg13_lv_pmos ad=91.2f pd=0.86u as=0.1511p ps=1.37u w=0.48u l=0.13u
X20 VDD a_1551_n6984# a_1589_n7064# VDD sg13_lv_pmos ad=0.3078p pd=2u as=0.3078p ps=2u w=1.62u l=0.385u
X21 a_1543_n8712# a_1211_n9080# VSS VSS sg13_lv_nmos ad=0.1783p pd=1.44u as=0.289p ps=2.38u w=0.85u l=0.13u
X22 a_1313_n8340# A_BIST_EN_I a_1645_n8242# VSS sg13_lv_nmos ad=0.1064p pd=0.94u as=0.1064p ps=0.94u w=0.56u l=0.13u
X23 VDD a_1143_n6984# a_1181_n7064# VDD sg13_lv_pmos ad=0.5508p pd=3.92u as=0.3078p ps=2u w=1.62u l=0.385u
X24 VSS a_293_n6660# A_DR_O VSS sg13_lv_nmos ad=0.3332p pd=2.64u as=0.1862p ps=1.36u w=0.98u l=0.13u
X25 a_1135_n5784# a_481_n5378# a_441_n5469# VSS sg13_lv_nmos ad=0.408p pd=3.08u as=0.228p ps=1.58u w=1.2u l=0.2u
X26 a_727_n6622# a_481_n5378# VSS VSS sg13_lv_nmos ad=0.1862p pd=1.36u as=0.3332p ps=2.64u w=0.98u l=0.13u
X27 a_1033_n9075# a_735_n9075# a_931_n9075# VDD sg13_lv_pmos ad=0.14927p pd=1.355u as=0.18525p ps=1.355u w=0.975u l=0.13u
X28 a_2092_n4732# a_1645_n9078# VSS VSS sg13_lv_nmos ad=0.3332p pd=2.64u as=0.3332p ps=2.64u w=0.98u l=0.13u
X29 a_931_n8672# a_421_n9075# VSS VSS sg13_lv_nmos ad=0.1653p pd=1.25u as=0.13717p ps=1.25u w=0.87u l=0.13u
X30 VSS A_BIST_BM_I a_523_n8670# VSS sg13_lv_nmos ad=0.1904p pd=1.8u as=0.1064p ps=0.94u w=0.56u l=0.13u
X31 VSS a_1181_n7064# a_1143_n6984# VSS sg13_lv_nmos ad=0.1577p pd=1.21u as=0.2822p ps=2.34u w=0.83u l=0.13u
X32 a_1823_n6660# A_RCLK_B_R VSS VSS sg13_lv_nmos ad=0.1836p pd=1.76u as=0.12157p ps=1.085u w=0.54u l=0.13u
X33 VSS a_2092_n4732# a_154_n4732# VSS sg13_lv_nmos ad=0.3332p pd=2.64u as=0.1862p ps=1.36u w=0.98u l=0.13u
X34 VDD a_441_n5469# a_803_n6660# VDD sg13_lv_pmos ad=0.171p pd=1.28u as=0.171p ps=1.28u w=0.9u l=0.13u
R0 A_WCLK_L A_WCLK_R 0.203077
X35 a_2092_n4732# a_1645_n9078# VDD VDD sg13_lv_pmos ad=0.5508p pd=3.92u as=0.5508p ps=3.92u w=1.62u l=0.13u
X36 VDD a_89_n8340# a_225_n8226# VDD sg13_lv_pmos ad=91.2f pd=0.86u as=0.1632p ps=1.64u w=0.48u l=0.13u
X37 a_319_n8670# A_BM_I VSS VSS sg13_lv_nmos ad=0.1064p pd=0.94u as=0.1064p ps=0.94u w=0.56u l=0.13u
X38 VDD a_701_n8294# a_625_n7920# VDD sg13_lv_pmos ad=0.3366p pd=2.66u as=0.1881p ps=1.37u w=0.99u l=0.13u
X39 VSS A_DCLK_B_L a_735_n9075# VSS sg13_lv_nmos ad=0.13717p pd=1.25u as=0.1683p ps=1.67u w=0.495u l=0.13u
X40 VDD A_DW_I a_1849_n7922# VDD sg13_lv_pmos ad=0.16165p pd=1.365u as=0.18715p ps=1.365u w=0.985u l=0.13u
X41 a_1925_n7024# a_1925_n7500# VDD VDD sg13_lv_pmos ad=0.3078p pd=2u as=0.3078p ps=2u w=1.62u l=0.385u
X42 a_900_n8091# A_DCLK_B_L a_1033_n7914# VDD sg13_lv_pmos ad=0.14927p pd=1.355u as=91.2f ps=0.86u w=0.48u l=0.13u
X43 VSS a_89_n8340# a_21_n8302# VSS sg13_lv_nmos ad=0.3332p pd=2.64u as=0.3332p ps=2.64u w=0.98u l=0.13u
X44 VSS a_1823_n9077# a_1747_n8670# VSS sg13_lv_nmos ad=91.2f pd=0.86u as=91.2f ps=0.86u w=0.48u l=0.13u
X45 a_1033_n9075# A_DCLK_B_L a_931_n8672# VSS sg13_lv_nmos ad=0.13605p pd=1.25u as=0.1653p ps=1.25u w=0.87u l=0.13u
X46 VSS a_1925_n7024# a_1925_n7500# VSS sg13_lv_nmos ad=0.1577p pd=1.21u as=0.1577p ps=1.21u w=0.83u l=0.13u
X47 RM_IHPSG13_1P_BLDRV_1[1]/WR_ONE a_633_n4942# VSS VSS sg13_lv_nmos ad=0.3332p pd=2.64u as=0.1502p ps=1.36u w=0.98u l=0.13u
X48 a_1181_n7064# a_1143_n6984# VDD VDD sg13_lv_pmos ad=0.3078p pd=2u as=0.5508p ps=3.92u w=1.62u l=0.385u
X49 a_21_n4942# a_21_n8302# VDD VDD sg13_lv_pmos ad=0.1634p pd=1.24u as=0.2924p ps=2.4u w=0.86u l=0.13u
X50 a_707_n5378# RM_IHPSG13_1P_BLDRV_1[1]/BLC_SEL a_373_n5378# VSS sg13_lv_nmos ad=0.228p pd=1.58u as=0.228p ps=1.58u w=1.2u l=0.2u
X51 VSS a_89_n8340# a_225_n8226# VSS sg13_lv_nmos ad=91.2f pd=0.86u as=0.1632p ps=1.64u w=0.48u l=0.13u
X52 a_115_n4942# a_21_n8302# a_21_n4942# VSS sg13_lv_nmos ad=95f pd=0.88u as=0.17p ps=1.68u w=0.5u l=0.13u
X53 a_481_n5378# a_441_n5469# VDD VDD sg13_lv_pmos ad=0.152p pd=1.18u as=0.3p ps=2.35u w=0.8u l=0.13u
X54 RM_IHPSG13_1P_BLDRV_1[1]/WR_ZERO a_21_n4942# VSS VSS sg13_lv_nmos ad=0.3332p pd=2.64u as=0.1502p ps=1.36u w=0.98u l=0.13u
X55 VSS a_263_n7064# a_225_n6984# VSS sg13_lv_nmos ad=0.1577p pd=1.21u as=0.1577p ps=1.21u w=0.83u l=0.13u
X56 a_463_n7750# A_DCLK_B_L VSS VSS sg13_lv_nmos ad=0.1683p pd=1.67u as=0.13717p ps=1.25u w=0.495u l=0.13u
X57 a_1237_n7920# a_463_n7750# a_900_n8091# VDD sg13_lv_pmos ad=0.18525p pd=1.355u as=0.14927p ps=1.355u w=0.975u l=0.13u
X58 VSS a_701_n5820# a_707_n5378# VSS sg13_lv_nmos ad=0.228p pd=1.58u as=0.228p ps=1.58u w=1.2u l=0.13u
X59 a_599_n7500# a_599_n7024# VSS VSS sg13_lv_nmos ad=0.2822p pd=2.34u as=0.1577p ps=1.21u w=0.83u l=0.13u
X60 a_421_n9075# A_BIST_EN_I a_319_n9075# VDD sg13_lv_pmos ad=0.18715p pd=1.365u as=0.18715p ps=1.365u w=0.985u l=0.13u
R1 A_DCLK_L A_DCLK_R 0.203077
X61 a_1135_n8982# A_DCLK_B_L a_1033_n9075# VDD sg13_lv_pmos ad=91.2f pd=0.86u as=0.14927p ps=1.355u w=0.48u l=0.13u
X62 VDD A_WCLK_B_R a_1619_n4980# VDD sg13_lv_pmos ad=0.2924p pd=2.4u as=0.1634p ps=1.24u w=0.86u l=0.13u
X63 a_1619_n4980# A_WCLK_B_R a_1747_n4942# VSS sg13_lv_nmos ad=0.17p pd=1.68u as=95f ps=0.88u w=0.5u l=0.13u
X64 A_WCLK_B_R A_WCLK_L VDD VDD sg13_lv_pmos ad=0.5508p pd=3.92u as=0.5508p ps=3.92u w=1.62u l=0.13u
X65 VDD a_1823_n9077# a_1747_n8978# VDD sg13_lv_pmos ad=91.2f pd=0.86u as=91.2f ps=0.86u w=0.48u l=0.13u
X66 VSS a_1589_n7064# a_1551_n6984# VSS sg13_lv_nmos ad=0.1577p pd=1.21u as=0.2822p ps=2.34u w=0.83u l=0.13u
X67 a_1849_n8242# a_1686_n7711# a_1313_n8340# VSS sg13_lv_nmos ad=0.1064p pd=0.94u as=0.1064p ps=0.94u w=0.56u l=0.13u
X68 A_DCLK_B_L A_DCLK_L VSS VSS sg13_lv_nmos ad=0.2397p pd=2.09u as=0.2397p ps=2.09u w=0.705u l=0.13u
X69 VSS a_701_n8294# a_625_n8300# VSS sg13_lv_nmos ad=0.289p pd=2.38u as=0.1783p ps=1.44u w=0.85u l=0.13u
X70 VDD a_1211_n9080# a_1135_n8982# VDD sg13_lv_pmos ad=91.2f pd=0.86u as=91.2f ps=0.86u w=0.48u l=0.13u
X71 a_293_n6660# a_803_n6660# a_727_n6622# VSS sg13_lv_nmos ad=0.3332p pd=2.64u as=0.1862p ps=1.36u w=0.98u l=0.13u
X72 a_1543_n9078# a_1211_n9080# VDD VDD sg13_lv_pmos ad=0.1881p pd=1.37u as=0.3366p ps=2.66u w=0.99u l=0.13u
X73 a_441_n5469# a_701_n5820# VDD VDD sg13_lv_pmos ad=0.152p pd=1.18u as=0.3p ps=2.35u w=0.8u l=0.13u
X74 a_1551_n6984# a_1589_n7064# VSS VSS sg13_lv_nmos ad=0.1577p pd=1.21u as=0.1577p ps=1.21u w=0.83u l=0.13u
X75 VDD a_701_n5820# a_373_n5378# VDD sg13_lv_pmos ad=0.152p pd=1.18u as=0.348p ps=2.47u w=0.8u l=0.13u
X76 a_625_n8300# a_463_n7750# a_89_n8340# VSS sg13_lv_nmos ad=0.1783p pd=1.44u as=0.13375p ps=1.23u w=0.85u l=0.13u
X77 a_1143_n6984# a_1181_n7064# VSS VSS sg13_lv_nmos ad=0.1577p pd=1.21u as=0.1577p ps=1.21u w=0.83u l=0.13u
X78 VSS A_RCLK_R A_RCLK_B_R VSS sg13_lv_nmos ad=0.2397p pd=2.09u as=0.2397p ps=2.09u w=0.705u l=0.13u
X79 a_293_n6660# a_481_n5378# VDD VDD sg13_lv_pmos ad=0.171p pd=1.28u as=0.171p ps=1.28u w=0.9u l=0.13u
X80 a_2053_n4620# A_WCLK_B_R VDD VDD sg13_lv_pmos ad=0.3078p pd=2u as=0.5508p ps=3.92u w=1.62u l=0.13u
X81 a_1686_n7711# A_BIST_EN_I VDD VDD sg13_lv_pmos ad=0.2193p pd=1.97u as=0.16165p ps=1.365u w=0.645u l=0.13u
X82 a_441_n5469# a_481_n5378# a_1135_n5784# VSS sg13_lv_nmos ad=0.228p pd=1.58u as=0.408p ps=3.08u w=1.2u l=0.2u
X83 a_803_n6660# a_441_n5469# VDD VDD sg13_lv_pmos ad=0.306p pd=2.48u as=0.171p ps=1.28u w=0.9u l=0.13u
X84 a_421_n7918# a_225_n8226# VDD VDD sg13_lv_pmos ad=91.2f pd=0.86u as=91.2f ps=0.86u w=0.48u l=0.13u
X85 a_421_n9075# a_123_n9075# a_319_n8670# VSS sg13_lv_nmos ad=0.1064p pd=0.94u as=0.1064p ps=0.94u w=0.56u l=0.13u
X86 a_1589_n7064# a_1551_n6984# VDD VDD sg13_lv_pmos ad=0.3078p pd=2u as=0.5508p ps=3.92u w=1.62u l=0.385u
X87 a_1339_n6622# a_293_n6660# a_803_n6660# VSS sg13_lv_nmos ad=0.1862p pd=1.36u as=0.3332p ps=2.64u w=0.98u l=0.13u
X88 a_1645_n7922# A_BIST_DW_I VDD VDD sg13_lv_pmos ad=0.18715p pd=1.365u as=0.3349p ps=2.65u w=0.985u l=0.13u
X89 a_707_n5378# RM_IHPSG13_1P_BLDRV_1[1]/BLT_SEL a_1135_n5784# VSS sg13_lv_nmos ad=0.408p pd=3.08u as=0.228p ps=1.58u w=1.2u l=0.2u
R2 A_RCLK_L A_RCLK_R 0.203077
X90 a_1135_n8672# a_735_n9075# a_1033_n9075# VSS sg13_lv_nmos ad=91.2f pd=0.86u as=0.13605p ps=1.25u w=0.48u l=0.13u
X91 a_1823_n9077# a_1645_n9078# VSS VSS sg13_lv_nmos ad=0.1632p pd=1.64u as=91.2f ps=0.86u w=0.48u l=0.13u
X92 VSS a_900_n8091# a_701_n8294# VSS sg13_lv_nmos ad=91.2f pd=0.86u as=0.1632p ps=1.64u w=0.48u l=0.13u
X93 a_1925_n7500# a_1925_n7024# VSS VSS sg13_lv_nmos ad=0.2822p pd=2.34u as=0.1577p ps=1.21u w=0.83u l=0.13u
X94 VDD a_1619_n4980# a_1313_n4980# VDD sg13_lv_pmos ad=0.2508p pd=2u as=0.5508p ps=3.92u w=1.62u l=0.13u
X95 a_1313_n8340# a_1686_n7711# a_1645_n7922# VDD sg13_lv_pmos ad=0.18715p pd=1.365u as=0.18715p ps=1.365u w=0.985u l=0.13u
X96 A_DR_O a_293_n6660# VDD VDD sg13_lv_pmos ad=0.3078p pd=2u as=0.5508p ps=3.92u w=1.62u l=0.13u
X97 a_421_n8226# a_225_n8226# VSS VSS sg13_lv_nmos ad=91.2f pd=0.86u as=91.2f ps=0.86u w=0.48u l=0.13u
X98 VSS a_1211_n9080# a_1135_n8672# VSS sg13_lv_nmos ad=91.2f pd=0.86u as=91.2f ps=0.86u w=0.48u l=0.13u
X99 a_707_n5378# a_701_n5820# VSS VSS sg13_lv_nmos ad=0.228p pd=1.58u as=0.228p ps=1.58u w=1.2u l=0.13u
X100 a_599_n7500# a_599_n7024# VSS VSS sg13_lv_nmos ad=0.1577p pd=1.21u as=0.1577p ps=1.21u w=0.83u l=0.13u
X101 VDD a_1313_n8340# a_1237_n7920# VDD sg13_lv_pmos ad=0.14812p pd=1.355u as=0.18525p ps=1.355u w=0.975u l=0.13u
X102 a_633_n4942# a_89_n8340# VDD VDD sg13_lv_pmos ad=0.1634p pd=1.24u as=0.2924p ps=2.4u w=0.86u l=0.13u
X103 a_727_n4942# a_89_n8340# a_633_n4942# VSS sg13_lv_nmos ad=95f pd=0.88u as=0.17p ps=1.68u w=0.5u l=0.13u
X104 RM_IHPSG13_1P_BLDRV_1[1]/PRE_N a_1313_n4980# VDD VDD sg13_lv_pmos ad=0.3078p pd=2u as=0.5508p ps=3.92u w=1.62u l=0.13u
X105 a_523_n9075# a_123_n9075# a_421_n9075# VDD sg13_lv_pmos ad=0.18715p pd=1.365u as=0.18715p ps=1.365u w=0.985u l=0.13u
X106 VDD a_599_n7500# a_599_n7024# VDD sg13_lv_pmos ad=0.5508p pd=3.92u as=0.3078p ps=2u w=1.62u l=0.385u
X107 VDD a_1823_n6660# a_701_n5820# VDD sg13_lv_pmos ad=0.2688p pd=2u as=0.5508p ps=3.92u w=1.62u l=0.13u
X108 a_373_n5378# RM_IHPSG13_1P_BLDRV_1[1]/BLC_SEL a_707_n5378# VSS sg13_lv_nmos ad=0.228p pd=1.58u as=0.408p ps=3.08u w=1.2u l=0.2u
X109 a_1823_n9077# a_1645_n9078# VDD VDD sg13_lv_pmos ad=0.1632p pd=1.64u as=91.2f ps=0.86u w=0.48u l=0.13u
X110 VDD A_DCLK_B_L a_735_n9075# VDD sg13_lv_pmos ad=0.14812p pd=1.355u as=0.1632p ps=1.64u w=0.48u l=0.13u
X111 a_1135_n5784# RM_IHPSG13_1P_BLDRV_1[1]/BLT_SEL a_707_n5378# VSS sg13_lv_nmos ad=0.228p pd=1.58u as=0.228p ps=1.58u w=1.2u l=0.2u
X112 VSS a_263_n7064# a_225_n6984# VSS sg13_lv_nmos ad=0.1577p pd=1.21u as=0.2822p ps=2.34u w=0.83u l=0.13u
X113 a_1237_n8302# A_DCLK_B_L a_900_n8091# VSS sg13_lv_nmos ad=0.1653p pd=1.25u as=0.13605p ps=1.25u w=0.87u l=0.13u
X114 VSS A_DW_I a_1849_n8242# VSS sg13_lv_nmos ad=0.1064p pd=0.94u as=0.1064p ps=0.94u w=0.56u l=0.13u
X115 a_1033_n8224# a_701_n8294# VSS VSS sg13_lv_nmos ad=91.2f pd=0.86u as=91.2f ps=0.86u w=0.48u l=0.13u
X116 VDD a_701_n5820# a_481_n5378# VDD sg13_lv_pmos ad=0.3p pd=2.35u as=0.152p ps=1.18u w=0.8u l=0.13u
X117 a_1211_n9080# a_1033_n9075# VDD VDD sg13_lv_pmos ad=0.1632p pd=1.64u as=91.2f ps=0.86u w=0.48u l=0.13u
X118 VDD A_BIST_EN_I a_123_n9075# VDD sg13_lv_pmos ad=0.16165p pd=1.365u as=0.2193p ps=1.97u w=0.645u l=0.13u
X119 a_373_n5378# a_441_n5469# a_481_n5378# VSS sg13_lv_nmos ad=0.408p pd=3.08u as=0.228p ps=1.58u w=1.2u l=0.2u
X120 a_1645_n9078# A_DCLK_B_L a_1543_n9078# VDD sg13_lv_pmos ad=0.1511p pd=1.37u as=0.1881p ps=1.37u w=0.99u l=0.13u
X121 VDD a_481_n5378# a_441_n5469# VDD sg13_lv_pmos ad=0.3p pd=2.35u as=0.152p ps=1.18u w=0.8u l=0.13u
X122 VSS a_1589_n7064# a_1551_n6984# VSS sg13_lv_nmos ad=0.1577p pd=1.21u as=0.1577p ps=1.21u w=0.83u l=0.13u
X123 a_1135_n5784# a_701_n5820# VDD VDD sg13_lv_pmos ad=0.348p pd=2.47u as=0.152p ps=1.18u w=0.8u l=0.13u
X124 VDD a_803_n6660# a_293_n6660# VDD sg13_lv_pmos ad=0.306p pd=2.48u as=0.171p ps=1.28u w=0.9u l=0.13u
X125 VSS a_1181_n7064# a_1143_n6984# VSS sg13_lv_nmos ad=0.2822p pd=2.34u as=0.1577p ps=1.21u w=0.83u l=0.13u
R3 A_DCLK_B_L A_DCLK_B_R 0.203077
R4 A_RCLK_B_L A_RCLK_B_R 0.203077
X126 a_154_n4732# a_2092_n4732# a_2053_n4620# VDD sg13_lv_pmos ad=0.5508p pd=3.92u as=0.3078p ps=2u w=1.62u l=0.13u
X127 a_599_n7024# a_599_n7500# VDD VDD sg13_lv_pmos ad=0.3078p pd=2u as=0.3078p ps=2u w=1.62u l=0.385u
X128 A_DR_O a_293_n6660# VSS VSS sg13_lv_nmos ad=0.1862p pd=1.36u as=0.3332p ps=2.64u w=0.98u l=0.13u
X129 VDD a_900_n8091# a_701_n8294# VDD sg13_lv_pmos ad=91.2f pd=0.86u as=0.1632p ps=1.64u w=0.48u l=0.13u
X130 a_625_n7920# A_DCLK_B_L a_89_n8340# VDD sg13_lv_pmos ad=0.1881p pd=1.37u as=0.1511p ps=1.37u w=0.99u l=0.13u
X131 a_89_n8340# a_463_n7750# a_421_n7918# VDD sg13_lv_pmos ad=0.1511p pd=1.37u as=91.2f ps=0.86u w=0.48u l=0.13u
X132 a_523_n8670# A_BIST_EN_I a_421_n9075# VSS sg13_lv_nmos ad=0.1064p pd=0.94u as=0.1064p ps=0.94u w=0.56u l=0.13u
X133 VSS a_1823_n6660# a_701_n5820# VSS sg13_lv_nmos ad=0.12157p pd=1.085u as=0.2397p ps=2.09u w=0.705u l=0.13u
X134 a_89_n7500# a_89_n7500# VSS VSS sg13_lv_nmos ad=0.1632p pd=1.64u as=0.1632p ps=1.64u w=0.48u l=0.13u
R5 A_WCLK_B_L A_WCLK_B_R 0.203077
X135 A_TIEH_O a_89_n7500# VDD VDD sg13_lv_pmos ad=0.1632p pd=1.64u as=0.1632p ps=1.64u w=0.48u l=0.13u
X136 VSS a_441_n5469# a_1339_n6622# VSS sg13_lv_nmos ad=0.3332p pd=2.64u as=0.1862p ps=1.36u w=0.98u l=0.13u
X137 a_263_n7064# a_225_n6984# VDD VDD sg13_lv_pmos ad=0.3078p pd=2u as=0.5508p ps=3.92u w=1.62u l=0.385u
X138 RM_IHPSG13_1P_BLDRV_1[1]/WR_ONE a_633_n4942# VDD VDD sg13_lv_pmos ad=0.5508p pd=3.92u as=0.2508p ps=2u w=1.62u l=0.13u
X139 a_154_n4732# A_WCLK_B_R VSS VSS sg13_lv_nmos ad=0.1862p pd=1.36u as=0.3332p ps=2.64u w=0.98u l=0.13u
X140 a_481_n5378# a_441_n5469# a_373_n5378# VSS sg13_lv_nmos ad=0.228p pd=1.58u as=0.408p ps=3.08u w=1.2u l=0.2u
X141 a_803_n6660# a_293_n6660# VDD VDD sg13_lv_pmos ad=0.171p pd=1.28u as=0.306p ps=2.48u w=0.9u l=0.13u
X142 a_1645_n9078# a_735_n9075# a_1543_n8712# VSS sg13_lv_nmos ad=0.13375p pd=1.23u as=0.1783p ps=1.44u w=0.85u l=0.13u
X143 VSS A_BIST_EN_I a_123_n9075# VSS sg13_lv_nmos ad=0.1064p pd=0.94u as=0.1904p ps=1.8u w=0.56u l=0.13u
X144 a_463_n7750# A_DCLK_B_L VDD VDD sg13_lv_pmos ad=0.1632p pd=1.64u as=0.14812p ps=1.355u w=0.48u l=0.13u
X145 A_WCLK_B_R A_WCLK_L VSS VSS sg13_lv_nmos ad=0.2397p pd=2.09u as=0.2397p ps=2.09u w=0.705u l=0.13u
X146 a_1686_n7711# A_BIST_EN_I VSS VSS sg13_lv_nmos ad=0.1904p pd=1.8u as=0.1064p ps=0.94u w=0.56u l=0.13u
X147 VDD a_1925_n7500# a_1925_n7024# VDD sg13_lv_pmos ad=0.5508p pd=3.92u as=0.3078p ps=2u w=1.62u l=0.385u
X148 RM_IHPSG13_1P_BLDRV_1[1]/WR_ZERO a_21_n4942# VDD VDD sg13_lv_pmos ad=0.5508p pd=3.92u as=0.2508p ps=2u w=1.62u l=0.13u
X149 a_1849_n7922# A_BIST_EN_I a_1313_n8340# VDD sg13_lv_pmos ad=0.18715p pd=1.365u as=0.18715p ps=1.365u w=0.985u l=0.13u
X150 a_1033_n7914# a_701_n8294# VDD VDD sg13_lv_pmos ad=91.2f pd=0.86u as=91.2f ps=0.86u w=0.48u l=0.13u
X151 A_DCLK_B_L A_DCLK_L VDD VDD sg13_lv_pmos ad=0.5508p pd=3.92u as=0.5508p ps=3.92u w=1.62u l=0.13u
X152 VDD a_293_n6660# A_DR_O VDD sg13_lv_pmos ad=0.5508p pd=3.92u as=0.3078p ps=2u w=1.62u l=0.13u
X153 a_89_n8340# A_DCLK_B_L a_421_n8226# VSS sg13_lv_nmos ad=0.13375p pd=1.23u as=91.2f ps=0.86u w=0.48u l=0.13u
X154 a_1823_n6660# A_RCLK_B_R VDD VDD sg13_lv_pmos ad=0.374p pd=2.88u as=0.2688p ps=2u w=1.1u l=0.13u
X155 a_1211_n9080# a_1033_n9075# VSS VSS sg13_lv_nmos ad=0.1632p pd=1.64u as=91.2f ps=0.86u w=0.48u l=0.13u
X156 VDD A_RCLK_R A_RCLK_B_R VDD sg13_lv_pmos ad=0.5508p pd=3.92u as=0.5508p ps=3.92u w=1.62u l=0.13u
X157 VDD a_154_n4732# a_633_n4942# VDD sg13_lv_pmos ad=0.2508p pd=2u as=0.1634p ps=1.24u w=0.86u l=0.13u
X158 a_1747_n8670# A_DCLK_B_L a_1645_n9078# VSS sg13_lv_nmos ad=91.2f pd=0.86u as=0.13375p ps=1.23u w=0.48u l=0.13u
X159 VSS a_154_n4732# a_727_n4942# VSS sg13_lv_nmos ad=0.1502p pd=1.36u as=95f ps=0.88u w=0.5u l=0.13u
.ends

.subckt RM_IHPSG13_1P_COLDRV13_FILL4 m3_0_n3297# dw_0_n7620# m3_0_n3969# m3_0_n2709#
+ m3_0_n6405# m3_0_n3549# m3_0_n6741# m3_0_n4137# m3_0_n6657# m3_0_n2625# m3_0_n3213#
+ m3_0_n3129# m3_0_n6321# m3_0_n3465# m3_0_n6237# m3_0_n6573# m3_0_n4053# m3_0_n6489#
+ w_n102_n7665# m3_0_n273#
X0 a_59_n1402# a_21_n1582# w_n102_n7665# w_n102_n7665# sg13_lv_pmos ad=0.3078p pd=2u as=0.5508p ps=3.92u w=1.62u l=0.385u
X1 a_21_n4942# a_59_n4762# dw_0_n7620# dw_0_n7620# sg13_lv_nmos ad=0.1577p pd=1.21u as=0.1577p ps=1.21u w=0.83u l=0.13u
X2 a_21_n264# a_59_n344# dw_0_n7620# dw_0_n7620# sg13_lv_nmos ad=0.1577p pd=1.21u as=0.1577p ps=1.21u w=0.83u l=0.13u
X3 dw_0_n7620# a_59_n5384# a_21_n5304# dw_0_n7620# sg13_lv_nmos ad=0.1577p pd=1.21u as=0.2822p ps=2.34u w=0.83u l=0.13u
X4 dw_0_n7620# a_59_n5384# a_21_n5304# dw_0_n7620# sg13_lv_nmos ad=0.2822p pd=2.34u as=0.1577p ps=1.21u w=0.83u l=0.13u
X5 dw_0_n7620# a_59_n2024# a_21_n1944# dw_0_n7620# sg13_lv_nmos ad=0.1577p pd=1.21u as=0.2822p ps=2.34u w=0.83u l=0.13u
X6 dw_0_n7620# a_59_n2024# a_21_n1944# dw_0_n7620# sg13_lv_nmos ad=0.2822p pd=2.34u as=0.1577p ps=1.21u w=0.83u l=0.13u
X7 w_n102_n7665# a_21_n264# a_59_n344# w_n102_n7665# sg13_lv_pmos ad=0.5508p pd=3.92u as=0.3078p ps=2u w=1.62u l=0.385u
X8 a_21_n1582# a_59_n1402# dw_0_n7620# dw_0_n7620# sg13_lv_nmos ad=0.1577p pd=1.21u as=0.1577p ps=1.21u w=0.83u l=0.13u
X9 w_n102_n7665# a_21_n6622# a_59_n6442# w_n102_n7665# sg13_lv_pmos ad=0.5508p pd=3.92u as=0.3078p ps=2u w=1.62u l=0.385u
X10 dw_0_n7620# a_59_n344# a_21_n264# dw_0_n7620# sg13_lv_nmos ad=0.1577p pd=1.21u as=0.2822p ps=2.34u w=0.83u l=0.13u
X11 w_n102_n7665# a_21_n3624# a_59_n3704# w_n102_n7665# sg13_lv_pmos ad=0.5508p pd=3.92u as=0.3078p ps=2u w=1.62u l=0.385u
X12 a_59_n2024# a_21_n1944# w_n102_n7665# w_n102_n7665# sg13_lv_pmos ad=0.3078p pd=2u as=0.5508p ps=3.92u w=1.62u l=0.385u
X13 a_21_n3624# a_59_n3704# dw_0_n7620# dw_0_n7620# sg13_lv_nmos ad=0.1577p pd=1.21u as=0.1577p ps=1.21u w=0.83u l=0.13u
X14 dw_0_n7620# a_59_n344# a_21_n264# dw_0_n7620# sg13_lv_nmos ad=0.2822p pd=2.34u as=0.1577p ps=1.21u w=0.83u l=0.13u
X15 a_59_n344# a_21_n264# w_n102_n7665# w_n102_n7665# sg13_lv_pmos ad=0.3078p pd=2u as=0.5508p ps=3.92u w=1.62u l=0.385u
X16 dw_0_n7620# a_59_n4762# a_21_n4942# dw_0_n7620# sg13_lv_nmos ad=0.1577p pd=1.21u as=0.2822p ps=2.34u w=0.83u l=0.13u
X17 dw_0_n7620# a_59_n4762# a_21_n4942# dw_0_n7620# sg13_lv_nmos ad=0.2822p pd=2.34u as=0.1577p ps=1.21u w=0.83u l=0.13u
X18 w_n102_n7665# a_21_n6984# a_59_n7064# w_n102_n7665# sg13_lv_pmos ad=0.5508p pd=3.92u as=0.3078p ps=2u w=1.62u l=0.385u
X19 a_59_n5384# a_21_n5304# w_n102_n7665# w_n102_n7665# sg13_lv_pmos ad=0.3078p pd=2u as=0.5508p ps=3.92u w=1.62u l=0.385u
X20 a_21_n6984# a_59_n7064# dw_0_n7620# dw_0_n7620# sg13_lv_nmos ad=0.1577p pd=1.21u as=0.1577p ps=1.21u w=0.83u l=0.13u
X21 dw_0_n7620# a_59_n1402# a_21_n1582# dw_0_n7620# sg13_lv_nmos ad=0.1577p pd=1.21u as=0.2822p ps=2.34u w=0.83u l=0.13u
X22 dw_0_n7620# a_59_n1402# a_21_n1582# dw_0_n7620# sg13_lv_nmos ad=0.2822p pd=2.34u as=0.1577p ps=1.21u w=0.83u l=0.13u
X23 w_n102_n7665# a_21_n4942# a_59_n4762# w_n102_n7665# sg13_lv_pmos ad=0.5508p pd=3.92u as=0.3078p ps=2u w=1.62u l=0.385u
X24 a_59_n3082# a_21_n3262# w_n102_n7665# w_n102_n7665# sg13_lv_pmos ad=0.3078p pd=2u as=0.5508p ps=3.92u w=1.62u l=0.385u
X25 a_21_n6622# a_59_n6442# dw_0_n7620# dw_0_n7620# sg13_lv_nmos ad=0.1577p pd=1.21u as=0.1577p ps=1.21u w=0.83u l=0.13u
X26 w_n102_n7665# a_21_n1582# a_59_n1402# w_n102_n7665# sg13_lv_pmos ad=0.5508p pd=3.92u as=0.3078p ps=2u w=1.62u l=0.385u
X27 a_21_n3262# a_59_n3082# dw_0_n7620# dw_0_n7620# sg13_lv_nmos ad=0.1577p pd=1.21u as=0.1577p ps=1.21u w=0.83u l=0.13u
X28 dw_0_n7620# a_59_n3704# a_21_n3624# dw_0_n7620# sg13_lv_nmos ad=0.1577p pd=1.21u as=0.2822p ps=2.34u w=0.83u l=0.13u
X29 dw_0_n7620# a_59_n3704# a_21_n3624# dw_0_n7620# sg13_lv_nmos ad=0.2822p pd=2.34u as=0.1577p ps=1.21u w=0.83u l=0.13u
X30 a_59_n6442# a_21_n6622# w_n102_n7665# w_n102_n7665# sg13_lv_pmos ad=0.3078p pd=2u as=0.5508p ps=3.92u w=1.62u l=0.385u
X31 dw_0_n7620# a_59_n7064# a_21_n6984# dw_0_n7620# sg13_lv_nmos ad=0.1577p pd=1.21u as=0.2822p ps=2.34u w=0.83u l=0.13u
X32 dw_0_n7620# a_59_n7064# a_21_n6984# dw_0_n7620# sg13_lv_nmos ad=0.2822p pd=2.34u as=0.1577p ps=1.21u w=0.83u l=0.13u
X33 a_59_n3704# a_21_n3624# w_n102_n7665# w_n102_n7665# sg13_lv_pmos ad=0.3078p pd=2u as=0.5508p ps=3.92u w=1.62u l=0.385u
X34 a_21_n5304# a_59_n5384# dw_0_n7620# dw_0_n7620# sg13_lv_nmos ad=0.1577p pd=1.21u as=0.1577p ps=1.21u w=0.83u l=0.13u
X35 w_n102_n7665# a_21_n1944# a_59_n2024# w_n102_n7665# sg13_lv_pmos ad=0.5508p pd=3.92u as=0.3078p ps=2u w=1.62u l=0.385u
X36 a_21_n1944# a_59_n2024# dw_0_n7620# dw_0_n7620# sg13_lv_nmos ad=0.1577p pd=1.21u as=0.1577p ps=1.21u w=0.83u l=0.13u
X37 dw_0_n7620# a_59_n6442# a_21_n6622# dw_0_n7620# sg13_lv_nmos ad=0.1577p pd=1.21u as=0.2822p ps=2.34u w=0.83u l=0.13u
X38 dw_0_n7620# a_59_n6442# a_21_n6622# dw_0_n7620# sg13_lv_nmos ad=0.2822p pd=2.34u as=0.1577p ps=1.21u w=0.83u l=0.13u
X39 a_59_n7064# a_21_n6984# w_n102_n7665# w_n102_n7665# sg13_lv_pmos ad=0.3078p pd=2u as=0.5508p ps=3.92u w=1.62u l=0.385u
X40 dw_0_n7620# a_59_n3082# a_21_n3262# dw_0_n7620# sg13_lv_nmos ad=0.1577p pd=1.21u as=0.2822p ps=2.34u w=0.83u l=0.13u
X41 dw_0_n7620# a_59_n3082# a_21_n3262# dw_0_n7620# sg13_lv_nmos ad=0.2822p pd=2.34u as=0.1577p ps=1.21u w=0.83u l=0.13u
X42 w_n102_n7665# a_21_n5304# a_59_n5384# w_n102_n7665# sg13_lv_pmos ad=0.5508p pd=3.92u as=0.3078p ps=2u w=1.62u l=0.385u
X43 a_59_n4762# a_21_n4942# w_n102_n7665# w_n102_n7665# sg13_lv_pmos ad=0.3078p pd=2u as=0.5508p ps=3.92u w=1.62u l=0.385u
X44 w_n102_n7665# a_21_n3262# a_59_n3082# w_n102_n7665# sg13_lv_pmos ad=0.5508p pd=3.92u as=0.3078p ps=2u w=1.62u l=0.385u
.ends

* Black-box entry subcircuit for RM_IHPSG13_1P_1024x8_c2_bm_bist abstract view
.subckt RM_IHPSG13_1P_1024x8_c2_bm_bist A_ADDR<9> A_ADDR<8> A_ADDR<7> A_ADDR<6> A_ADDR<5>
+ A_ADDR<4> A_ADDR<3> A_ADDR<2> A_ADDR<1> A_ADDR<0> A_BIST_ADDR<9> A_BIST_ADDR<8>
+ A_BIST_ADDR<7> A_BIST_ADDR<6> A_BIST_ADDR<5> A_BIST_ADDR<4> A_BIST_ADDR<3> A_BIST_ADDR<2>
+ A_BIST_ADDR<1> A_BIST_ADDR<0> A_BIST_BM<7> A_BIST_BM<6> A_BIST_BM<5> A_BIST_BM<4>
+ A_BIST_BM<3> A_BIST_BM<2> A_BIST_BM<1> A_BIST_BM<0> A_BIST_CLK A_BIST_DIN<7> A_BIST_DIN<6>
+ A_BIST_DIN<5> A_BIST_DIN<4> A_BIST_DIN<3> A_BIST_DIN<2> A_BIST_DIN<1> A_BIST_DIN<0>
+ A_BIST_EN A_BIST_MEN A_BIST_REN A_BIST_WEN A_BM<7> A_BM<6> A_BM<5> A_BM<4> A_BM<3>
+ A_BM<2> A_BM<1> A_BM<0> A_CLK A_DIN<7> A_DIN<6> A_DIN<5> A_DIN<4> A_DIN<3> A_DIN<2>
+ A_DIN<1> A_DIN<0> A_DLY A_DOUT<7> A_DOUT<6> A_DOUT<5> A_DOUT<4> A_DOUT<3> A_DOUT<2>
+ A_DOUT<1> A_DOUT<0> A_MEN A_REN A_WEN VDD VDDARRAY VSS
.ends

.subckt sg13_hv_nmos_2RYP69 D S G sub
X0 S G D sub sg13_hv_nmos ad=0.34p pd=2.68u as=0.34p ps=2.68u w=1u l=1u
.ends

.subckt bias_nstack itail shld2 shld3 avss a_1030_2157# nbias ncasc ena
Xsg13_hv_nmos_2RYP69_0[0] sg13_hv_nmos_2RYP69_0[5]/D itail ena avss sg13_hv_nmos_2RYP69
Xsg13_hv_nmos_2RYP69_0[1] sg13_hv_nmos_2RYP69_0[5]/D itail ena avss sg13_hv_nmos_2RYP69
Xsg13_hv_nmos_2RYP69_0[2] sg13_hv_nmos_2RYP69_0[5]/D itail ena avss sg13_hv_nmos_2RYP69
Xsg13_hv_nmos_2RYP69_0[3] sg13_hv_nmos_2RYP69_0[5]/D sg13_hv_nmos_2RYP69_0[8]/S ncasc
+ avss sg13_hv_nmos_2RYP69
Xsg13_hv_nmos_2RYP69_0[4] sg13_hv_nmos_2RYP69_0[5]/D sg13_hv_nmos_2RYP69_0[8]/S ncasc
+ avss sg13_hv_nmos_2RYP69
Xsg13_hv_nmos_2RYP69_0[5] sg13_hv_nmos_2RYP69_0[5]/D sg13_hv_nmos_2RYP69_0[8]/S ncasc
+ avss sg13_hv_nmos_2RYP69
Xsg13_hv_nmos_2RYP69_0[6] avss sg13_hv_nmos_2RYP69_0[8]/S nbias avss sg13_hv_nmos_2RYP69
Xsg13_hv_nmos_2RYP69_0[7] avss sg13_hv_nmos_2RYP69_0[8]/S nbias avss sg13_hv_nmos_2RYP69
Xsg13_hv_nmos_2RYP69_0[8] avss sg13_hv_nmos_2RYP69_0[8]/S nbias avss sg13_hv_nmos_2RYP69
.ends

.subckt sg13_hv_pmos_KGSGVN D S G w_n292_n205#
X0 S G D w_n292_n205# sg13_hv_pmos ad=0.34p pd=2.68u as=0.34p ps=2.68u w=1u l=1u
.ends

.subckt bias_pstack avdd itail shld2 shld3 enb pbias pcasc
Xsg13_hv_pmos_KGSGVN_0[0] sg13_hv_pmos_KGSGVN_0[5]/D itail enb avdd sg13_hv_pmos_KGSGVN
Xsg13_hv_pmos_KGSGVN_0[1] sg13_hv_pmos_KGSGVN_0[5]/D itail enb avdd sg13_hv_pmos_KGSGVN
Xsg13_hv_pmos_KGSGVN_0[2] sg13_hv_pmos_KGSGVN_0[5]/D itail enb avdd sg13_hv_pmos_KGSGVN
Xsg13_hv_pmos_KGSGVN_0[3] sg13_hv_pmos_KGSGVN_0[5]/D sg13_hv_pmos_KGSGVN_0[8]/S pcasc
+ avdd sg13_hv_pmos_KGSGVN
Xsg13_hv_pmos_KGSGVN_0[4] sg13_hv_pmos_KGSGVN_0[5]/D sg13_hv_pmos_KGSGVN_0[8]/S pcasc
+ avdd sg13_hv_pmos_KGSGVN
Xsg13_hv_pmos_KGSGVN_0[5] sg13_hv_pmos_KGSGVN_0[5]/D sg13_hv_pmos_KGSGVN_0[8]/S pcasc
+ avdd sg13_hv_pmos_KGSGVN
Xsg13_hv_pmos_KGSGVN_0[6] avdd sg13_hv_pmos_KGSGVN_0[8]/S pbias avdd sg13_hv_pmos_KGSGVN
Xsg13_hv_pmos_KGSGVN_0[7] avdd sg13_hv_pmos_KGSGVN_0[8]/S pbias avdd sg13_hv_pmos_KGSGVN
Xsg13_hv_pmos_KGSGVN_0[8] avdd sg13_hv_pmos_KGSGVN_0[8]/S pbias avdd sg13_hv_pmos_KGSGVN
.ends

.subckt bias_generator_ben1um sink_ena[2] sink_ena[1] sink_ena[0] sink_ibias ncasc
+ bias_nstack_0[9]/itail sub dvdd nbias bias_nstack_3/shld2 avdd dvss bias_nstack_2[2]/a_1030_2157#
+ bias_nstack_3/shld3
Xbias_nstack_0[0] bias_nstack_0[9]/itail bias_nstack_3/shld2 bias_nstack_3/shld3 sub
+ sub nbias ncasc sub bias_nstack
Xbias_nstack_0[1] bias_nstack_0[9]/itail bias_nstack_3/shld2 bias_nstack_3/shld3 sub
+ sub nbias ncasc sub bias_nstack
Xbias_nstack_0[2] bias_nstack_0[9]/itail bias_nstack_3/shld2 bias_nstack_3/shld3 sub
+ sub nbias ncasc sub bias_nstack
Xbias_nstack_0[3] bias_nstack_0[9]/itail bias_nstack_3/shld2 bias_nstack_3/shld3 sub
+ sub nbias ncasc sub bias_nstack
Xbias_nstack_0[4] bias_nstack_0[9]/itail bias_nstack_3/shld2 bias_nstack_3/shld3 sub
+ sub nbias ncasc sub bias_nstack
Xbias_nstack_0[5] bias_nstack_0[9]/itail bias_nstack_3/shld2 bias_nstack_3/shld3 sub
+ sub nbias ncasc sub bias_nstack
Xbias_nstack_0[6] bias_nstack_0[9]/itail bias_nstack_3/shld2 bias_nstack_3/shld3 sub
+ sub nbias ncasc sub bias_nstack
Xbias_nstack_0[7] bias_nstack_0[9]/itail bias_nstack_3/shld2 bias_nstack_3/shld3 sub
+ sub nbias ncasc sub bias_nstack
Xbias_nstack_0[8] bias_nstack_0[9]/itail bias_nstack_3/shld2 bias_nstack_3/shld3 sub
+ sub nbias ncasc sub bias_nstack
Xbias_nstack_0[9] bias_nstack_0[9]/itail bias_nstack_3/shld2 bias_nstack_3/shld3 sub
+ sub nbias ncasc sub bias_nstack
Xsg13cmos5l_inv_2_0 level_shift_0/in_n sink_ena[1] dvdd dvss sg13cmos5l_inv_2
Xbias_nstack_1 sink_ibias bias_nstack_3/shld2 bias_nstack_3/shld3 sub sub nbias ncasc
+ level_shift_0/out bias_nstack
Xsg13cmos5l_inv_2_1 level_shift_1/in_n sink_ena[2] dvdd dvss sg13cmos5l_inv_2
Xbias_nstack_2[0] sink_ibias bias_nstack_3/shld2 bias_nstack_3/shld3 sub bias_nstack_2[2]/a_1030_2157#
+ nbias ncasc level_shift_4/out bias_nstack
Xbias_nstack_2[1] sink_ibias bias_nstack_3/shld2 bias_nstack_3/shld3 sub bias_nstack_2[2]/a_1030_2157#
+ nbias ncasc level_shift_4/out bias_nstack
Xbias_nstack_2[2] sink_ibias bias_nstack_3/shld2 bias_nstack_3/shld3 sub bias_nstack_2[2]/a_1030_2157#
+ nbias ncasc level_shift_4/out bias_nstack
Xbias_nstack_3 sink_ibias bias_nstack_3/shld2 bias_nstack_3/shld3 sub bias_nstack_3/a_1030_2157#
+ nbias ncasc level_shift_1/out bias_nstack
Xsg13cmos5l_inv_2_4 level_shift_4/in_n sink_ena[0] dvdd dvss sg13cmos5l_inv_2
Xsg13cmos5l_antennanp_0 sink_ena[1] dvdd dvss sg13cmos5l_antennanp
Xsg13cmos5l_antennanp_1 sink_ena[2] dvdd dvss sg13cmos5l_antennanp
Xsg13cmos5l_antennanp_4 sink_ena[0] dvdd dvss sg13cmos5l_antennanp
Xlevel_shift_0 level_shift_0/in_n sink_ena[1] level_shift_0/out sub avdd level_shift
Xlevel_shift_1 level_shift_1/in_n sink_ena[2] level_shift_1/out sub avdd level_shift
Xsg13cmos5l_decap_4_0 dvdd dvss sg13cmos5l_decap_4
Xsg13cmos5l_decap_4_1 dvdd dvss sg13cmos5l_decap_4
Xlevel_shift_4 level_shift_4/in_n sink_ena[0] level_shift_4/out sub avdd level_shift
Xsg13cmos5l_decap_4_2 dvdd dvss sg13cmos5l_decap_4
.ends

.subckt bias_amp_large avdd out inn inp nbias ena avss
Xsg13_hv_pmos_7A8CUW_0 avdd avdd avdd XM6/S7 avdd XM6/S7 avdd out XM6/S7 XM6/S7 avdd
+ XM6/S7 avdd out XM6/S7 XM6/S7 avdd XM6/S7 avdd out XM6/S7 XM6/S7 avdd XM6/S7 avdd
+ out XM6/S7 XM6/S7 avdd XM6/S7 avdd out XM6/S7 avdd avdd avdd avdd sg13_hv_pmos_7A8CUW
XXM1 avss XM1/S8_1 nbias avss XM1/S8_1 nbias XM1/S8_1 avss nbias XM1/S8_1 avss nbias
+ avss XM1/S8_1 nbias avss XM1/S8_1 nbias XM1/S8_1 avss nbias XM1/S8_1 avss nbias
+ avss XM1/S8_1 nbias avss XM1/S8_1 nbias XM1/S8_1 avss nbias XM1/S8_1 avss nbias
+ avss XM1/S8_1 nbias avss XM1/S8_1 nbias XM1/S8_1 avss nbias XM1/S8_1 avss nbias
+ avss XM1/S8_1 nbias avss XM1/S8_1 nbias XM1/S8_1 avss nbias XM1/S8_1 avss nbias
+ avss sg13_hv_nmos_XVVFQX
XXM2 avdd avdd avdd out avdd XM6/S7 avdd XM6/S7 XM6/S7 out avdd XM6/S7 avdd XM6/S7
+ XM6/S7 out avdd XM6/S7 avdd XM6/S7 XM6/S7 out avdd XM6/S7 avdd XM6/S7 XM6/S7 out
+ avdd XM6/S7 avdd XM6/S7 XM6/S7 avdd avdd avdd avdd sg13_hv_pmos_7A8CUW
XXM5 XM6/D8 inp XM6/S7 inp XM6/D8 inn out inn XM6/D8 inp XM6/S7 inp XM6/D8 inn out
+ inn XM6/D8 inp XM6/S7 inp XM6/D8 inn out inn XM6/D8 inp XM6/S7 inp XM6/D8 inn out
+ inn XM6/D8 inp XM6/S7 inp XM6/D8 inn out inn XM6/D8 avss sg13_hv_nmos_666RAL
XXM6 XM6/D8 inn out inn XM6/D8 inp XM6/S7 inp XM6/D8 inn out inn XM6/D8 inp XM6/S7
+ inp XM6/D8 inn out inn XM6/D8 inp XM6/S7 inp XM6/D8 inn out inn XM6/D8 inp XM6/S7
+ inp XM6/D8 inn out inn XM6/D8 inp XM6/S7 inp XM6/D8 avss sg13_hv_nmos_666RAL
Xsg13_hv_nmos_666RAL_0 XM1/S8_1 ena XM6/D8 ena XM1/S8_1 ena XM6/D8 ena XM1/S8_1 ena
+ XM6/D8 ena XM1/S8_1 ena XM6/D8 ena XM1/S8_1 ena XM6/D8 ena XM1/S8_1 ena XM6/D8 ena
+ XM1/S8_1 ena XM6/D8 ena XM1/S8_1 ena XM6/D8 ena XM1/S8_1 ena XM6/D8 ena XM1/S8_1
+ ena XM6/D8 ena XM1/S8_1 avss sg13_hv_nmos_666RAL
.ends

.subckt bias_pset pcasc enb itail shld3 avdd pbias
Xsg13_hv_pmos_KGSGVN_0[0] pcasc itail enb avdd sg13_hv_pmos_KGSGVN
Xsg13_hv_pmos_KGSGVN_0[1] pcasc itail enb avdd sg13_hv_pmos_KGSGVN
Xsg13_hv_pmos_KGSGVN_0[2] pcasc itail enb avdd sg13_hv_pmos_KGSGVN
Xsg13_hv_pmos_KGSGVN_0[3] pcasc pbias pcasc avdd sg13_hv_pmos_KGSGVN
Xsg13_hv_pmos_KGSGVN_0[4] pcasc pbias pcasc avdd sg13_hv_pmos_KGSGVN
Xsg13_hv_pmos_KGSGVN_0[5] pcasc pbias pcasc avdd sg13_hv_pmos_KGSGVN
Xsg13_hv_pmos_KGSGVN_0[6] avdd pbias pbias avdd sg13_hv_pmos_KGSGVN
Xsg13_hv_pmos_KGSGVN_0[7] avdd pbias pbias avdd sg13_hv_pmos_KGSGVN
Xsg13_hv_pmos_KGSGVN_0[8] avdd pbias pbias avdd sg13_hv_pmos_KGSGVN
.ends

.subckt rhigh_GJN3VD B R1_0 R2_0 R1_1 R2_1 R1_2 R2_2 R1_3 R2_3 R1_4 R2_4 R1_5 R2_5
+ R1_6 R2_6 R1_7 R2_7
X0 R1_5 R2_5 B rhigh l=17.32u w=0.5u
X1 R1_6 R2_6 B rhigh l=17.32u w=0.5u
X2 R1_3 R2_3 B rhigh l=17.32u w=0.5u
X3 R1_2 R2_2 B rhigh l=17.32u w=0.5u
X4 R1_7 R2_7 B rhigh l=17.32u w=0.5u
X5 R1_4 R2_4 B rhigh l=17.32u w=0.5u
X6 R1_1 R2_1 B rhigh l=17.32u w=0.5u
X7 R1_0 R2_0 B rhigh l=17.32u w=0.5u
.ends

.subckt bias_pset2 pbias pcasc enb itail shld2 shld3 avdd
Xsg13_hv_pmos_KGSGVN_0[0] pcasc itail enb avdd sg13_hv_pmos_KGSGVN
Xsg13_hv_pmos_KGSGVN_0[1] pcasc itail enb avdd sg13_hv_pmos_KGSGVN
Xsg13_hv_pmos_KGSGVN_0[2] pcasc itail enb avdd sg13_hv_pmos_KGSGVN
Xsg13_hv_pmos_KGSGVN_0[3] pcasc pbias pcasc avdd sg13_hv_pmos_KGSGVN
Xsg13_hv_pmos_KGSGVN_0[4] pcasc pbias pcasc avdd sg13_hv_pmos_KGSGVN
Xsg13_hv_pmos_KGSGVN_0[5] pcasc pbias pcasc avdd sg13_hv_pmos_KGSGVN
Xsg13_hv_pmos_KGSGVN_0[6] avdd pbias pbias avdd sg13_hv_pmos_KGSGVN
Xsg13_hv_pmos_KGSGVN_0[7] avdd pbias pbias avdd sg13_hv_pmos_KGSGVN
Xsg13_hv_pmos_KGSGVN_0[8] avdd pbias pbias avdd sg13_hv_pmos_KGSGVN
.ends

.subckt capacitor_UPRECB c1 c2
X0 c1 c2 cap_cmomf mm_ok=1 subblock=0 mmax=4 mmin=1 l=11u w=16u
.ends

.subckt rhigh_AFSZTU B R1_0 R2_0 R1_1 R2_1 R1_2 R2_2 R1_3 R2_3 R1_4 R2_4 R1_5 R2_5
+ R1_6 R2_6 R1_7 R2_7 R1_8 R2_8 R1_9 R2_9 R1_10 R2_10 R1_11 R2_11 R1_12 R2_12 R1_13
+ R2_13 R1_14 R2_14 R1_15 R2_15 R1_16 R2_16 R1_17 R2_17 R1_18 R2_18 R1_19 R2_19
X0 R1_18 R2_18 B rhigh l=16.86u w=0.5u
X1 R1_19 R2_19 B rhigh l=16.86u w=0.5u
X2 R1_4 R2_4 B rhigh l=16.86u w=0.5u
X3 R1_3 R2_3 B rhigh l=16.86u w=0.5u
X4 R1_2 R2_2 B rhigh l=16.86u w=0.5u
X5 R1_11 R2_11 B rhigh l=16.86u w=0.5u
X6 R1_12 R2_12 B rhigh l=16.86u w=0.5u
X7 R1_0 R2_0 B rhigh l=16.86u w=0.5u
X8 R1_1 R2_1 B rhigh l=16.86u w=0.5u
X9 R1_9 R2_9 B rhigh l=16.86u w=0.5u
X10 R1_8 R2_8 B rhigh l=16.86u w=0.5u
X11 R1_13 R2_13 B rhigh l=16.86u w=0.5u
X12 R1_14 R2_14 B rhigh l=16.86u w=0.5u
X13 R1_10 R2_10 B rhigh l=16.86u w=0.5u
X14 R1_15 R2_15 B rhigh l=16.86u w=0.5u
X15 R1_16 R2_16 B rhigh l=16.86u w=0.5u
X16 R1_17 R2_17 B rhigh l=16.86u w=0.5u
X17 R1_7 R2_7 B rhigh l=16.86u w=0.5u
X18 R1_5 R2_5 B rhigh l=16.86u w=0.5u
X19 R1_6 R2_6 B rhigh l=16.86u w=0.5u
.ends

.subckt bias_nset itail shld2 shld3 a_1043_n1378# avss nbias ncasc ena
Xsg13_hv_nmos_2RYP69_0[0] ncasc itail ena avss sg13_hv_nmos_2RYP69
Xsg13_hv_nmos_2RYP69_0[1] ncasc itail ena avss sg13_hv_nmos_2RYP69
Xsg13_hv_nmos_2RYP69_0[2] ncasc itail ena avss sg13_hv_nmos_2RYP69
Xsg13_hv_nmos_2RYP69_0[3] ncasc nbias ncasc avss sg13_hv_nmos_2RYP69
Xsg13_hv_nmos_2RYP69_0[4] ncasc nbias ncasc avss sg13_hv_nmos_2RYP69
Xsg13_hv_nmos_2RYP69_0[5] ncasc nbias ncasc avss sg13_hv_nmos_2RYP69
Xsg13_hv_nmos_2RYP69_0[6] avss nbias nbias avss sg13_hv_nmos_2RYP69
Xsg13_hv_nmos_2RYP69_0[7] avss nbias nbias avss sg13_hv_nmos_2RYP69
Xsg13_hv_nmos_2RYP69_0[8] avss nbias nbias avss sg13_hv_nmos_2RYP69
.ends

.subckt sg13cmos5l_nand2_1 Y A B VDD VSS
X0 a_154_118# B VSS VSS sg13_lv_nmos ad=0.1406p pd=1.12u as=0.2516p ps=2.16u w=0.74u l=0.13u
X1 Y A a_154_118# VSS sg13_lv_nmos ad=0.2516p pd=2.16u as=0.1406p ps=1.12u w=0.74u l=0.13u
X2 Y B VDD VDD sg13_lv_pmos ad=0.2128p pd=1.5u as=0.3808p ps=2.92u w=1.12u l=0.13u
X3 VDD A Y VDD sg13_lv_pmos ad=0.3808p pd=2.92u as=0.2128p ps=1.5u w=1.12u l=0.13u
.ends

.subckt sg13cmos5l_nor2_1 Y A B VDD VSS
X0 Y A VSS VSS sg13_lv_nmos ad=0.1406p pd=1.12u as=0.2516p ps=2.16u w=0.74u l=0.13u
X1 VSS B Y VSS sg13_lv_nmos ad=0.2516p pd=2.16u as=0.1406p ps=1.12u w=0.74u l=0.13u
X2 a_170_412# A VDD VDD sg13_lv_pmos ad=0.1176p pd=1.33u as=0.4032p ps=2.96u w=1.12u l=0.13u
X3 Y B a_170_412# VDD sg13_lv_pmos ad=0.3808p pd=2.92u as=0.1176p ps=1.33u w=1.12u l=0.13u
.ends

.subckt bias_generator_fe_v2 ena vbg src_test0 ena_src_test0 ref_in nbias pcasc pbias
+ snk_test0 ena_snk_test0 ncasc ref_sel_fine ref_sel_coarse x13[9]/shld2 ref_sel_vbg
+ x4[1]/a_1030_2157# dvdd x3/avdd avss dvss
Xbias_nstack_0 bias_pset_1/itail avss avss avss bias_nstack_0/a_1030_2157# nbias ncasc
+ ena_3v3 bias_nstack
Xsg13cmos5l_inv_2_0 level_shift_4/in_n level_shift_4/in_p dvdd dvss sg13cmos5l_inv_2
Xbias_nstack_1[0] XR4/R2_0 avss avss avss bias_nstack_1[1]/a_1030_2157# nbias ncasc
+ avss bias_nstack
Xbias_nstack_1[1] XR4/R2_0 avss avss avss bias_nstack_1[1]/a_1030_2157# nbias ncasc
+ avss bias_nstack
Xsg13cmos5l_inv_2_1 x12/in_n ena_snk_test0 dvdd dvss sg13cmos5l_inv_2
Xx3 x3/avdd pbias vbg C2/c2 nbias ena_vbg_3v3 avss bias_amp_large
Xsg13cmos5l_inv_2_2 level_shift_0/in_n ena dvdd dvss sg13cmos5l_inv_2
Xx4[0] snk_test0 avss avss avss x4[1]/a_1030_2157# nbias ncasc ena_test0_3v3 bias_nstack
Xx4[1] snk_test0 avss avss avss x4[1]/a_1030_2157# nbias ncasc ena_test0_3v3 bias_nstack
Xsg13cmos5l_inv_2_3 level_shift_6/in_p ena_src_test0 dvdd dvss sg13cmos5l_inv_2
Xbias_pset_1 pcasc ena_vbg_3v3 bias_pset_1/itail x3/avdd x3/avdd pbias bias_pset
Xsg13cmos5l_inv_2_4 level_shift_2/in_n ref_sel_vbg dvdd dvss sg13cmos5l_inv_2
Xsg13cmos5l_inv_2_5 level_shift_3/in_n level_shift_3/in_p dvdd dvss sg13cmos5l_inv_2
Xsg13cmos5l_inv_2_6 level_shift_5/in_n level_shift_5/in_p dvdd dvss sg13cmos5l_inv_2
Xsg13cmos5l_inv_2_7 sg13cmos5l_inv_2_7/Y ref_sel_fine dvdd dvss sg13cmos5l_inv_2
XXR4 avss XR4/R1_1 XR4/R2_0 XR4/R1_1 XR4/R2_2 XR4/R1_3 XR4/R2_2 XR4/R1_3 XR4/R2_4
+ XR4/R1_5 XR4/R2_4 XR4/R1_5 XR4/R2_6 XR4/R1_7 XR4/R2_6 XR4/R1_7 ref_in rhigh_GJN3VD
Xsg13cmos5l_antennanp_0 ref_sel_coarse dvdd dvss sg13cmos5l_antennanp
Xbias_pstack_0[0] x3/avdd C2/c2 x13[9]/shld2 x3/avdd enb_std_3v3 pbias pcasc bias_pstack
Xbias_pstack_0[1] x3/avdd C2/c2 x13[9]/shld2 x3/avdd enb_std_3v3 pbias pcasc bias_pstack
Xbias_pstack_0[2] x3/avdd C2/c2 x13[9]/shld2 x3/avdd enb_std_3v3 pbias pcasc bias_pstack
Xsg13cmos5l_antennanp_1 ena_snk_test0 dvdd dvss sg13cmos5l_antennanp
Xbias_pstack_1 x3/avdd C2/c2 x13[9]/shld2 x3/avdd enb_coarse_3v3 pbias pcasc bias_pstack
Xsg13cmos5l_antennanp_2 ena dvdd dvss sg13cmos5l_antennanp
Xsg13cmos5l_antennanp_3 ena_src_test0 dvdd dvss sg13cmos5l_antennanp
Xbias_pstack_2[0] x3/avdd src_test0 x13[9]/shld2 x3/avdd level_shift_6/out pbias pcasc
+ bias_pstack
Xbias_pstack_2[1] x3/avdd src_test0 x13[9]/shld2 x3/avdd level_shift_6/out pbias pcasc
+ bias_pstack
Xbias_pstack_3[0] x3/avdd C2/c2 pbias x3/avdd x3/avdd bias_pset2_0/pbias pcasc bias_pstack
Xbias_pstack_3[1] x3/avdd C2/c2 pbias x3/avdd x3/avdd bias_pset2_0/pbias pcasc bias_pstack
Xsg13cmos5l_antennanp_4 ref_sel_vbg dvdd dvss sg13cmos5l_antennanp
Xbias_pset2_0 bias_pset2_0/pbias pcasc enb_vbg_3v3 bias_pset_1/itail pbias x3/avdd
+ x3/avdd bias_pset2
Xsg13cmos5l_antennanp_5 ref_sel_fine dvdd dvss sg13cmos5l_antennanp
XC2 pbias C2/c2 capacitor_UPRECB
Xlevel_shift_0 level_shift_0/in_n ena ena_3v3 avss x3/avdd level_shift
Xlevel_shift_1 ref_sel_vbg level_shift_2/in_n enb_vbg_3v3 avss x3/avdd level_shift
Xlevel_shift_2 level_shift_2/in_n ref_sel_vbg ena_vbg_3v3 avss x3/avdd level_shift
Xsg13cmos5l_decap_4_0 dvdd dvss sg13cmos5l_decap_4
Xrhigh_AFSZTU_0 avss C2/c2 rhigh_AFSZTU_0/R2_1 rhigh_AFSZTU_0/R1_2 rhigh_AFSZTU_0/R2_1
+ rhigh_AFSZTU_0/R1_2 rhigh_AFSZTU_0/R2_3 rhigh_AFSZTU_0/R1_4 rhigh_AFSZTU_0/R2_3
+ rhigh_AFSZTU_0/R1_4 rhigh_AFSZTU_0/R2_5 rhigh_AFSZTU_0/R1_6 rhigh_AFSZTU_0/R2_5
+ rhigh_AFSZTU_0/R1_6 rhigh_AFSZTU_0/R2_7 rhigh_AFSZTU_0/R1_8 rhigh_AFSZTU_0/R2_7
+ rhigh_AFSZTU_0/R1_8 rhigh_AFSZTU_0/R2_9 rhigh_AFSZTU_0/R1_9 rhigh_AFSZTU_0/R2_9
+ rhigh_AFSZTU_0/R1_9 rhigh_AFSZTU_0/R2_11 rhigh_AFSZTU_0/R1_12 rhigh_AFSZTU_0/R2_11
+ rhigh_AFSZTU_0/R1_12 rhigh_AFSZTU_0/R2_13 rhigh_AFSZTU_0/R1_14 rhigh_AFSZTU_0/R2_13
+ rhigh_AFSZTU_0/R1_14 rhigh_AFSZTU_0/R2_15 rhigh_AFSZTU_0/R1_16 rhigh_AFSZTU_0/R2_15
+ rhigh_AFSZTU_0/R1_16 rhigh_AFSZTU_0/R2_17 rhigh_AFSZTU_0/R1_18 rhigh_AFSZTU_0/R2_17
+ rhigh_AFSZTU_0/R1_18 rhigh_AFSZTU_0/R2_19 avss rhigh_AFSZTU_0/R2_19 rhigh_AFSZTU
Xsg13cmos5l_decap_4_1 dvdd dvss sg13cmos5l_decap_4
Xlevel_shift_3 level_shift_3/in_n level_shift_3/in_p enb_coarse_3v3 avss x3/avdd level_shift
Xx12 x12/in_n ena_snk_test0 ena_test0_3v3 avss x3/avdd level_shift
Xlevel_shift_4 level_shift_4/in_n level_shift_4/in_p enb_std_3v3 avss x3/avdd level_shift
Xbias_nset_0[0] XR4/R2_0 avss avss avss avss nbias ncasc ena_3v3 bias_nset
Xbias_nset_0[1] XR4/R2_0 avss avss avss avss nbias ncasc ena_3v3 bias_nset
Xbias_nset_0[2] XR4/R2_0 avss avss avss avss nbias ncasc ena_3v3 bias_nset
Xbias_nset_0[3] XR4/R2_0 avss avss avss avss nbias ncasc ena_3v3 bias_nset
Xbias_nset_0[4] XR4/R2_0 avss avss avss avss nbias ncasc ena_3v3 bias_nset
Xbias_nset_0[5] XR4/R2_0 avss avss avss avss nbias ncasc ena_3v3 bias_nset
Xbias_nset_0[6] XR4/R2_0 avss avss avss avss nbias ncasc ena_3v3 bias_nset
Xbias_nset_0[7] XR4/R2_0 avss avss avss avss nbias ncasc ena_3v3 bias_nset
Xbias_nset_0[8] XR4/R2_0 avss avss avss avss nbias ncasc ena_3v3 bias_nset
Xbias_nset_0[9] XR4/R2_0 avss avss avss avss nbias ncasc ena_3v3 bias_nset
Xbias_nset_0[10] XR4/R2_0 avss avss avss avss nbias ncasc ena_3v3 bias_nset
Xbias_nset_0[11] XR4/R2_0 avss avss avss avss nbias ncasc ena_3v3 bias_nset
Xbias_nset_0[12] XR4/R2_0 avss avss avss avss nbias ncasc ena_3v3 bias_nset
Xbias_nset_0[13] XR4/R2_0 avss avss avss avss nbias ncasc ena_3v3 bias_nset
Xbias_nset_0[14] XR4/R2_0 avss avss avss avss nbias ncasc ena_3v3 bias_nset
Xbias_nset_0[15] XR4/R2_0 avss avss avss avss nbias ncasc ena_3v3 bias_nset
Xsg13cmos5l_decap_4_2 dvdd dvss sg13cmos5l_decap_4
Xsg13cmos5l_nand2_1_0 level_shift_4/in_p sg13cmos5l_nand2_1_3/Y ref_sel_vbg dvdd dvss
+ sg13cmos5l_nand2_1
Xx13[0] x3/avdd C2/c2 x13[9]/shld2 x3/avdd enb_fine_3v3 pbias pcasc bias_pstack
Xx13[1] x3/avdd C2/c2 x13[9]/shld2 x3/avdd enb_fine_3v3 pbias pcasc bias_pstack
Xx13[2] x3/avdd C2/c2 x13[9]/shld2 x3/avdd enb_fine_3v3 pbias pcasc bias_pstack
Xx13[3] x3/avdd C2/c2 x13[9]/shld2 x3/avdd enb_fine_3v3 pbias pcasc bias_pstack
Xx13[4] x3/avdd C2/c2 x13[9]/shld2 x3/avdd enb_fine_3v3 pbias pcasc bias_pstack
Xx13[5] x3/avdd C2/c2 x13[9]/shld2 x3/avdd enb_fine_3v3 pbias pcasc bias_pstack
Xx13[6] x3/avdd C2/c2 x13[9]/shld2 x3/avdd enb_fine_3v3 pbias pcasc bias_pstack
Xx13[7] x3/avdd C2/c2 x13[9]/shld2 x3/avdd enb_fine_3v3 pbias pcasc bias_pstack
Xx13[8] x3/avdd C2/c2 x13[9]/shld2 x3/avdd enb_fine_3v3 pbias pcasc bias_pstack
Xx13[9] x3/avdd C2/c2 x13[9]/shld2 x3/avdd enb_fine_3v3 pbias pcasc bias_pstack
Xx13[10] x3/avdd C2/c2 x13[9]/shld2 x3/avdd enb_fine_3v3 pbias pcasc bias_pstack
Xx13[11] x3/avdd C2/c2 x13[9]/shld2 x3/avdd enb_fine_3v3 pbias pcasc bias_pstack
Xx13[12] x3/avdd C2/c2 x13[9]/shld2 x3/avdd enb_fine_3v3 pbias pcasc bias_pstack
Xx13[13] x3/avdd C2/c2 x13[9]/shld2 x3/avdd enb_fine_3v3 pbias pcasc bias_pstack
Xx13[14] x3/avdd C2/c2 x13[9]/shld2 x3/avdd enb_fine_3v3 pbias pcasc bias_pstack
Xx13[15] x3/avdd C2/c2 x13[9]/shld2 x3/avdd enb_fine_3v3 pbias pcasc bias_pstack
Xlevel_shift_5 level_shift_5/in_n level_shift_5/in_p enb_fine_3v3 avss x3/avdd level_shift
Xsg13cmos5l_decap_4_3 dvdd dvss sg13cmos5l_decap_4
Xsg13cmos5l_nand2_1_1 level_shift_3/in_p sg13cmos5l_nand2_1_4/Y ref_sel_vbg dvdd dvss
+ sg13cmos5l_nand2_1
Xlevel_shift_6 ena_src_test0 level_shift_6/in_p level_shift_6/out avss x3/avdd level_shift
Xsg13cmos5l_nor2_1_1 sg13cmos5l_nor2_1_1/Y ref_sel_coarse sg13cmos5l_inv_2_7/Y dvdd
+ dvss sg13cmos5l_nor2_1
Xsg13cmos5l_decap_4_4 dvdd dvss sg13cmos5l_decap_4
Xsg13cmos5l_nand2_1_2 level_shift_5/in_p sg13cmos5l_nor2_1_1/Y ref_sel_vbg dvdd dvss
+ sg13cmos5l_nand2_1
Xsg13cmos5l_decap_4_5 dvdd dvss sg13cmos5l_decap_4
Xsg13cmos5l_nand2_1_3 sg13cmos5l_nand2_1_3/Y sg13cmos5l_inv_2_7/Y ref_sel_coarse dvdd
+ dvss sg13cmos5l_nand2_1
Xsg13cmos5l_decap_4_6 dvdd dvss sg13cmos5l_decap_4
Xsg13cmos5l_nand2_1_4 sg13cmos5l_nand2_1_4/Y ref_sel_coarse ref_sel_fine dvdd dvss
+ sg13cmos5l_nand2_1
.ends

.subckt bias_generator_ben250nm sink_ena[1] sink_ena[0] sink_ibias nbias bias_nstack_3/shld2
+ bias_nstack_3/shld3 ncasc bias_nstack_1/a_1030_2157# avdd dvdd dvss sub
Xbias_nstack_0[0] bias_nstack_0[7]/itail bias_nstack_3/shld2 bias_nstack_3/shld3 sub
+ sub nbias ncasc sub bias_nstack
Xbias_nstack_0[1] bias_nstack_0[7]/itail bias_nstack_3/shld2 bias_nstack_3/shld3 sub
+ sub nbias ncasc sub bias_nstack
Xbias_nstack_0[2] bias_nstack_0[7]/itail bias_nstack_3/shld2 bias_nstack_3/shld3 sub
+ sub nbias ncasc sub bias_nstack
Xbias_nstack_0[3] bias_nstack_0[7]/itail bias_nstack_3/shld2 bias_nstack_3/shld3 sub
+ sub nbias ncasc sub bias_nstack
Xbias_nstack_0[4] bias_nstack_0[7]/itail bias_nstack_3/shld2 bias_nstack_3/shld3 sub
+ sub nbias ncasc sub bias_nstack
Xbias_nstack_0[5] bias_nstack_0[7]/itail bias_nstack_3/shld2 bias_nstack_3/shld3 sub
+ sub nbias ncasc sub bias_nstack
Xbias_nstack_0[6] bias_nstack_0[7]/itail bias_nstack_3/shld2 bias_nstack_3/shld3 sub
+ sub nbias ncasc sub bias_nstack
Xbias_nstack_0[7] bias_nstack_0[7]/itail bias_nstack_3/shld2 bias_nstack_3/shld3 sub
+ sub nbias ncasc sub bias_nstack
Xsg13cmos5l_inv_2_0 level_shift_0/in_n sink_ena[1] dvdd dvss sg13cmos5l_inv_2
Xbias_nstack_1 sink_ibias bias_nstack_3/shld2 bias_nstack_3/shld3 sub bias_nstack_1/a_1030_2157#
+ nbias ncasc level_shift_4/out bias_nstack
Xbias_nstack_3 sink_ibias bias_nstack_3/shld2 bias_nstack_3/shld3 sub bias_nstack_3/a_1030_2157#
+ nbias ncasc level_shift_0/out bias_nstack
Xsg13cmos5l_inv_2_4 level_shift_4/in_n sink_ena[0] dvdd dvss sg13cmos5l_inv_2
Xsg13cmos5l_antennanp_0 sink_ena[1] dvdd dvss sg13cmos5l_antennanp
Xsg13cmos5l_antennanp_4 sink_ena[0] dvdd dvss sg13cmos5l_antennanp
Xlevel_shift_0 level_shift_0/in_n sink_ena[1] level_shift_0/out sub avdd level_shift
Xsg13cmos5l_decap_4_0 dvdd dvss sg13cmos5l_decap_4
Xlevel_shift_4 level_shift_4/in_n sink_ena[0] level_shift_4/out sub avdd level_shift
Xsg13cmos5l_decap_4_2 dvdd dvss sg13cmos5l_decap_4
.ends

.subckt bias_generator_be0p_v2 pcasc source_ena[4] source_ena[3] source_ena[2] source_ena[1]
+ source_ibias sub dvdd avdd bias_pstack_3/shld3 pbias bias_pstack_3/shld2 source_ena[0]
+ dvss
Xsg13cmos5l_inv_2_0 sg13cmos5l_inv_2_0/Y source_ena[1] dvdd dvss sg13cmos5l_inv_2
Xsg13cmos5l_inv_2_1 sg13cmos5l_inv_2_1/Y source_ena[2] dvdd dvss sg13cmos5l_inv_2
Xsg13cmos5l_inv_2_2 sg13cmos5l_inv_2_2/Y source_ena[3] dvdd dvss sg13cmos5l_inv_2
Xsg13cmos5l_inv_2_4 sg13cmos5l_inv_2_4/Y source_ena[4] dvdd dvss sg13cmos5l_inv_2
Xsg13cmos5l_inv_2_3 sg13cmos5l_inv_2_3/Y source_ena[0] dvdd dvss sg13cmos5l_inv_2
Xsg13cmos5l_antennanp_0 source_ena[1] dvdd dvss sg13cmos5l_antennanp
Xsg13cmos5l_antennanp_1 source_ena[2] dvdd dvss sg13cmos5l_antennanp
Xbias_pstack_0[0] avdd source_ibias bias_pstack_3/shld2 bias_pstack_3/shld3 level_shift_4[1]/out
+ pbias pcasc bias_pstack
Xbias_pstack_0[1] avdd source_ibias bias_pstack_3/shld2 bias_pstack_3/shld3 level_shift_4[1]/out
+ pbias pcasc bias_pstack
Xbias_pstack_0[2] avdd source_ibias bias_pstack_3/shld2 bias_pstack_3/shld3 level_shift_4[1]/out
+ pbias pcasc bias_pstack
Xbias_pstack_0[3] avdd source_ibias bias_pstack_3/shld2 bias_pstack_3/shld3 level_shift_4[1]/out
+ pbias pcasc bias_pstack
Xbias_pstack_0[4] avdd source_ibias bias_pstack_3/shld2 bias_pstack_3/shld3 level_shift_4[1]/out
+ pbias pcasc bias_pstack
Xbias_pstack_0[5] avdd source_ibias bias_pstack_3/shld2 bias_pstack_3/shld3 level_shift_4[1]/out
+ pbias pcasc bias_pstack
Xbias_pstack_0[6] avdd source_ibias bias_pstack_3/shld2 bias_pstack_3/shld3 level_shift_4[1]/out
+ pbias pcasc bias_pstack
Xbias_pstack_0[7] avdd source_ibias bias_pstack_3/shld2 bias_pstack_3/shld3 level_shift_4[1]/out
+ pbias pcasc bias_pstack
Xsg13cmos5l_antennanp_2 source_ena[3] dvdd dvss sg13cmos5l_antennanp
Xbias_pstack_1[0] avdd source_ibias bias_pstack_3/shld2 bias_pstack_3/shld3 level_shift_4[2]/out
+ pbias pcasc bias_pstack
Xbias_pstack_1[1] avdd source_ibias bias_pstack_3/shld2 bias_pstack_3/shld3 level_shift_4[2]/out
+ pbias pcasc bias_pstack
Xbias_pstack_1[2] avdd source_ibias bias_pstack_3/shld2 bias_pstack_3/shld3 level_shift_4[2]/out
+ pbias pcasc bias_pstack
Xbias_pstack_1[3] avdd source_ibias bias_pstack_3/shld2 bias_pstack_3/shld3 level_shift_4[2]/out
+ pbias pcasc bias_pstack
Xsg13cmos5l_antennanp_3 source_ena[0] dvdd dvss sg13cmos5l_antennanp
Xbias_pstack_2[0] avdd source_ibias bias_pstack_3/shld2 bias_pstack_3/shld3 level_shift_4[3]/out
+ pbias pcasc bias_pstack
Xbias_pstack_2[1] avdd source_ibias bias_pstack_3/shld2 bias_pstack_3/shld3 level_shift_4[3]/out
+ pbias pcasc bias_pstack
Xsg13cmos5l_antennanp_4 source_ena[4] dvdd dvss sg13cmos5l_antennanp
Xbias_pstack_4[0] avdd source_ibias bias_pstack_3/shld2 bias_pstack_3/shld3 level_shift_4[0]/out
+ pbias pcasc bias_pstack
Xbias_pstack_4[1] avdd source_ibias bias_pstack_3/shld2 bias_pstack_3/shld3 level_shift_4[0]/out
+ pbias pcasc bias_pstack
Xbias_pstack_4[2] avdd source_ibias bias_pstack_3/shld2 bias_pstack_3/shld3 level_shift_4[0]/out
+ pbias pcasc bias_pstack
Xbias_pstack_4[3] avdd source_ibias bias_pstack_3/shld2 bias_pstack_3/shld3 level_shift_4[0]/out
+ pbias pcasc bias_pstack
Xbias_pstack_4[4] avdd source_ibias bias_pstack_3/shld2 bias_pstack_3/shld3 level_shift_4[0]/out
+ pbias pcasc bias_pstack
Xbias_pstack_4[5] avdd source_ibias bias_pstack_3/shld2 bias_pstack_3/shld3 level_shift_4[0]/out
+ pbias pcasc bias_pstack
Xbias_pstack_4[6] avdd source_ibias bias_pstack_3/shld2 bias_pstack_3/shld3 level_shift_4[0]/out
+ pbias pcasc bias_pstack
Xbias_pstack_4[7] avdd source_ibias bias_pstack_3/shld2 bias_pstack_3/shld3 level_shift_4[0]/out
+ pbias pcasc bias_pstack
Xbias_pstack_4[8] avdd source_ibias bias_pstack_3/shld2 bias_pstack_3/shld3 level_shift_4[0]/out
+ pbias pcasc bias_pstack
Xbias_pstack_4[9] avdd source_ibias bias_pstack_3/shld2 bias_pstack_3/shld3 level_shift_4[0]/out
+ pbias pcasc bias_pstack
Xbias_pstack_4[10] avdd source_ibias bias_pstack_3/shld2 bias_pstack_3/shld3 level_shift_4[0]/out
+ pbias pcasc bias_pstack
Xbias_pstack_4[11] avdd source_ibias bias_pstack_3/shld2 bias_pstack_3/shld3 level_shift_4[0]/out
+ pbias pcasc bias_pstack
Xbias_pstack_4[12] avdd source_ibias bias_pstack_3/shld2 bias_pstack_3/shld3 level_shift_4[0]/out
+ pbias pcasc bias_pstack
Xbias_pstack_4[13] avdd source_ibias bias_pstack_3/shld2 bias_pstack_3/shld3 level_shift_4[0]/out
+ pbias pcasc bias_pstack
Xbias_pstack_4[14] avdd source_ibias bias_pstack_3/shld2 bias_pstack_3/shld3 level_shift_4[0]/out
+ pbias pcasc bias_pstack
Xbias_pstack_4[15] avdd source_ibias bias_pstack_3/shld2 bias_pstack_3/shld3 level_shift_4[0]/out
+ pbias pcasc bias_pstack
Xbias_pstack_3 avdd source_ibias bias_pstack_3/shld2 bias_pstack_3/shld3 bias_pstack_3/enb
+ pbias pcasc bias_pstack
Xsg13cmos5l_decap_4_0 dvdd dvss sg13cmos5l_decap_4
Xsg13cmos5l_decap_4_1 dvdd dvss sg13cmos5l_decap_4
Xlevel_shift_4[0] source_ena[4] sg13cmos5l_inv_2_4/Y level_shift_4[0]/out sub avdd
+ level_shift
Xlevel_shift_4[1] source_ena[3] sg13cmos5l_inv_2_2/Y level_shift_4[1]/out sub avdd
+ level_shift
Xlevel_shift_4[2] source_ena[2] sg13cmos5l_inv_2_1/Y level_shift_4[2]/out sub avdd
+ level_shift
Xlevel_shift_4[3] source_ena[1] sg13cmos5l_inv_2_0/Y level_shift_4[3]/out sub avdd
+ level_shift
Xlevel_shift_4[4] source_ena[0] sg13cmos5l_inv_2_3/Y bias_pstack_3/enb sub avdd level_shift
Xsg13cmos5l_decap_4_2 dvdd dvss sg13cmos5l_decap_4
Xsg13cmos5l_decap_4_3 dvdd dvss sg13cmos5l_decap_4
Xsg13cmos5l_decap_4_4 dvdd dvss sg13cmos5l_decap_4
.ends

.subckt sg13cmos5l_ocd_ip__biasgen2 ena vbg ref_sel_vbg idac1_source_ibias idac2_source[4]
+ idac2_source[3] idac2_source[2] idac2_source[1] idac2_source[0] idac2_source_ibias
+ idac1_source[0] idac1_source[1] idac1_source[2] idac1_source[3] idac1_source[4]
+ voltgen_source[4] voltgen_source[3] voltgen_source[2] voltgen_source[1] voltgen_source[0]
+ voltgen_source_ibias ref_sel_coarse ref_sel_fine bandgap_sink2_ibias bandgap_sink2[0]
+ bandgap_sink2[1] bandgap_sink1[0] bandgap_sink1[1] bandgap_sink1[2] voltgen_sink1[0]
+ voltgen_sink1[1] voltgen_sink1[2] voltgen_sink2[0] voltgen_sink2[1] voltgen_sink2[2]
+ voltgen_sink2_ibias voltgen_sink1_ibias bandgap_sink1_ibias ref_in avdd sub dvss
+ dvdd
Xbias_nstack_0[0] bias_nstack_0[4]/itail sub sub sub bias_nstack_0[4]/a_1030_2157#
+ bias_nstack_0[4]/nbias bias_nstack_0[4]/ncasc sub bias_nstack
Xbias_nstack_0[1] bias_nstack_0[4]/itail sub sub sub bias_nstack_0[4]/a_1030_2157#
+ bias_nstack_0[4]/nbias bias_nstack_0[4]/ncasc sub bias_nstack
Xbias_nstack_0[2] bias_nstack_0[4]/itail sub sub sub bias_nstack_0[4]/a_1030_2157#
+ bias_nstack_0[4]/nbias bias_nstack_0[4]/ncasc sub bias_nstack
Xbias_nstack_0[3] bias_nstack_0[4]/itail sub sub sub bias_nstack_0[4]/a_1030_2157#
+ bias_nstack_0[4]/nbias bias_nstack_0[4]/ncasc sub bias_nstack
Xbias_nstack_0[4] bias_nstack_0[4]/itail sub sub sub bias_nstack_0[4]/a_1030_2157#
+ bias_nstack_0[4]/nbias bias_nstack_0[4]/ncasc sub bias_nstack
Xbias_pstack_0[0] avdd bias_pstack_0[4]/itail avdd avdd avdd bias_pstack_0[4]/pbias
+ bias_pstack_0[4]/pcasc bias_pstack
Xbias_pstack_0[1] avdd bias_pstack_0[4]/itail avdd avdd avdd bias_pstack_0[4]/pbias
+ bias_pstack_0[4]/pcasc bias_pstack
Xbias_pstack_0[2] avdd bias_pstack_0[4]/itail avdd avdd avdd bias_pstack_0[4]/pbias
+ bias_pstack_0[4]/pcasc bias_pstack
Xbias_pstack_0[3] avdd bias_pstack_0[4]/itail avdd avdd avdd bias_pstack_0[4]/pbias
+ bias_pstack_0[4]/pcasc bias_pstack
Xbias_pstack_0[4] avdd bias_pstack_0[4]/itail avdd avdd avdd bias_pstack_0[4]/pbias
+ bias_pstack_0[4]/pcasc bias_pstack
Xbias_generator_ben1um_0 voltgen_sink2[2] voltgen_sink2[1] voltgen_sink2[0] voltgen_sink2_ibias
+ bias_nstack_0[4]/ncasc bias_generator_ben1um_0/bias_nstack_0[9]/itail sub dvdd bias_nstack_0[4]/nbias
+ sub avdd dvss sub sub bias_generator_ben1um
Xbias_generator_ben1um_1 voltgen_sink1[2] voltgen_sink1[1] voltgen_sink1[0] voltgen_sink1_ibias
+ bias_nstack_0[4]/ncasc bias_generator_ben1um_1/bias_nstack_0[9]/itail sub dvdd bias_nstack_0[4]/nbias
+ sub avdd dvss sub sub bias_generator_ben1um
Xbias_generator_ben1um_2 bandgap_sink1[2] bandgap_sink1[1] bandgap_sink1[0] bandgap_sink1_ibias
+ bias_nstack_0[4]/ncasc bias_generator_ben1um_2/bias_nstack_0[9]/itail sub dvdd bias_nstack_0[4]/nbias
+ sub avdd dvss sub sub bias_generator_ben1um
Xbias_generator_fe_v2_0 ena vbg bias_generator_fe_v2_0/src_test0 dvss ref_in bias_nstack_0[4]/nbias
+ bias_pstack_0[4]/pcasc bias_pstack_0[4]/pbias bias_generator_fe_v2_0/snk_test0 dvss
+ bias_nstack_0[4]/ncasc ref_sel_fine ref_sel_coarse avdd ref_sel_vbg sub dvdd avdd
+ sub dvss bias_generator_fe_v2
Xbias_generator_ben250nm_0 bandgap_sink2[1] bandgap_sink2[0] bandgap_sink2_ibias bias_nstack_0[4]/nbias
+ sub sub bias_nstack_0[4]/ncasc bias_nstack_0[4]/a_1030_2157# avdd dvdd dvss sub
+ bias_generator_ben250nm
Xbias_generator_be0p_v2_0 bias_pstack_0[4]/pcasc voltgen_source[4] voltgen_source[3]
+ voltgen_source[2] voltgen_source[1] voltgen_source_ibias sub dvdd avdd avdd bias_pstack_0[4]/pbias
+ avdd voltgen_source[0] dvss bias_generator_be0p_v2
Xbias_generator_be0p_v2_1 bias_pstack_0[4]/pcasc idac2_source[4] idac2_source[3] idac2_source[2]
+ idac2_source[1] idac2_source_ibias sub dvdd avdd avdd bias_pstack_0[4]/pbias avdd
+ idac2_source[0] dvss bias_generator_be0p_v2
Xbias_generator_be0p_v2_2 bias_pstack_0[4]/pcasc idac1_source[4] idac1_source[3] idac1_source[2]
+ idac1_source[1] idac1_source_ibias sub dvdd avdd avdd bias_pstack_0[4]/pbias avdd
+ idac1_source[0] dvss bias_generator_be0p_v2
.ends

* Black-box entry subcircuit for slot2_wrapper abstract view
.subckt slot2_wrapper s2_an[0] s2_an[1] s2_an_0_esd s2_an_1_esd vbias dig_in[23] dig_in[22]
+ dig_in[21] dig_in[20] dig_in[19] dig_in[18] dig_in[17] dig_in[16] dig_in[15] dig_in[14]
+ dig_in[13] dig_in[12] dig_in[11] dig_in[10] dig_in[9] dig_in[8] dig_in[7] dig_in[6]
+ dig_in[5] dig_in[4] dig_in[3] dig_in[2] dig_in[1] dig_in[0] dig_out[11] dig_out[10]
+ dig_out[9] dig_out[8] dig_out[7] dig_out[6] dig_out[5] dig_out[4] dig_out[3] dig_out[2]
+ dig_out[1] dig_out[0] ibias0 ibias1 analog_bus3 analog_bus2 analog_bus1 analog_bus0
+ vss_1v2 vdd_1v2 vss_3v3 vdd_3v3 enable clk reset
.ends

* Black-box entry subcircuit for slot6_wrapper abstract view
.subckt slot6_wrapper s6_an[0] s6_an[1] s6_an_0_esd s6_an_1_esd vbias dig_in[23] dig_in[22]
+ dig_in[21] dig_in[20] dig_in[19] dig_in[18] dig_in[17] dig_in[16] dig_in[15] dig_in[14]
+ dig_in[13] dig_in[12] dig_in[11] dig_in[10] dig_in[9] dig_in[8] dig_in[7] dig_in[6]
+ dig_in[5] dig_in[4] dig_in[3] dig_in[2] dig_in[1] dig_in[0] dig_out[11] dig_out[10]
+ dig_out[9] dig_out[8] dig_out[7] dig_out[6] dig_out[5] dig_out[4] dig_out[3] dig_out[2]
+ dig_out[1] dig_out[0] ibias0 ibias1 analog_bus3 analog_bus2 analog_bus1 analog_bus0
+ vss_1v2 vdd_1v2 vss_3v3 vdd_3v3 enable clk reset
.ends

* Black-box entry subcircuit for slot10_wrapper abstract view
.subckt slot10_wrapper s10_an[0] s10_an[1] s10_an[2] s10_an_0_esd s10_an_1_esd s10_an_2_esd
+ vbias dig_in[23] dig_in[22] dig_in[21] dig_in[20] dig_in[19] dig_in[18] dig_in[17]
+ dig_in[16] dig_in[15] dig_in[14] dig_in[13] dig_in[12] dig_in[11] dig_in[10] dig_in[9]
+ dig_in[8] dig_in[7] dig_in[6] dig_in[5] dig_in[4] dig_in[3] dig_in[2] dig_in[1]
+ dig_in[0] dig_out[11] dig_out[10] dig_out[9] dig_out[8] dig_out[7] dig_out[6] dig_out[5]
+ dig_out[4] dig_out[3] dig_out[2] dig_out[1] dig_out[0] ibias0 ibias1 analog_bus3
+ analog_bus2 analog_bus1 analog_bus0 vss_1v2 vdd_1v2 vss_3v3 vdd_3v3 enable clk reset
.ends

* Black-box entry subcircuit for slot14_wrapper abstract view
.subckt slot14_wrapper s14_an[0] s14_an[1] s14_an[2] s14_an_0_esd s14_an_1_esd s14_an_2_esd
+ vbias dig_in[23] dig_in[22] dig_in[21] dig_in[20] dig_in[19] dig_in[18] dig_in[17]
+ dig_in[16] dig_in[15] dig_in[14] dig_in[13] dig_in[12] dig_in[11] dig_in[10] dig_in[9]
+ dig_in[8] dig_in[7] dig_in[6] dig_in[5] dig_in[4] dig_in[3] dig_in[2] dig_in[1]
+ dig_in[0] dig_out[11] dig_out[10] dig_out[9] dig_out[8] dig_out[7] dig_out[6] dig_out[5]
+ dig_out[4] dig_out[3] dig_out[2] dig_out[1] dig_out[0] ibias0 ibias1 analog_bus3
+ analog_bus2 analog_bus1 analog_bus0 vss_1v2 vdd_1v2 vss_3v3 vdd_3v3 enable clk reset
.ends

* Black-box entry subcircuit for slot18_wrapper abstract view
.subckt slot18_wrapper s18_an[0] s18_an[1] s18_an_0_esd s18_an_1_esd vbias dig_in[23]
+ dig_in[22] dig_in[21] dig_in[20] dig_in[19] dig_in[18] dig_in[17] dig_in[16] dig_in[15]
+ dig_in[14] dig_in[13] dig_in[12] dig_in[11] dig_in[10] dig_in[9] dig_in[8] dig_in[7]
+ dig_in[6] dig_in[5] dig_in[4] dig_in[3] dig_in[2] dig_in[1] dig_in[0] dig_out[11]
+ dig_out[10] dig_out[9] dig_out[8] dig_out[7] dig_out[6] dig_out[5] dig_out[4] dig_out[3]
+ dig_out[2] dig_out[1] dig_out[0] ibias0 ibias1 analog_bus3 analog_bus2 analog_bus1
+ analog_bus0 vss_1v2 vdd_1v2 vss_3v3 vdd_3v3 enable clk reset
.ends

* Black-box entry subcircuit for slot1_wrapper abstract view
.subckt slot1_wrapper s1_an[0] s1_an[1] s1_an_0_esd vbias dig_in[23] dig_in[22] dig_in[21]
+ dig_in[20] dig_in[19] dig_in[18] dig_in[17] dig_in[16] dig_in[15] dig_in[14] dig_in[13]
+ dig_in[12] dig_in[11] dig_in[10] dig_in[9] dig_in[8] dig_in[7] dig_in[6] dig_in[5]
+ dig_in[4] dig_in[3] dig_in[2] dig_in[1] dig_in[0] dig_out[11] dig_out[10] dig_out[9]
+ dig_out[8] dig_out[7] dig_out[6] dig_out[5] dig_out[4] dig_out[3] dig_out[2] dig_out[1]
+ dig_out[0] ibias0 ibias1 analog_bus3 analog_bus2 analog_bus1 analog_bus0 vss_1v2
+ vdd_1v2 vss_3v3 vdd_3v3 enable clk reset
.ends

* Black-box entry subcircuit for slot5_wrapper abstract view
.subckt slot5_wrapper s5_an[0] s5_an[1] s5_an[2] s5_an_0_esd s5_an_1_esd vbias dig_in[23]
+ dig_in[22] dig_in[21] dig_in[20] dig_in[19] dig_in[18] dig_in[17] dig_in[16] dig_in[15]
+ dig_in[14] dig_in[13] dig_in[12] dig_in[11] dig_in[10] dig_in[9] dig_in[8] dig_in[7]
+ dig_in[6] dig_in[5] dig_in[4] dig_in[3] dig_in[2] dig_in[1] dig_in[0] dig_out[11]
+ dig_out[10] dig_out[9] dig_out[8] dig_out[7] dig_out[6] dig_out[5] dig_out[4] dig_out[3]
+ dig_out[2] dig_out[1] dig_out[0] ibias0 ibias1 analog_bus3 analog_bus2 analog_bus1
+ analog_bus0 vss_1v2 vdd_1v2 vss_3v3 vdd_3v3 enable clk reset
.ends

* Black-box entry subcircuit for slot9_wrapper abstract view
.subckt slot9_wrapper s9_an[0] s9_an[1] s9_an[2] s9_an_0_esd s9_an_1_esd vbias dig_in[23]
+ dig_in[22] dig_in[21] dig_in[20] dig_in[19] dig_in[18] dig_in[17] dig_in[16] dig_in[15]
+ dig_in[14] dig_in[13] dig_in[12] dig_in[11] dig_in[10] dig_in[9] dig_in[8] dig_in[7]
+ dig_in[6] dig_in[5] dig_in[4] dig_in[3] dig_in[2] dig_in[1] dig_in[0] dig_out[11]
+ dig_out[10] dig_out[9] dig_out[8] dig_out[7] dig_out[6] dig_out[5] dig_out[4] dig_out[3]
+ dig_out[2] dig_out[1] dig_out[0] ibias0 ibias1 analog_bus3 analog_bus2 analog_bus1
+ analog_bus0 vss_1v2 vdd_1v2 vss_3v3 vdd_3v3 enable clk reset
.ends

* Black-box entry subcircuit for slot13_wrapper abstract view
.subckt slot13_wrapper s13_an[0] s13_an[1] s13_an_0_esd s13_an_1_esd vbias dig_in[23]
+ dig_in[22] dig_in[21] dig_in[20] dig_in[19] dig_in[18] dig_in[17] dig_in[16] dig_in[15]
+ dig_in[14] dig_in[13] dig_in[12] dig_in[11] dig_in[10] dig_in[9] dig_in[8] dig_in[7]
+ dig_in[6] dig_in[5] dig_in[4] dig_in[3] dig_in[2] dig_in[1] dig_in[0] dig_out[11]
+ dig_out[10] dig_out[9] dig_out[8] dig_out[7] dig_out[6] dig_out[5] dig_out[4] dig_out[3]
+ dig_out[2] dig_out[1] dig_out[0] ibias0 ibias1 analog_bus3 analog_bus2 analog_bus1
+ analog_bus0 vss_1v2 vdd_1v2 vss_3v3 vdd_3v3 enable clk reset
.ends

* Black-box entry subcircuit for slot17_wrapper abstract view
.subckt slot17_wrapper s17_an[0] s17_an[1] s17_an_0_esd s17_an_1_esd vbias dig_in[23]
+ dig_in[22] dig_in[21] dig_in[20] dig_in[19] dig_in[18] dig_in[17] dig_in[16] dig_in[15]
+ dig_in[14] dig_in[13] dig_in[12] dig_in[11] dig_in[10] dig_in[9] dig_in[8] dig_in[7]
+ dig_in[6] dig_in[5] dig_in[4] dig_in[3] dig_in[2] dig_in[1] dig_in[0] dig_out[11]
+ dig_out[10] dig_out[9] dig_out[8] dig_out[7] dig_out[6] dig_out[5] dig_out[4] dig_out[3]
+ dig_out[2] dig_out[1] dig_out[0] ibias0 ibias1 analog_bus3 analog_bus2 analog_bus1
+ analog_bus0 vss_1v2 vdd_1v2 vss_3v3 vdd_3v3 enable clk reset
.ends

* Black-box entry subcircuit for slot4_wrapper abstract view
.subckt slot4_wrapper s4_an[0] vss_1v2 s4_an_0_esd vbias dig_in[23] dig_in[22] dig_in[21]
+ dig_in[20] dig_in[19] dig_in[18] dig_in[17] dig_in[16] dig_in[15] dig_in[14] dig_in[13]
+ dig_in[12] dig_in[11] dig_in[10] dig_in[9] dig_in[8] dig_in[7] dig_in[6] dig_in[5]
+ dig_in[4] dig_in[3] dig_in[2] dig_in[1] dig_in[0] dig_out[11] dig_out[10] dig_out[9]
+ dig_out[8] dig_out[7] dig_out[6] dig_out[5] dig_out[4] dig_out[3] dig_out[2] dig_out[1]
+ dig_out[0] ibias0 ibias1 analog_bus3 analog_bus2 analog_bus1 analog_bus0 vdd_1v2
+ vss_3v3 vdd_3v3 enable clk reset
.ends

* Black-box entry subcircuit for slot8_wrapper abstract view
.subckt slot8_wrapper vss_3v3 s8_an[0] s8_an_0_esd vbias dig_in[23] dig_in[22] dig_in[21]
+ dig_in[20] dig_in[19] dig_in[18] dig_in[17] dig_in[16] dig_in[15] dig_in[14] dig_in[13]
+ dig_in[12] dig_in[11] dig_in[10] dig_in[9] dig_in[8] dig_in[7] dig_in[6] dig_in[5]
+ dig_in[4] dig_in[3] dig_in[2] dig_in[1] dig_in[0] dig_out[11] dig_out[10] dig_out[9]
+ dig_out[8] dig_out[7] dig_out[6] dig_out[5] dig_out[4] dig_out[3] dig_out[2] dig_out[1]
+ dig_out[0] ibias0 ibias1 analog_bus3 analog_bus2 analog_bus1 analog_bus0 vss_1v2
+ vdd_1v2 vdd_3v3 enable clk reset
.ends

.subckt pnpMPA_9DZCCL C B E
X0 C B E pnpMPA a=1.4p p=5.4u
.ends

.subckt rhigh_SUDY2Y R1 R2 sub
X0 R1 R2 sub rhigh l=20u w=0.69u
.ends

.subckt bg_res b a d c vss e f g h j k
XXR1[0] k j vss rhigh_SUDY2Y
XXR1[1] XR1[3]/R1 a vss rhigh_SUDY2Y
XXR1[2] XR1[4]/R1 b vss rhigh_SUDY2Y
XXR1[3] XR1[3]/R1 XR1[5]/R2 vss rhigh_SUDY2Y
XXR1[4] XR1[4]/R1 XR1[6]/R2 vss rhigh_SUDY2Y
XXR1[5] XR1[7]/R1 XR1[5]/R2 vss rhigh_SUDY2Y
XXR1[6] XR1[8]/R1 XR1[6]/R2 vss rhigh_SUDY2Y
XXR1[7] XR1[7]/R1 XR1[9]/R2 vss rhigh_SUDY2Y
XXR1[8] XR1[8]/R1 XR1[8]/R2 vss rhigh_SUDY2Y
XXR1[9] XR1[9]/R1 XR1[9]/R2 vss rhigh_SUDY2Y
XXR1[10] XR1[12]/R1 XR1[8]/R2 vss rhigh_SUDY2Y
XXR1[11] XR1[9]/R1 XR1[13]/R2 vss rhigh_SUDY2Y
XXR1[12] XR1[12]/R1 XR1[14]/R2 vss rhigh_SUDY2Y
XXR1[13] XR1[15]/R1 XR1[13]/R2 vss rhigh_SUDY2Y
XXR1[14] XR1[16]/R1 XR1[14]/R2 vss rhigh_SUDY2Y
XXR1[15] XR1[15]/R1 XR1[17]/R2 vss rhigh_SUDY2Y
XXR1[16] XR1[16]/R1 XR1[18]/R2 vss rhigh_SUDY2Y
XXR1[17] XR1[19]/R1 XR1[17]/R2 vss rhigh_SUDY2Y
XXR1[18] XR1[20]/R1 XR1[18]/R2 vss rhigh_SUDY2Y
XXR1[19] XR1[19]/R1 c vss rhigh_SUDY2Y
XXR1[20] XR1[20]/R1 d vss rhigh_SUDY2Y
XXR1[21] f e vss rhigh_SUDY2Y
XXR1[22] h g vss rhigh_SUDY2Y
.ends

.subckt sg13_hv_pmos_NWA9LU D0 S0 G0 D1 S1 G1 w_n481_n524#
X0 D1 G1 S1 w_n481_n524# sg13_hv_pmos ad=1.36p pd=8.68u as=1.36p ps=8.68u w=4u l=1u
X1 S0 G0 D0 w_n481_n524# sg13_hv_pmos ad=1.36p pd=8.68u as=1.36p ps=8.68u w=4u l=1u
.ends

.subckt sg13_hv_nmos_BEVMZW D S G sub
X0 S G D sub sg13_hv_nmos ad=0.34p pd=2.68u as=0.34p ps=2.68u w=1u l=1u
.ends

.subckt sg13_hv_pmos_WYN5QB D S G w_n292_n224#
X0 S G D w_n292_n224# sg13_hv_pmos ad=0.34p pd=2.68u as=0.34p ps=2.68u w=1u l=1u
.ends

.subckt capacitor_UEBLR3 c1 c2
X0 c1 c2 cap_cmomf mm_ok=1 subblock=0 mmax=4 mmin=1 l=26.749u w=48u
.ends

.subckt capacitor_77YAAU c1 c2
X0 c1 c2 cap_cmomf mm_ok=1 subblock=0 mmax=4 mmin=1 l=20u w=20u
.ends

.subckt capacitor_C4E5CZ c1 c2
X0 c1 c2 cap_cmomf mm_ok=1 subblock=0 mmax=4 mmin=1 l=7u w=13.7u
.ends

.subckt sg13_hv_nmos_2UD3QN D S G sub
X0 S G D sub sg13_hv_nmos ad=0.68p pd=4.68u as=0.68p ps=4.68u w=2u l=0.5u
.ends

.subckt rppd_Y8MW75 R1 R2 sub
X0 R1 R2 sub rppd l=3.4u w=1.41u
.ends

.subckt bg_trim top bot ctrl[15] ctrl[14] ctrl[13] ctrl[12] ctrl[11] ctrl[10] ctrl[9]
+ ctrl[8] ctrl[7] ctrl[6] ctrl[5] ctrl[4] ctrl[3] ctrl[2] ctrl[1] ctrl[0] vss
XXM0[0] vss vss vss vss sg13_hv_nmos_2UD3QN
XXM0[1] bot XM0[1]/S ctrl[0] vss sg13_hv_nmos_2UD3QN
XXM0[2] bot XM0[2]/S ctrl[1] vss sg13_hv_nmos_2UD3QN
XXM0[3] bot XM0[3]/S ctrl[2] vss sg13_hv_nmos_2UD3QN
XXM0[4] bot XM0[4]/S ctrl[3] vss sg13_hv_nmos_2UD3QN
XXM0[5] bot XM0[5]/S ctrl[4] vss sg13_hv_nmos_2UD3QN
XXM0[6] bot XM0[6]/S ctrl[5] vss sg13_hv_nmos_2UD3QN
XXM0[7] bot XM0[7]/S ctrl[6] vss sg13_hv_nmos_2UD3QN
XXM0[8] bot XM0[8]/S ctrl[7] vss sg13_hv_nmos_2UD3QN
XXM0[9] bot XM0[9]/S ctrl[8] vss sg13_hv_nmos_2UD3QN
XXM0[10] bot XM0[10]/S ctrl[9] vss sg13_hv_nmos_2UD3QN
XXM0[11] bot XM0[11]/S ctrl[10] vss sg13_hv_nmos_2UD3QN
XXM0[12] bot XM0[12]/S ctrl[11] vss sg13_hv_nmos_2UD3QN
XXM0[13] bot XM0[13]/S ctrl[12] vss sg13_hv_nmos_2UD3QN
XXM0[14] bot XM0[14]/S ctrl[13] vss sg13_hv_nmos_2UD3QN
XXM0[15] bot XM0[15]/S ctrl[14] vss sg13_hv_nmos_2UD3QN
XXM0[16] bot top ctrl[15] vss sg13_hv_nmos_2UD3QN
XXM0[17] vss vss vss vss sg13_hv_nmos_2UD3QN
Xrppd_Y8MW75_0[0] vss vss vss rppd_Y8MW75
Xrppd_Y8MW75_0[1] XM0[1]/S bot vss rppd_Y8MW75
Xrppd_Y8MW75_0[2] XM0[2]/S XM0[1]/S vss rppd_Y8MW75
Xrppd_Y8MW75_0[3] XM0[3]/S XM0[2]/S vss rppd_Y8MW75
Xrppd_Y8MW75_0[4] XM0[4]/S XM0[3]/S vss rppd_Y8MW75
Xrppd_Y8MW75_0[5] XM0[5]/S XM0[4]/S vss rppd_Y8MW75
Xrppd_Y8MW75_0[6] XM0[6]/S XM0[5]/S vss rppd_Y8MW75
Xrppd_Y8MW75_0[7] XM0[7]/S XM0[6]/S vss rppd_Y8MW75
Xrppd_Y8MW75_0[8] XM0[8]/S XM0[7]/S vss rppd_Y8MW75
Xrppd_Y8MW75_0[9] XM0[9]/S XM0[8]/S vss rppd_Y8MW75
Xrppd_Y8MW75_0[10] XM0[10]/S XM0[9]/S vss rppd_Y8MW75
Xrppd_Y8MW75_0[11] XM0[11]/S XM0[10]/S vss rppd_Y8MW75
Xrppd_Y8MW75_0[12] XM0[12]/S XM0[11]/S vss rppd_Y8MW75
Xrppd_Y8MW75_0[13] XM0[13]/S XM0[12]/S vss rppd_Y8MW75
Xrppd_Y8MW75_0[14] XM0[14]/S XM0[13]/S vss rppd_Y8MW75
Xrppd_Y8MW75_0[15] XM0[15]/S XM0[14]/S vss rppd_Y8MW75
Xrppd_Y8MW75_0[16] top XM0[15]/S vss rppd_Y8MW75
Xrppd_Y8MW75_0[17] top top vss rppd_Y8MW75
.ends

.subckt capacitor_P4YBHP c1 c2
X0 c1 c2 cap_cmomf mm_ok=1 subblock=0 mmax=4 mmin=1 l=16.1u w=12.35u
.ends

.subckt capacitor_4HNWC9 c1 c2
X0 c1 c2 cap_cmomf mm_ok=1 subblock=0 mmax=4 mmin=1 l=10.8u w=21.6u
.ends

.subckt bandgap_unbuffered_v2 vbg bias trim[15] trim[14] trim[13] trim[12] trim[11]
+ trim[10] trim[9] trim[8] trim[7] trim[6] trim[5] trim[4] trim[3] trim[2] trim[1]
+ trim[0] ena ena_b_h XM4/S dvdd dvss vss vdd
Xsg13cmos5l_antennanp_16 ena dvdd dvss sg13cmos5l_antennanp
XXQ2_1 vss vss xtr/bot pnpMPA_9DZCCL
Xx1[0] ena x1[0]/in_p ena_b_h vss vdd level_shift
Xx1[1] x1[1]/in_n trim[15] x1[1]/out vss vdd level_shift
Xx1[2] x1[2]/in_n trim[13] x1[2]/out vss vdd level_shift
Xx1[3] x1[3]/in_n trim[11] x1[3]/out vss vdd level_shift
Xx1[4] x1[4]/in_n trim[9] x1[4]/out vss vdd level_shift
Xx1[5] x1[5]/in_n trim[7] x1[5]/out vss vdd level_shift
Xx1[6] x1[6]/in_n trim[5] x1[6]/out vss vdd level_shift
Xx1[7] x1[7]/in_n trim[3] x1[7]/out vss vdd level_shift
Xx1[8] x1[8]/in_n trim[1] x1[8]/out vss vdd level_shift
Xxamp XM4/S bias ena_b_h XQ1/E xres/e vdd vss se_folded_cascode_p
Xsg13cmos5l_inv_2_0 x1[1]/in_n trim[15] dvdd dvss sg13cmos5l_inv_2
XXQ2_2 vss vss xtr/bot pnpMPA_9DZCCL
Xsg13cmos5l_inv_2_1 sg13cmos5l_inv_2_1/Y trim[14] dvdd dvss sg13cmos5l_inv_2
XXQ2_3 vss vss xtr/bot pnpMPA_9DZCCL
Xxres vbg xres/a xres/e XQ1/E vss xres/e xres/f vss vss vss vss bg_res
Xsg13cmos5l_inv_2_2 x1[2]/in_n trim[13] dvdd dvss sg13cmos5l_inv_2
XXQ2_4 vss vss xtr/bot pnpMPA_9DZCCL
XXQ2_5 vss vss xtr/bot pnpMPA_9DZCCL
Xsg13cmos5l_inv_2_3 sg13cmos5l_inv_2_3/Y trim[12] dvdd dvss sg13cmos5l_inv_2
Xsg13cmos5l_inv_2_4 x1[3]/in_n trim[11] dvdd dvss sg13cmos5l_inv_2
XXQ2_6 vss vss xtr/bot pnpMPA_9DZCCL
XXQ2_7 vss vss xtr/bot pnpMPA_9DZCCL
Xsg13cmos5l_inv_2_5 sg13cmos5l_inv_2_5/Y trim[10] dvdd dvss sg13cmos5l_inv_2
Xsg13cmos5l_inv_2_6 x1[4]/in_n trim[9] dvdd dvss sg13cmos5l_inv_2
XXQ1 vss vss XQ1/E pnpMPA_9DZCCL
Xsg13cmos5l_inv_2_7 sg13cmos5l_inv_2_7/Y trim[8] dvdd dvss sg13cmos5l_inv_2
Xsg13cmos5l_inv_2_8 x1[5]/in_n trim[7] dvdd dvss sg13cmos5l_inv_2
Xsg13cmos5l_inv_2_9 sg13cmos5l_inv_2_9/Y trim[6] dvdd dvss sg13cmos5l_inv_2
XXM1 vdd xres/a XM4/S vbg vdd XM4/S vdd sg13_hv_pmos_NWA9LU
XXM2 vdd xres/a XM4/S vbg vdd XM4/S vdd sg13_hv_pmos_NWA9LU
Xsg13cmos5l_antennanp_0 trim[15] dvdd dvss sg13cmos5l_antennanp
Xsg13cmos5l_antennanp_1 trim[14] dvdd dvss sg13cmos5l_antennanp
XXM3 vss vs1 vbg vss sg13_hv_nmos_BEVMZW
XXM4 vss XM4/S vs1 vss sg13_hv_nmos_BEVMZW
Xsg13cmos5l_antennanp_2 trim[13] dvdd dvss sg13cmos5l_antennanp
Xsg13cmos5l_antennanp_3 trim[12] dvdd dvss sg13cmos5l_antennanp
XXM5 vdd vs1 vs2 vdd sg13_hv_pmos_WYN5QB
XXM6 vdd vs2 vs2 vdd sg13_hv_pmos_WYN5QB
Xsg13cmos5l_antennanp_4 trim[11] dvdd dvss sg13cmos5l_antennanp
Xsg13cmos5l_antennanp_5 trim[10] dvdd dvss sg13cmos5l_antennanp
XC1 vss XM4/S capacitor_UEBLR3
XXM7 vs2 vss vdd vs2 sg13_hv_pmos_WYN5QB
Xsg13cmos5l_antennanp_6 trim[9] dvdd dvss sg13cmos5l_antennanp
Xsg13cmos5l_antennanp_7 trim[8] dvdd dvss sg13cmos5l_antennanp
Xcapacitor_77YAAU_0 vss vs2 capacitor_77YAAU
Xsg13cmos5l_antennanp_8 trim[7] dvdd dvss sg13cmos5l_antennanp
Xsg13cmos5l_antennanp_9 trim[6] dvdd dvss sg13cmos5l_antennanp
Xlevel_shift_0[0] sg13cmos5l_inv_2_1/Y trim[14] xtr/ctrl[14] vss vdd level_shift
Xlevel_shift_0[1] sg13cmos5l_inv_2_3/Y trim[12] xtr/ctrl[12] vss vdd level_shift
Xlevel_shift_0[2] sg13cmos5l_inv_2_5/Y trim[10] xtr/ctrl[10] vss vdd level_shift
Xlevel_shift_0[3] sg13cmos5l_inv_2_7/Y trim[8] xtr/ctrl[8] vss vdd level_shift
Xlevel_shift_0[4] sg13cmos5l_inv_2_9/Y trim[6] xtr/ctrl[6] vss vdd level_shift
Xlevel_shift_0[5] sg13cmos5l_inv_2_11/Y trim[4] xtr/ctrl[4] vss vdd level_shift
Xlevel_shift_0[6] sg13cmos5l_inv_2_13/Y trim[2] xtr/ctrl[2] vss vdd level_shift
Xlevel_shift_0[7] sg13cmos5l_inv_2_15/Y trim[0] xtr/ctrl[0] vss vdd level_shift
Xcapacitor_C4E5CZ_0 vss vs2 capacitor_C4E5CZ
Xxtr xres/f xtr/bot x1[1]/out xtr/ctrl[14] x1[2]/out xtr/ctrl[12] x1[3]/out xtr/ctrl[10]
+ x1[4]/out xtr/ctrl[8] x1[5]/out xtr/ctrl[6] x1[6]/out xtr/ctrl[4] x1[7]/out xtr/ctrl[2]
+ x1[8]/out xtr/ctrl[0] vss bg_trim
Xsg13cmos5l_decap_4_0 dvdd dvss sg13cmos5l_decap_4
Xsg13cmos5l_decap_4_3 dvdd dvss sg13cmos5l_decap_4
Xsg13cmos5l_inv_2_10 x1[6]/in_n trim[5] dvdd dvss sg13cmos5l_inv_2
Xsg13cmos5l_decap_4_5 dvdd dvss sg13cmos5l_decap_4
Xsg13cmos5l_antennanp_10 trim[5] dvdd dvss sg13cmos5l_antennanp
Xsg13cmos5l_inv_2_11 sg13cmos5l_inv_2_11/Y trim[4] dvdd dvss sg13cmos5l_inv_2
Xsg13cmos5l_antennanp_11 trim[4] dvdd dvss sg13cmos5l_antennanp
Xsg13cmos5l_decap_4_7 dvdd dvss sg13cmos5l_decap_4
Xsg13cmos5l_inv_2_12 x1[7]/in_n trim[3] dvdd dvss sg13cmos5l_inv_2
Xsg13cmos5l_antennanp_12 trim[3] dvdd dvss sg13cmos5l_antennanp
Xsg13cmos5l_decap_4_8 dvdd dvss sg13cmos5l_decap_4
Xsg13cmos5l_inv_2_13 sg13cmos5l_inv_2_13/Y trim[2] dvdd dvss sg13cmos5l_inv_2
Xsg13cmos5l_antennanp_13 trim[2] dvdd dvss sg13cmos5l_antennanp
Xcapacitor_P4YBHP_0 vss vs2 capacitor_P4YBHP
Xsg13cmos5l_inv_2_14 x1[8]/in_n trim[1] dvdd dvss sg13cmos5l_inv_2
Xsg13cmos5l_antennanp_14 trim[1] dvdd dvss sg13cmos5l_antennanp
Xsg13cmos5l_inv_2_15 sg13cmos5l_inv_2_15/Y trim[0] dvdd dvss sg13cmos5l_inv_2
Xsg13cmos5l_antennanp_15 trim[0] dvdd dvss sg13cmos5l_antennanp
XXQ2_0 vss vss xtr/bot pnpMPA_9DZCCL
Xsg13cmos5l_inv_2_16 x1[0]/in_p ena dvdd dvss sg13cmos5l_inv_2
Xcapacitor_4HNWC9_0 vss vdd capacitor_4HNWC9
.ends

.subckt sg13_hv_pmos_QWE845 D0_0 S0_0 G0_0 D0_1 S0_1 G0_1 D1_0 S1_0 G1_0 D1_1 S1_1
+ G1_1 w_n1081_n1018#
X0 S0_0 G0_0 D0_0 w_n1081_n1018# sg13_hv_pmos ad=1.36p pd=8.68u as=1.36p ps=8.68u w=4u l=4u
X1 D1_0 G1_0 S1_0 w_n1081_n1018# sg13_hv_pmos ad=1.36p pd=8.68u as=1.36p ps=8.68u w=4u l=4u
X2 D1_1 G1_1 S1_1 w_n1081_n1018# sg13_hv_pmos ad=1.36p pd=8.68u as=1.36p ps=8.68u w=4u l=4u
X3 S0_1 G0_1 D0_1 w_n1081_n1018# sg13_hv_pmos ad=1.36p pd=8.68u as=1.36p ps=8.68u w=4u l=4u
.ends

.subckt sg13_hv_nmos_BEHQUZ D0 S0 G0 D1 S1 G1 D2 S2 G2 D3 S3 G3 D4 S4 G4 D5 S5 G5
+ D6 S6 G6 D7 S7 G7 sub
X0 S4 G4 D4 sub sg13_hv_nmos ad=0.34p pd=2.68u as=0.34p ps=2.68u w=1u l=1u
X1 S6 G6 D6 sub sg13_hv_nmos ad=0.34p pd=2.68u as=0.34p ps=2.68u w=1u l=1u
X2 D5 G5 S5 sub sg13_hv_nmos ad=0.34p pd=2.68u as=0.34p ps=2.68u w=1u l=1u
X3 D7 G7 S7 sub sg13_hv_nmos ad=0.34p pd=2.68u as=0.34p ps=2.68u w=1u l=1u
X4 S0 G0 D0 sub sg13_hv_nmos ad=0.34p pd=2.68u as=0.34p ps=2.68u w=1u l=1u
X5 D1 G1 S1 sub sg13_hv_nmos ad=0.34p pd=2.68u as=0.34p ps=2.68u w=1u l=1u
X6 S2 G2 D2 sub sg13_hv_nmos ad=0.34p pd=2.68u as=0.34p ps=2.68u w=1u l=1u
X7 D3 G3 S3 sub sg13_hv_nmos ad=0.34p pd=2.68u as=0.34p ps=2.68u w=1u l=1u
.ends

.subckt sg13_hv_nmos_BEZCVZ D0 S0 G0 D1 S1 G1 D2 S2 G2 D3 S3 G3 sub
X0 S2 G2 D2 sub sg13_hv_nmos ad=0.34p pd=2.68u as=0.34p ps=2.68u w=1u l=1u
X1 D3 G3 S3 sub sg13_hv_nmos ad=0.34p pd=2.68u as=0.34p ps=2.68u w=1u l=1u
X2 S0 G0 D0 sub sg13_hv_nmos ad=0.34p pd=2.68u as=0.34p ps=2.68u w=1u l=1u
X3 D1 G1 S1 sub sg13_hv_nmos ad=0.34p pd=2.68u as=0.34p ps=2.68u w=1u l=1u
.ends

.subckt sg13_hv_pmos_ZK4LW2 D0 S0 G0 D1 S1 G1 D2 S2 G2 D3 S3 G3 D4 S4 G4 D5 S5 G5
+ D6 S6 G6 D7 S7 G7 D8 S8 G8 D9 S9 G9 D10 S10 G10 D11 S11 G11 w_n2371_n224#
X0 D5 G5 S5 w_n2371_n224# sg13_hv_pmos ad=0.34p pd=2.68u as=0.34p ps=2.68u w=1u l=1u
X1 S6 G6 D6 w_n2371_n224# sg13_hv_pmos ad=0.34p pd=2.68u as=0.34p ps=2.68u w=1u l=1u
X2 S0 G0 D0 w_n2371_n224# sg13_hv_pmos ad=0.34p pd=2.68u as=0.34p ps=2.68u w=1u l=1u
X3 D11 G11 S11 w_n2371_n224# sg13_hv_pmos ad=0.34p pd=2.68u as=0.34p ps=2.68u w=1u l=1u
X4 S8 G8 D8 w_n2371_n224# sg13_hv_pmos ad=0.34p pd=2.68u as=0.34p ps=2.68u w=1u l=1u
X5 S10 G10 D10 w_n2371_n224# sg13_hv_pmos ad=0.34p pd=2.68u as=0.34p ps=2.68u w=1u l=1u
X6 D7 G7 S7 w_n2371_n224# sg13_hv_pmos ad=0.34p pd=2.68u as=0.34p ps=2.68u w=1u l=1u
X7 D9 G9 S9 w_n2371_n224# sg13_hv_pmos ad=0.34p pd=2.68u as=0.34p ps=2.68u w=1u l=1u
X8 D1 G1 S1 w_n2371_n224# sg13_hv_pmos ad=0.34p pd=2.68u as=0.34p ps=2.68u w=1u l=1u
X9 S2 G2 D2 w_n2371_n224# sg13_hv_pmos ad=0.34p pd=2.68u as=0.34p ps=2.68u w=1u l=1u
X10 D3 G3 S3 w_n2371_n224# sg13_hv_pmos ad=0.34p pd=2.68u as=0.34p ps=2.68u w=1u l=1u
X11 S4 G4 D4 w_n2371_n224# sg13_hv_pmos ad=0.34p pd=2.68u as=0.34p ps=2.68u w=1u l=1u
.ends

.subckt sg13_hv_pmos_DFT6DG D0_0 S0_0 G0_0 D0_1 S0_1 G0_1 D0_2 S0_2 G0_2 D0_3 S0_3
+ G0_3 D1_0 S1_0 G1_0 D1_1 S1_1 G1_1 D1_2 S1_2 G1_2 D1_3 S1_3 G1_3 D2_0 S2_0 G2_0
+ D2_1 S2_1 G2_1 D2_2 S2_2 G2_2 D2_3 S2_3 G2_3 D3_0 S3_0 G3_0 D3_1 S3_1 G3_1 D3_2
+ S3_2 G3_2 D3_3 S3_3 G3_3 w_n2059_n806#
X0 S0_3 G0_3 D0_3 w_n2059_n806# sg13_hv_pmos ad=0.34p pd=2.68u as=0.34p ps=2.68u w=1u l=4u
X1 S0_0 G0_0 D0_0 w_n2059_n806# sg13_hv_pmos ad=0.34p pd=2.68u as=0.34p ps=2.68u w=1u l=4u
X2 D1_0 G1_0 S1_0 w_n2059_n806# sg13_hv_pmos ad=0.34p pd=2.68u as=0.34p ps=2.68u w=1u l=4u
X3 D3_2 G3_2 S3_2 w_n2059_n806# sg13_hv_pmos ad=0.34p pd=2.68u as=0.34p ps=2.68u w=1u l=4u
X4 S2_1 G2_1 D2_1 w_n2059_n806# sg13_hv_pmos ad=0.34p pd=2.68u as=0.34p ps=2.68u w=1u l=4u
X5 D3_1 G3_1 S3_1 w_n2059_n806# sg13_hv_pmos ad=0.34p pd=2.68u as=0.34p ps=2.68u w=1u l=4u
X6 S0_2 G0_2 D0_2 w_n2059_n806# sg13_hv_pmos ad=0.34p pd=2.68u as=0.34p ps=2.68u w=1u l=4u
X7 S2_2 G2_2 D2_2 w_n2059_n806# sg13_hv_pmos ad=0.34p pd=2.68u as=0.34p ps=2.68u w=1u l=4u
X8 S0_1 G0_1 D0_1 w_n2059_n806# sg13_hv_pmos ad=0.34p pd=2.68u as=0.34p ps=2.68u w=1u l=4u
X9 D3_3 G3_3 S3_3 w_n2059_n806# sg13_hv_pmos ad=0.34p pd=2.68u as=0.34p ps=2.68u w=1u l=4u
X10 D3_0 G3_0 S3_0 w_n2059_n806# sg13_hv_pmos ad=0.34p pd=2.68u as=0.34p ps=2.68u w=1u l=4u
X11 S2_0 G2_0 D2_0 w_n2059_n806# sg13_hv_pmos ad=0.34p pd=2.68u as=0.34p ps=2.68u w=1u l=4u
X12 S2_3 G2_3 D2_3 w_n2059_n806# sg13_hv_pmos ad=0.34p pd=2.68u as=0.34p ps=2.68u w=1u l=4u
X13 D1_2 G1_2 S1_2 w_n2059_n806# sg13_hv_pmos ad=0.34p pd=2.68u as=0.34p ps=2.68u w=1u l=4u
X14 D1_1 G1_1 S1_1 w_n2059_n806# sg13_hv_pmos ad=0.34p pd=2.68u as=0.34p ps=2.68u w=1u l=4u
X15 D1_3 G1_3 S1_3 w_n2059_n806# sg13_hv_pmos ad=0.34p pd=2.68u as=0.34p ps=2.68u w=1u l=4u
.ends

.subckt sg13_hv_nmos_T2KQE3 D0 S0 G0 D1 S1 G1 D2 S2 G2 D3 S3 G3 sub
X0 S0 G0 D0 sub sg13_hv_nmos ad=0.68p pd=4.68u as=0.68p ps=4.68u w=2u l=4u
X1 S2 G2 D2 sub sg13_hv_nmos ad=0.68p pd=4.68u as=0.68p ps=4.68u w=2u l=4u
X2 S3 G3 D3 sub sg13_hv_nmos ad=0.68p pd=4.68u as=0.68p ps=4.68u w=2u l=4u
X3 S1 G1 D1 sub sg13_hv_nmos ad=0.68p pd=4.68u as=0.68p ps=4.68u w=2u l=4u
.ends

.subckt sg13_hv_nmos_TAZSE3 D0_0 S0_0 G0_0 D0_1 S0_1 G0_1 D0_2 S0_2 G0_2 D0_3 S0_3
+ G0_3 D1_0 S1_0 G1_0 D1_1 S1_1 G1_1 D1_2 S1_2 G1_2 D1_3 S1_3 G1_3 D2_0 S2_0 G2_0
+ D2_1 S2_1 G2_1 D2_2 S2_2 G2_2 D2_3 S2_3 G2_3 D3_0 S3_0 G3_0 D3_1 S3_1 G3_1 D3_2
+ S3_2 G3_2 D3_3 S3_3 G3_3 sub
X0 S0_1 G0_1 D0_1 sub sg13_hv_nmos ad=0.68p pd=4.68u as=0.68p ps=4.68u w=2u l=4u
X1 S2_0 G2_0 D2_0 sub sg13_hv_nmos ad=0.68p pd=4.68u as=0.68p ps=4.68u w=2u l=4u
X2 D3_3 G3_3 S3_3 sub sg13_hv_nmos ad=0.68p pd=4.68u as=0.68p ps=4.68u w=2u l=4u
X3 S2_3 G2_3 D2_3 sub sg13_hv_nmos ad=0.68p pd=4.68u as=0.68p ps=4.68u w=2u l=4u
X4 D1_0 G1_0 S1_0 sub sg13_hv_nmos ad=0.68p pd=4.68u as=0.68p ps=4.68u w=2u l=4u
X5 D1_1 G1_1 S1_1 sub sg13_hv_nmos ad=0.68p pd=4.68u as=0.68p ps=4.68u w=2u l=4u
X6 D1_3 G1_3 S1_3 sub sg13_hv_nmos ad=0.68p pd=4.68u as=0.68p ps=4.68u w=2u l=4u
X7 D3_2 G3_2 S3_2 sub sg13_hv_nmos ad=0.68p pd=4.68u as=0.68p ps=4.68u w=2u l=4u
X8 S0_3 G0_3 D0_3 sub sg13_hv_nmos ad=0.68p pd=4.68u as=0.68p ps=4.68u w=2u l=4u
X9 S0_2 G0_2 D0_2 sub sg13_hv_nmos ad=0.68p pd=4.68u as=0.68p ps=4.68u w=2u l=4u
X10 S0_0 G0_0 D0_0 sub sg13_hv_nmos ad=0.68p pd=4.68u as=0.68p ps=4.68u w=2u l=4u
X11 S2_2 G2_2 D2_2 sub sg13_hv_nmos ad=0.68p pd=4.68u as=0.68p ps=4.68u w=2u l=4u
X12 D3_0 G3_0 S3_0 sub sg13_hv_nmos ad=0.68p pd=4.68u as=0.68p ps=4.68u w=2u l=4u
X13 S2_1 G2_1 D2_1 sub sg13_hv_nmos ad=0.68p pd=4.68u as=0.68p ps=4.68u w=2u l=4u
X14 D3_1 G3_1 S3_1 sub sg13_hv_nmos ad=0.68p pd=4.68u as=0.68p ps=4.68u w=2u l=4u
X15 D1_2 G1_2 S1_2 sub sg13_hv_nmos ad=0.68p pd=4.68u as=0.68p ps=4.68u w=2u l=4u
.ends

.subckt sg13_hv_pmos_NQD9LU D0_0 S0_0 G0_0 D0_1 S0_1 G0_1 D1_0 S1_0 G1_0 D1_1 S1_1
+ G1_1 D2_0 S2_0 G2_0 D2_1 S2_1 G2_1 D3_0 S3_0 G3_0 D3_1 S3_1 G3_1 D4_0 S4_0 G4_0
+ D4_1 S4_1 G4_1 D5_0 S5_0 G5_0 D5_1 S5_1 G5_1 D6_0 S6_0 G6_0 D6_1 S6_1 G6_1 D7_0
+ S7_0 G7_0 D7_1 S7_1 G7_1 w_n1615_n418#
X0 S6_0 G6_0 D6_0 w_n1615_n418# sg13_hv_pmos ad=0.34p pd=2.68u as=0.34p ps=2.68u w=1u l=1u
X1 D5_1 G5_1 S5_1 w_n1615_n418# sg13_hv_pmos ad=0.34p pd=2.68u as=0.34p ps=2.68u w=1u l=1u
X2 S2_1 G2_1 D2_1 w_n1615_n418# sg13_hv_pmos ad=0.34p pd=2.68u as=0.34p ps=2.68u w=1u l=1u
X3 D7_0 G7_0 S7_0 w_n1615_n418# sg13_hv_pmos ad=0.34p pd=2.68u as=0.34p ps=2.68u w=1u l=1u
X4 D1_1 G1_1 S1_1 w_n1615_n418# sg13_hv_pmos ad=0.34p pd=2.68u as=0.34p ps=2.68u w=1u l=1u
X5 D7_1 G7_1 S7_1 w_n1615_n418# sg13_hv_pmos ad=0.34p pd=2.68u as=0.34p ps=2.68u w=1u l=1u
X6 D3_1 G3_1 S3_1 w_n1615_n418# sg13_hv_pmos ad=0.34p pd=2.68u as=0.34p ps=2.68u w=1u l=1u
X7 D3_0 G3_0 S3_0 w_n1615_n418# sg13_hv_pmos ad=0.34p pd=2.68u as=0.34p ps=2.68u w=1u l=1u
X8 S4_0 G4_0 D4_0 w_n1615_n418# sg13_hv_pmos ad=0.34p pd=2.68u as=0.34p ps=2.68u w=1u l=1u
X9 S2_0 G2_0 D2_0 w_n1615_n418# sg13_hv_pmos ad=0.34p pd=2.68u as=0.34p ps=2.68u w=1u l=1u
X10 S4_1 G4_1 D4_1 w_n1615_n418# sg13_hv_pmos ad=0.34p pd=2.68u as=0.34p ps=2.68u w=1u l=1u
X11 S6_1 G6_1 D6_1 w_n1615_n418# sg13_hv_pmos ad=0.34p pd=2.68u as=0.34p ps=2.68u w=1u l=1u
X12 D1_0 G1_0 S1_0 w_n1615_n418# sg13_hv_pmos ad=0.34p pd=2.68u as=0.34p ps=2.68u w=1u l=1u
X13 D5_0 G5_0 S5_0 w_n1615_n418# sg13_hv_pmos ad=0.34p pd=2.68u as=0.34p ps=2.68u w=1u l=1u
X14 S0_1 G0_1 D0_1 w_n1615_n418# sg13_hv_pmos ad=0.34p pd=2.68u as=0.34p ps=2.68u w=1u l=1u
X15 S0_0 G0_0 D0_0 w_n1615_n418# sg13_hv_pmos ad=0.34p pd=2.68u as=0.34p ps=2.68u w=1u l=1u
.ends

.subckt sg13_hv_pmos_V3Q6DG D0 S0 G0 D1 S1 G1 D2 S2 G2 D3 S3 G3 w_n592_n806#
X0 S0 G0 D0 w_n592_n806# sg13_hv_pmos ad=0.34p pd=2.68u as=0.34p ps=2.68u w=1u l=4u
X1 S2 G2 D2 w_n592_n806# sg13_hv_pmos ad=0.34p pd=2.68u as=0.34p ps=2.68u w=1u l=4u
X2 S3 G3 D3 w_n592_n806# sg13_hv_pmos ad=0.34p pd=2.68u as=0.34p ps=2.68u w=1u l=4u
X3 S1 G1 D1 w_n592_n806# sg13_hv_pmos ad=0.34p pd=2.68u as=0.34p ps=2.68u w=1u l=4u
.ends

.subckt sg13_hv_pmos_NED9LU D0_0 S0_0 G0_0 D0_1 S0_1 G0_1 D1_0 S1_0 G1_0 D1_1 S1_1
+ G1_1 D2_0 S2_0 G2_0 D2_1 S2_1 G2_1 D3_0 S3_0 G3_0 D3_1 S3_1 G3_1 w_n859_n1018#
X0 D3_0 G3_0 S3_0 w_n859_n1018# sg13_hv_pmos ad=1.36p pd=8.68u as=1.36p ps=8.68u w=4u l=1u
X1 D3_1 G3_1 S3_1 w_n859_n1018# sg13_hv_pmos ad=1.36p pd=8.68u as=1.36p ps=8.68u w=4u l=1u
X2 S0_1 G0_1 D0_1 w_n859_n1018# sg13_hv_pmos ad=1.36p pd=8.68u as=1.36p ps=8.68u w=4u l=1u
X3 D1_1 G1_1 S1_1 w_n859_n1018# sg13_hv_pmos ad=1.36p pd=8.68u as=1.36p ps=8.68u w=4u l=1u
X4 D1_0 G1_0 S1_0 w_n859_n1018# sg13_hv_pmos ad=1.36p pd=8.68u as=1.36p ps=8.68u w=4u l=1u
X5 S2_0 G2_0 D2_0 w_n859_n1018# sg13_hv_pmos ad=1.36p pd=8.68u as=1.36p ps=8.68u w=4u l=1u
X6 S2_1 G2_1 D2_1 w_n859_n1018# sg13_hv_pmos ad=1.36p pd=8.68u as=1.36p ps=8.68u w=4u l=1u
X7 S0_0 G0_0 D0_0 w_n859_n1018# sg13_hv_pmos ad=1.36p pd=8.68u as=1.36p ps=8.68u w=4u l=1u
.ends

.subckt sg13_hv_nmos_BENXUZ D0_0 S0_0 G0_0 D0_1 S0_1 G0_1 D1_0 S1_0 G1_0 D1_1 S1_1
+ G1_1 D2_0 S2_0 G2_0 D2_1 S2_1 G2_1 D3_0 S3_0 G3_0 D3_1 S3_1 G3_1 sub
X0 D3_1 G3_1 S3_1 sub sg13_hv_nmos ad=0.68p pd=4.68u as=0.68p ps=4.68u w=2u l=1u
X1 S0_1 G0_1 D0_1 sub sg13_hv_nmos ad=0.68p pd=4.68u as=0.68p ps=4.68u w=2u l=1u
X2 D3_0 G3_0 S3_0 sub sg13_hv_nmos ad=0.68p pd=4.68u as=0.68p ps=4.68u w=2u l=1u
X3 D1_1 G1_1 S1_1 sub sg13_hv_nmos ad=0.68p pd=4.68u as=0.68p ps=4.68u w=2u l=1u
X4 S2_1 G2_1 D2_1 sub sg13_hv_nmos ad=0.68p pd=4.68u as=0.68p ps=4.68u w=2u l=1u
X5 S2_0 G2_0 D2_0 sub sg13_hv_nmos ad=0.68p pd=4.68u as=0.68p ps=4.68u w=2u l=1u
X6 D1_0 G1_0 S1_0 sub sg13_hv_nmos ad=0.68p pd=4.68u as=0.68p ps=4.68u w=2u l=1u
X7 S0_0 G0_0 D0_0 sub sg13_hv_nmos ad=0.68p pd=4.68u as=0.68p ps=4.68u w=2u l=1u
.ends

.subckt capacitor_W9X9FK sub c1 c2
X0 c1 c2 cap_cmomf mm_ok=1 subblock=1 mmax=4 mmin=1 l=15.5u w=35.317u
.ends

.subckt sg13_hv_nmos_XAS6UC D0_0 S0_0 G0_0 D0_1 S0_1 G0_1 D1_0 S1_0 G1_0 D1_1 S1_1
+ G1_1 D2_0 S2_0 G2_0 D2_1 S2_1 G2_1 D3_0 S3_0 G3_0 D3_1 S3_1 G3_1 D4_0 S4_0 G4_0
+ D4_1 S4_1 G4_1 D5_0 S5_0 G5_0 D5_1 S5_1 G5_1 D6_0 S6_0 G6_0 D6_1 S6_1 G6_1 D7_0
+ S7_0 G7_0 D7_1 S7_1 G7_1 D8_0 S8_0 G8_0 D8_1 S8_1 G8_1 D9_0 S9_0 G9_0 D9_1 S9_1
+ G9_1 D10_0 S10_0 G10_0 D10_1 S10_1 G10_1 D11_0 S11_0 G11_0 D11_1 S11_1 G11_1 sub
X0 S0_1 G0_1 D0_1 sub sg13_hv_nmos ad=0.34p pd=2.68u as=0.34p ps=2.68u w=1u l=1u
X1 D7_1 G7_1 S7_1 sub sg13_hv_nmos ad=0.34p pd=2.68u as=0.34p ps=2.68u w=1u l=1u
X2 S4_1 G4_1 D4_1 sub sg13_hv_nmos ad=0.34p pd=2.68u as=0.34p ps=2.68u w=1u l=1u
X3 D9_0 G9_0 S9_0 sub sg13_hv_nmos ad=0.34p pd=2.68u as=0.34p ps=2.68u w=1u l=1u
X4 D3_1 G3_1 S3_1 sub sg13_hv_nmos ad=0.34p pd=2.68u as=0.34p ps=2.68u w=1u l=1u
X5 D11_1 G11_1 S11_1 sub sg13_hv_nmos ad=0.34p pd=2.68u as=0.34p ps=2.68u w=1u l=1u
X6 S10_0 G10_0 D10_0 sub sg13_hv_nmos ad=0.34p pd=2.68u as=0.34p ps=2.68u w=1u l=1u
X7 D9_1 G9_1 S9_1 sub sg13_hv_nmos ad=0.34p pd=2.68u as=0.34p ps=2.68u w=1u l=1u
X8 S6_0 G6_0 D6_0 sub sg13_hv_nmos ad=0.34p pd=2.68u as=0.34p ps=2.68u w=1u l=1u
X9 D11_0 G11_0 S11_0 sub sg13_hv_nmos ad=0.34p pd=2.68u as=0.34p ps=2.68u w=1u l=1u
X10 D5_1 G5_1 S5_1 sub sg13_hv_nmos ad=0.34p pd=2.68u as=0.34p ps=2.68u w=1u l=1u
X11 D5_0 G5_0 S5_0 sub sg13_hv_nmos ad=0.34p pd=2.68u as=0.34p ps=2.68u w=1u l=1u
X12 S0_0 G0_0 D0_0 sub sg13_hv_nmos ad=0.34p pd=2.68u as=0.34p ps=2.68u w=1u l=1u
X13 S4_0 G4_0 D4_0 sub sg13_hv_nmos ad=0.34p pd=2.68u as=0.34p ps=2.68u w=1u l=1u
X14 D1_1 G1_1 S1_1 sub sg13_hv_nmos ad=0.34p pd=2.68u as=0.34p ps=2.68u w=1u l=1u
X15 S6_1 G6_1 D6_1 sub sg13_hv_nmos ad=0.34p pd=2.68u as=0.34p ps=2.68u w=1u l=1u
X16 S8_1 G8_1 D8_1 sub sg13_hv_nmos ad=0.34p pd=2.68u as=0.34p ps=2.68u w=1u l=1u
X17 D3_0 G3_0 S3_0 sub sg13_hv_nmos ad=0.34p pd=2.68u as=0.34p ps=2.68u w=1u l=1u
X18 D7_0 G7_0 S7_0 sub sg13_hv_nmos ad=0.34p pd=2.68u as=0.34p ps=2.68u w=1u l=1u
X19 S2_0 G2_0 D2_0 sub sg13_hv_nmos ad=0.34p pd=2.68u as=0.34p ps=2.68u w=1u l=1u
X20 S2_1 G2_1 D2_1 sub sg13_hv_nmos ad=0.34p pd=2.68u as=0.34p ps=2.68u w=1u l=1u
X21 S10_1 G10_1 D10_1 sub sg13_hv_nmos ad=0.34p pd=2.68u as=0.34p ps=2.68u w=1u l=1u
X22 D1_0 G1_0 S1_0 sub sg13_hv_nmos ad=0.34p pd=2.68u as=0.34p ps=2.68u w=1u l=1u
X23 S8_0 G8_0 D8_0 sub sg13_hv_nmos ad=0.34p pd=2.68u as=0.34p ps=2.68u w=1u l=1u
.ends

.subckt sg13_hv_nmos_2G82VR D0_0 S0_0 G0_0 D0_1 S0_1 G0_1 D1_0 S1_0 G1_0 D1_1 S1_1
+ G1_1 sub
X0 S0_0 G0_0 D0_0 sub sg13_hv_nmos ad=1.36p pd=8.68u as=1.36p ps=8.68u w=4u l=4u
X1 D1_0 G1_0 S1_0 sub sg13_hv_nmos ad=1.36p pd=8.68u as=1.36p ps=8.68u w=4u l=4u
X2 D1_1 G1_1 S1_1 sub sg13_hv_nmos ad=1.36p pd=8.68u as=1.36p ps=8.68u w=4u l=4u
X3 S0_1 G0_1 D0_1 sub sg13_hv_nmos ad=1.36p pd=8.68u as=1.36p ps=8.68u w=4u l=4u
.ends

.subckt se_folded_cascode_np_ab vdd out inp inn vss bias ena_b
XXMOP out vdd XM9/S3_2 out vdd XM9/S3_2 vdd out XM9/S3_2 vdd out XM9/S3_2 vdd sg13_hv_pmos_QWE845
Xsg13_hv_nmos_BEHQUZ_0 vss vss vss vss vss vss vss vss vss vss vss vss vss vss vss
+ vss vss vss vss vss vss vss vss vss vss sg13_hv_nmos_BEHQUZ
Xsg13_hv_nmos_BEZCVZ_0 vss vss vss vss vss vss vss vss vss vss vss vss vss sg13_hv_nmos_BEZCVZ
XXM4 vdd outa1n outa1n outa1p vdd outa1n vdd outa1n outa1n outa1p vdd outa1n vdd outa1n
+ outa1n outa1p vdd outa1n vdd outa1n outa1n outa1p vdd outa1n vdd outa1n outa1n outa1p
+ vdd outa1n vdd outa1n outa1n outa1p vdd outa1n vdd sg13_hv_pmos_ZK4LW2
XXM5 vdd outa1n outa1n outa1p vdd outa1n vdd outa1n outa1n outa1p vdd outa1n vdd outa1n
+ outa1n outa1p vdd outa1n vdd outa1n outa1n outa1p vdd outa1n vdd outa1n outa1n outa1p
+ vdd outa1n vdd outa1n outa1n outa1p vdd outa1n vdd sg13_hv_pmos_ZK4LW2
XXM6 XM9/S3_2 outa1p XM9/S3_3 outa1n XM9/S3_3 XM9/S3_3 XM9/S3_2 outa1p XM9/S3_3 outa1n
+ XM9/S3_3 XM9/S3_3 XM9/S3_3 outa1n XM9/S3_3 outa1p XM9/S3_2 XM9/S3_3 XM9/S3_3 outa1n
+ XM9/S3_3 outa1p XM9/S3_2 XM9/S3_3 XM9/S3_2 outa1p XM9/S3_3 outa1n XM9/S3_3 XM9/S3_3
+ XM9/S3_2 outa1p XM9/S3_3 outa1n XM9/S3_3 XM9/S3_3 XM9/S3_3 outa1n XM9/S3_3 outa1p
+ XM9/S3_2 XM9/S3_3 XM9/S3_3 outa1n XM9/S3_3 outa1p XM9/S3_2 XM9/S3_3 vdd sg13_hv_pmos_DFT6DG
XXM7 XM9/S3_2 outa1p XM9/S3_3 outa1n XM9/S3_3 XM9/S3_3 XM9/S3_2 outa1p XM9/S3_3 outa1n
+ XM9/S3_3 XM9/S3_3 XM9/S3_3 outa1n XM9/S3_3 outa1p XM9/S3_2 XM9/S3_3 XM9/S3_3 outa1n
+ XM9/S3_3 outa1p XM9/S3_2 XM9/S3_3 XM9/S3_2 outa1p XM9/S3_3 outa1n XM9/S3_3 XM9/S3_3
+ XM9/S3_2 outa1p XM9/S3_3 outa1n XM9/S3_3 XM9/S3_3 XM9/S3_3 outa1n XM9/S3_3 outa1p
+ XM9/S3_2 XM9/S3_3 XM9/S3_3 outa1n XM9/S3_3 outa1p XM9/S3_2 XM9/S3_3 vdd sg13_hv_pmos_DFT6DG
XXMB1 vbn1 vbn2 vbn2 vbn1 vbn2 vbn2 vbn1 vbn2 vbn2 vbn1 vbn2 vbn2 vss sg13_hv_nmos_T2KQE3
XXM8 XM9/S3_3 outb1n vbn2 XM9/S3_2 outb1p vbn2 XM9/S3_3 outb1n vbn2 XM9/S3_2 outb1p
+ vbn2 outb1p XM9/S3_2 vbn2 outb1n XM9/S3_3 vbn2 outb1p XM9/S3_2 vbn2 outb1n XM9/S3_3
+ vbn2 XM9/S3_3 outb1n vbn2 XM9/S3_2 outb1p vbn2 XM9/S3_3 outb1n vbn2 XM9/S3_2 outb1p
+ vbn2 outb1p XM9/S3_2 vbn2 outb1n XM9/S3_3 vbn2 outb1p XM9/S3_2 vbn2 outb1n XM9/S3_3
+ vbn2 vss sg13_hv_nmos_TAZSE3
XXMB2 vss vbn1 vbn1 vbn1 vss vbn1 vss vbn1 vbn1 vbn1 vss vbn1 vss sg13_hv_nmos_BEZCVZ
XXMIP1 vdd diffb vbp1 vdd diffb vbp1 diffb vdd vbp1 diffb vdd vbp1 vdd diffb vbp1
+ vdd diffb vbp1 diffb vdd vbp1 diffb vdd vbp1 vdd diffb vbp1 vdd diffb vbp1 diffb
+ vdd vbp1 diffb vdd vbp1 vdd diffb vbp1 vdd diffb vbp1 diffb vdd vbp1 diffb vdd vbp1
+ vdd sg13_hv_pmos_NQD9LU
XXM9 XM9/S3_3 outb1n vbn2 XM9/S3_2 outb1p vbn2 XM9/S3_3 outb1n vbn2 XM9/S3_2 outb1p
+ vbn2 outb1p XM9/S3_2 vbn2 outb1n XM9/S3_3 vbn2 outb1p XM9/S3_2 vbn2 outb1n XM9/S3_3
+ vbn2 XM9/S3_3 outb1n vbn2 XM9/S3_2 outb1p vbn2 XM9/S3_3 outb1n vbn2 XM9/S3_2 outb1p
+ vbn2 outb1p XM9/S3_2 vbn2 outb1n XM9/S3_3 vbn2 outb1p XM9/S3_2 vbn2 outb1n XM9/S3_3
+ vbn2 vss sg13_hv_nmos_TAZSE3
XXMB3 XMB4/S3 bias ena_b XMB4/S3 bias ena_b XMB4/S3 bias ena_b XMB4/S3 bias ena_b
+ vdd sg13_hv_pmos_V3Q6DG
XXMIP2 outb1n diffb inn outb1p diffb inp diffb outb1p inp diffb outb1n inn outb1n
+ diffb inn outb1p diffb inp diffb outb1p inp diffb outb1n inn vdd sg13_hv_pmos_NED9LU
XXMB4 vbp1 XMB4/S3 XMB4/S3 vbp1 XMB4/S3 XMB4/S3 vbp1 XMB4/S3 XMB4/S3 vbp1 XMB4/S3
+ XMB4/S3 vdd sg13_hv_pmos_V3Q6DG
XXMIP3 outb1n diffb inn outb1p diffb inp diffb outb1p inp diffb outb1n inn outb1n
+ diffb inn outb1p diffb inp diffb outb1p inp diffb outb1n inn vdd sg13_hv_pmos_NED9LU
XXMIN1 vss diffa vbn1 diffa vss vbn1 vss diffa vbn1 diffa vss vbn1 vss diffa vbn1
+ diffa vss vbn1 vss diffa vbn1 diffa vss vbn1 vss sg13_hv_nmos_BEHQUZ
XXMB5 vdd vbn2 vbp1 vbp1 vdd vbp1 vdd vbn2 vbp1 vbp1 vdd vbp1 vdd sg13_hv_pmos_NQUDLU
XXMIN2 outa1n diffa inn outa1p diffa inp diffa outa1p inp diffa outa1n inn outa1n
+ diffa inn outa1p diffa inp diffa outa1p inp diffa outa1n inn vss sg13_hv_nmos_BENXUZ
XXMB6 vdd vbn2 vbp1 vbp1 vdd vbp1 vdd vbn2 vbp1 vbp1 vdd vbp1 vdd sg13_hv_pmos_NQUDLU
XXMIN3 outa1n diffa inn outa1p diffa inp diffa outa1p inp diffa outa1n inn outa1n
+ diffa inn outa1p diffa inp diffa outa1p inp diffa outa1n inn vss sg13_hv_nmos_BENXUZ
XC1[1] vss XM9/S3_2 out capacitor_W9X9FK
XC1[0] vss XM9/S3_2 out capacitor_W9X9FK
XXM10 vss outb1p vbn1 vss outb1p vbn1 outb1n vss vbn1 outb1n vss vbn1 vss outb1p vbn1
+ vss outb1p vbn1 outb1n vss vbn1 outb1n vss vbn1 vss outb1p vbn1 vss outb1p vbn1
+ outb1n vss vbn1 outb1n vss vbn1 vss outb1p vbn1 vss outb1p vbn1 outb1n vss vbn1
+ outb1n vss vbn1 vss outb1p vbn1 vss outb1p vbn1 outb1n vss vbn1 outb1n vss vbn1
+ vss outb1p vbn1 vss outb1p vbn1 outb1n vss vbn1 outb1n vss vbn1 vss sg13_hv_nmos_XAS6UC
XXMON out vss XM9/S3_2 out vss XM9/S3_2 vss out XM9/S3_2 vss out XM9/S3_2 vss sg13_hv_nmos_2G82VR
Xsg13_hv_nmos_T2KQE3_0 vss vss vbn2 vss vss vbn2 vss vss vbn2 vss vss vbn2 vss sg13_hv_nmos_T2KQE3
XXM11 vss outb1p vbn1 vss outb1p vbn1 outb1n vss vbn1 outb1n vss vbn1 vss outb1p vbn1
+ vss outb1p vbn1 outb1n vss vbn1 outb1n vss vbn1 vss outb1p vbn1 vss outb1p vbn1
+ outb1n vss vbn1 outb1n vss vbn1 vss outb1p vbn1 vss outb1p vbn1 outb1n vss vbn1
+ outb1n vss vbn1 vss outb1p vbn1 vss outb1p vbn1 outb1n vss vbn1 outb1n vss vbn1
+ vss outb1p vbn1 vss outb1p vbn1 outb1n vss vbn1 outb1n vss vbn1 vss sg13_hv_nmos_XAS6UC
.ends

.subckt sg13cmos5l_ocd_ip__bandgap_v3 vbg ibias1_250n trim[15] trim[14] trim[13] trim[12]
+ trim[11] trim[10] trim[9] trim[8] trim[7] trim[6] trim[5] trim[4] trim[3] trim[2]
+ trim[1] trim[0] ena ibias2_1u dvdd vdd vss dvss
Xx1 x2/inp ibias1_250n trim[15] trim[14] trim[13] trim[12] trim[11] trim[10] trim[9]
+ trim[8] trim[7] trim[6] trim[5] trim[4] trim[3] trim[2] trim[1] trim[0] ena x2/ena_b
+ x1/XM4/S dvdd dvss vss vdd bandgap_unbuffered_v2
Xx2 vdd vbg x2/inp vbg vss ibias2_1u x2/ena_b se_folded_cascode_np_ab
.ends

* Black-box entry subcircuit for slot12_wrapper abstract view
.subckt slot12_wrapper vss_3v3 s12_an[0] s12_an[1] s12_an_0_esd s12_an_1_esd vbias
+ dig_in[23] dig_in[22] dig_in[21] dig_in[20] dig_in[19] dig_in[18] dig_in[17] dig_in[16]
+ dig_in[15] dig_in[14] dig_in[13] dig_in[12] dig_in[11] dig_in[10] dig_in[9] dig_in[8]
+ dig_in[7] dig_in[6] dig_in[5] dig_in[4] dig_in[3] dig_in[2] dig_in[1] dig_in[0]
+ dig_out[11] dig_out[10] dig_out[9] dig_out[8] dig_out[7] dig_out[6] dig_out[5] dig_out[4]
+ dig_out[3] dig_out[2] dig_out[1] dig_out[0] ibias0 ibias1 analog_bus3 analog_bus2
+ analog_bus1 analog_bus0 vss_1v2 vdd_1v2 vdd_3v3 enable clk reset
.ends

.subckt sg13cmos5l_nor2b_1 Y A B_N VDD VSS
X0 VDD B_N a_46_156# VDD sg13_lv_pmos ad=0.2618p pd=1.63u as=0.2856p ps=2.36u w=0.84u l=0.13u
X1 VSS B_N a_46_156# VSS sg13_lv_nmos ad=0.17255p pd=1.25u as=0.187p ps=1.78u w=0.55u l=0.13u
X2 Y a_46_156# VSS VSS sg13_lv_nmos ad=0.1406p pd=1.12u as=0.17255p ps=1.25u w=0.74u l=0.13u
X3 VSS A Y VSS sg13_lv_nmos ad=0.2516p pd=2.16u as=0.1406p ps=1.12u w=0.74u l=0.13u
X4 a_268_412# a_46_156# VDD VDD sg13_lv_pmos ad=0.1176p pd=1.33u as=0.2618p ps=1.63u w=1.12u l=0.13u
X5 Y A a_268_412# VDD sg13_lv_pmos ad=0.3808p pd=2.92u as=0.1176p ps=1.33u w=1.12u l=0.13u
.ends

.subckt sg13cmos5l_a21oi_1 Y A1 A2 B1 VDD VSS
X0 Y B1 VSS VSS sg13_lv_nmos ad=0.1406p pd=1.12u as=0.2516p ps=2.16u w=0.74u l=0.13u
X1 a_257_140# A1 Y VSS sg13_lv_nmos ad=0.1406p pd=1.12u as=0.1406p ps=1.12u w=0.74u l=0.13u
X2 VSS A2 a_257_140# VSS sg13_lv_nmos ad=0.2516p pd=2.16u as=0.1406p ps=1.12u w=0.74u l=0.13u
X3 a_155_412# B1 Y VDD sg13_lv_pmos ad=0.2128p pd=1.5u as=0.3808p ps=2.92u w=1.12u l=0.13u
X4 VDD A1 a_155_412# VDD sg13_lv_pmos ad=0.2128p pd=1.5u as=0.2128p ps=1.5u w=1.12u l=0.13u
X5 a_155_412# A2 VDD VDD sg13_lv_pmos ad=0.3808p pd=2.92u as=0.2128p ps=1.5u w=1.12u l=0.13u
.ends

.subckt sg13cmos5l_xnor2_1 Y A B VDD VSS
X0 a_192_429# A VDD VDD sg13_lv_pmos ad=0.1596p pd=1.22u as=0.4536p ps=2.76u w=0.84u l=0.13u
X1 VSS A a_341_118# VSS sg13_lv_nmos ad=0.1898p pd=1.36u as=0.2516p ps=2.16u w=0.74u l=0.13u
X2 VDD B a_192_429# VDD sg13_lv_pmos ad=0.2891p pd=1.695u as=0.1596p ps=1.22u w=0.84u l=0.13u
X3 a_435_412# A VDD VDD sg13_lv_pmos ad=0.1428p pd=1.375u as=0.2891p ps=1.695u w=1.12u l=0.13u
X4 a_155_160# A VSS VSS sg13_lv_nmos ad=78.39999f pd=0.885u as=0.2272p ps=1.99u w=0.64u l=0.13u
X5 a_341_118# B VSS VSS sg13_lv_nmos ad=0.1406p pd=1.12u as=0.1898p ps=1.36u w=0.74u l=0.13u
X6 Y a_192_429# a_341_118# VSS sg13_lv_nmos ad=0.2516p pd=2.16u as=0.1406p ps=1.12u w=0.74u l=0.13u
X7 VDD a_192_429# Y VDD sg13_lv_pmos ad=0.3808p pd=2.92u as=0.2408p ps=1.55u w=1.12u l=0.13u
X8 Y B a_435_412# VDD sg13_lv_pmos ad=0.2408p pd=1.55u as=0.1428p ps=1.375u w=1.12u l=0.13u
X9 a_192_429# B a_155_160# VSS sg13_lv_nmos ad=0.2176p pd=1.96u as=78.39999f ps=0.885u w=0.64u l=0.13u
.ends

.subckt sg13cmos5l_buf_2 X A VDD VSS
X0 a_41_304# A VSS VSS sg13_lv_nmos ad=0.2176p pd=1.96u as=0.1371p ps=1.12u w=0.64u l=0.13u
X1 a_41_304# A VDD VDD sg13_lv_pmos ad=0.34p pd=2.68u as=0.2086p ps=1.5u w=1u l=0.13u
X2 X a_41_304# VSS VSS sg13_lv_nmos ad=0.1406p pd=1.12u as=0.2516p ps=2.16u w=0.74u l=0.13u
X3 X a_41_304# VDD VDD sg13_lv_pmos ad=0.2128p pd=1.5u as=0.7336p ps=3.55u w=1.12u l=0.13u
X4 VSS a_41_304# X VSS sg13_lv_nmos ad=0.1371p pd=1.12u as=0.1406p ps=1.12u w=0.74u l=0.13u
X5 VDD a_41_304# X VDD sg13_lv_pmos ad=0.2086p pd=1.5u as=0.2128p ps=1.5u w=1.12u l=0.13u
.ends

.subckt sg13cmos5l_and4_1 X A B C D VDD VSS
X0 VDD D a_81_118# VDD sg13_lv_pmos ad=0.2044p pd=1.53u as=0.1848p ps=1.28u w=0.84u l=0.13u
X1 a_175_118# A a_81_118# VSS sg13_lv_nmos ad=0.1216p pd=1.02u as=0.2176p ps=1.96u w=0.64u l=0.13u
X2 a_277_118# B a_175_118# VSS sg13_lv_nmos ad=0.1216p pd=1.02u as=0.1216p ps=1.02u w=0.64u l=0.13u
X3 a_379_118# C a_277_118# VSS sg13_lv_nmos ad=0.1408p pd=1.08u as=0.1216p ps=1.02u w=0.64u l=0.13u
X4 VSS D a_379_118# VSS sg13_lv_nmos ad=0.1447p pd=1.15u as=0.1408p ps=1.08u w=0.64u l=0.13u
X5 X a_81_118# VSS VSS sg13_lv_nmos ad=0.3552p pd=2.44u as=0.1447p ps=1.15u w=0.74u l=0.13u
X6 X a_81_118# VDD VDD sg13_lv_pmos ad=0.5376p pd=3.2u as=0.2044p ps=1.53u w=1.12u l=0.13u
X7 a_81_118# A VDD VDD sg13_lv_pmos ad=0.1596p pd=1.22u as=0.2856p ps=2.36u w=0.84u l=0.13u
X8 VDD B a_81_118# VDD sg13_lv_pmos ad=0.1596p pd=1.22u as=0.1596p ps=1.22u w=0.84u l=0.13u
X9 a_81_118# C VDD VDD sg13_lv_pmos ad=0.1848p pd=1.28u as=0.1596p ps=1.22u w=0.84u l=0.13u
.ends

.subckt sg13cmos5l_o21ai_1 Y A1 A2 B1 VDD VSS
X0 VSS A1 a_22_110# VSS sg13_lv_nmos ad=0.1406p pd=1.12u as=0.2516p ps=2.16u w=0.74u l=0.15u
X1 a_120_432# A1 VDD VDD sg13_lv_pmos ad=0.2128p pd=1.5u as=0.3808p ps=2.92u w=1.12u l=0.15u
X2 a_22_110# A2 VSS VSS sg13_lv_nmos ad=0.1406p pd=1.12u as=0.1406p ps=1.12u w=0.74u l=0.15u
X3 Y B1 a_22_110# VSS sg13_lv_nmos ad=0.2516p pd=2.16u as=0.1406p ps=1.12u w=0.74u l=0.15u
X4 Y A2 a_120_432# VDD sg13_lv_pmos ad=0.2128p pd=1.5u as=0.2128p ps=1.5u w=1.12u l=0.15u
X5 VDD B1 Y VDD sg13_lv_pmos ad=0.3808p pd=2.92u as=0.2128p ps=1.5u w=1.12u l=0.15u
.ends

.subckt sg13cmos5l_or2_1 X A B VDD VSS
X0 a_142_492# B a_48_492# VDD sg13_lv_pmos ad=0.1596p pd=1.22u as=0.2856p ps=2.36u w=0.84u l=0.13u
X1 VDD A a_142_492# VDD sg13_lv_pmos ad=0.2226p pd=1.535u as=0.1596p ps=1.22u w=0.84u l=0.13u
X2 X a_48_492# VSS VSS sg13_lv_nmos ad=0.2516p pd=2.16u as=0.1469p ps=1.155u w=0.74u l=0.13u
X3 VSS A a_48_492# VSS sg13_lv_nmos ad=0.1469p pd=1.155u as=0.1045p ps=0.93u w=0.55u l=0.13u
X4 a_48_492# B VSS VSS sg13_lv_nmos ad=0.1045p pd=0.93u as=0.187p ps=1.78u w=0.55u l=0.13u
X5 X a_48_492# VDD VDD sg13_lv_pmos ad=0.3976p pd=2.95u as=0.2226p ps=1.535u w=1.12u l=0.13u
.ends

.subckt sg13cmos5l_a22oi_1 Y A1 A2 B1 B2 VDD VSS
X0 a_398_96# A1 Y VSS sg13_lv_nmos ad=96.2f pd=1u as=0.2664p ps=1.46u w=0.74u l=0.13u
X1 Y B2 a_127_96# VSS sg13_lv_nmos ad=0.2664p pd=1.46u as=0.13875p ps=1.115u w=0.74u l=0.13u
X2 VDD A2 a_127_436# VDD sg13_lv_pmos ad=0.3808p pd=2.92u as=0.2744p ps=1.61u w=1.12u l=0.13u
X3 Y B1 a_127_436# VDD sg13_lv_pmos ad=0.2128p pd=1.5u as=0.2716p ps=1.605u w=1.12u l=0.13u
X4 a_127_436# B2 Y VDD sg13_lv_pmos ad=0.2744p pd=1.61u as=0.2128p ps=1.5u w=1.12u l=0.13u
X5 a_127_96# B1 VSS VSS sg13_lv_nmos ad=0.13875p pd=1.115u as=0.2553p ps=2.17u w=0.74u l=0.13u
X6 a_127_436# A1 VDD VDD sg13_lv_pmos ad=0.2716p pd=1.605u as=0.3808p ps=2.92u w=1.12u l=0.13u
X7 VSS A2 a_398_96# VSS sg13_lv_nmos ad=0.2516p pd=2.16u as=96.2f ps=1u w=0.74u l=0.13u
.ends

.subckt sg13cmos5l_a21o_1 X A1 A2 B1 VDD VSS
X0 VDD A1 a_358_436# VDD sg13_lv_pmos ad=0.19p pd=1.38u as=0.2125p ps=1.425u w=1u l=0.13u
X1 VSS A2 a_494_160# VSS sg13_lv_nmos ad=0.2176p pd=1.96u as=81.6f ps=0.895u w=0.64u l=0.13u
X2 a_358_436# A2 VDD VDD sg13_lv_pmos ad=0.34p pd=2.68u as=0.19p ps=1.38u w=1u l=0.13u
X3 a_115_308# B1 VSS VSS sg13_lv_nmos ad=0.1216p pd=1.02u as=0.15745p ps=1.175u w=0.64u l=0.13u
X4 a_494_160# A1 a_115_308# VSS sg13_lv_nmos ad=81.6f pd=0.895u as=0.1216p ps=1.02u w=0.64u l=0.13u
X5 a_358_436# B1 a_115_308# VDD sg13_lv_pmos ad=0.2125p pd=1.425u as=0.35p ps=2.7u w=1u l=0.13u
X6 VDD a_115_308# X VDD sg13_lv_pmos ad=0.3808p pd=2.92u as=0.3808p ps=2.92u w=1.12u l=0.13u
X7 VSS a_115_308# X VSS sg13_lv_nmos ad=0.15745p pd=1.175u as=0.2351p ps=2.16u w=0.74u l=0.13u
.ends

.subckt sg13cmos5l_a221oi_1 Y A1 A2 B1 B2 C1 VDD VSS
X0 a_550_140# A1 Y VSS sg13_lv_nmos ad=0.1406p pd=1.12u as=0.2516p ps=2.16u w=0.74u l=0.13u
X1 VSS A2 a_550_140# VSS sg13_lv_nmos ad=0.2516p pd=2.16u as=0.1406p ps=1.12u w=0.74u l=0.13u
X2 a_142_412# C1 Y VDD sg13_lv_pmos ad=0.2128p pd=1.5u as=0.3808p ps=2.92u w=1.12u l=0.13u
X3 a_244_412# B2 a_142_412# VDD sg13_lv_pmos ad=0.2128p pd=1.5u as=0.2128p ps=1.5u w=1.12u l=0.13u
X4 a_142_412# B1 a_244_412# VDD sg13_lv_pmos ad=0.3808p pd=2.92u as=0.2128p ps=1.5u w=1.12u l=0.13u
X5 a_244_412# A1 VDD VDD sg13_lv_pmos ad=0.2128p pd=1.5u as=0.3808p ps=2.92u w=1.12u l=0.13u
X6 VDD A2 a_244_412# VDD sg13_lv_pmos ad=0.3808p pd=2.92u as=0.2128p ps=1.5u w=1.12u l=0.13u
X7 VSS C1 Y VSS sg13_lv_nmos ad=0.1406p pd=1.12u as=0.2516p ps=2.16u w=0.74u l=0.13u
X8 a_244_140# B2 VSS VSS sg13_lv_nmos ad=0.1406p pd=1.12u as=0.1406p ps=1.12u w=0.74u l=0.13u
X9 Y B1 a_244_140# VSS sg13_lv_nmos ad=0.2516p pd=2.16u as=0.1406p ps=1.12u w=0.74u l=0.13u
.ends

.subckt sg13cmos5l_nor4_1 Y A B C D VDD VSS
X0 a_354_412# C a_252_412# VDD sg13_lv_pmos ad=0.2128p pd=1.5u as=0.2128p ps=1.5u w=1.12u l=0.13u
X1 Y D a_354_412# VDD sg13_lv_pmos ad=0.4368p pd=3.02u as=0.2128p ps=1.5u w=1.12u l=0.13u
X2 Y A VSS VSS sg13_lv_nmos ad=0.1406p pd=1.12u as=0.2516p ps=2.16u w=0.74u l=0.13u
X3 a_150_412# A VDD VDD sg13_lv_pmos ad=0.2128p pd=1.5u as=0.3808p ps=2.92u w=1.12u l=0.13u
X4 VSS B Y VSS sg13_lv_nmos ad=0.1406p pd=1.12u as=0.1406p ps=1.12u w=0.74u l=0.13u
X5 a_252_412# B a_150_412# VDD sg13_lv_pmos ad=0.2128p pd=1.5u as=0.2128p ps=1.5u w=1.12u l=0.13u
X6 Y C VSS VSS sg13_lv_nmos ad=0.1406p pd=1.12u as=0.1406p ps=1.12u w=0.74u l=0.13u
X7 VSS D Y VSS sg13_lv_nmos ad=0.23757p pd=2.16u as=0.1406p ps=1.12u w=0.74u l=0.13u
.ends

.subckt sg13cmos5l_and3_1 X A B C VDD VSS
X0 a_170_160# A a_76_160# VSS sg13_lv_nmos ad=0.1216p pd=1.02u as=0.2176p ps=1.96u w=0.64u l=0.13u
X1 a_272_160# B a_170_160# VSS sg13_lv_nmos ad=0.1216p pd=1.02u as=0.1216p ps=1.02u w=0.64u l=0.13u
X2 VSS C a_272_160# VSS sg13_lv_nmos ad=0.1371p pd=1.12u as=0.1216p ps=1.02u w=0.64u l=0.13u
X3 VDD A a_76_160# VDD sg13_lv_pmos ad=0.1596p pd=1.22u as=0.2856p ps=2.36u w=0.84u l=0.13u
X4 a_76_160# B VDD VDD sg13_lv_pmos ad=0.1596p pd=1.22u as=0.1596p ps=1.22u w=0.84u l=0.13u
X5 VDD C a_76_160# VDD sg13_lv_pmos ad=0.36195p pd=1.84u as=0.1596p ps=1.22u w=0.84u l=0.13u
X6 X a_76_160# VDD VDD sg13_lv_pmos ad=0.3808p pd=2.92u as=0.36195p ps=1.84u w=1.12u l=0.13u
X7 X a_76_160# VSS VSS sg13_lv_nmos ad=0.2516p pd=2.16u as=0.1371p ps=1.12u w=0.74u l=0.13u
.ends

.subckt sg13cmos5l_or3_1 X A B C VDD VSS
X0 VSS A a_73_118# VSS sg13_lv_nmos ad=0.13395p pd=1.12u as=0.198p ps=1.27u w=0.55u l=0.13u
X1 X a_73_118# VSS VSS sg13_lv_nmos ad=0.2516p pd=2.16u as=0.13395p ps=1.12u w=0.74u l=0.13u
X2 VDD A a_269_412# VDD sg13_lv_pmos ad=0.3822p pd=1.84u as=0.1575p ps=1.315u w=1u l=0.13u
X3 VSS C a_73_118# VSS sg13_lv_nmos ad=0.1045p pd=0.93u as=0.187p ps=1.78u w=0.55u l=0.13u
X4 a_167_412# C a_73_118# VDD sg13_lv_pmos ad=0.19p pd=1.38u as=0.34p ps=2.68u w=1u l=0.13u
X5 a_73_118# B VSS VSS sg13_lv_nmos ad=0.198p pd=1.27u as=0.1045p ps=0.93u w=0.55u l=0.13u
X6 X a_73_118# VDD VDD sg13_lv_pmos ad=0.3808p pd=2.92u as=0.3822p ps=1.84u w=1.12u l=0.13u
X7 a_269_412# B a_167_412# VDD sg13_lv_pmos ad=0.1575p pd=1.315u as=0.19p ps=1.38u w=1u l=0.13u
.ends

.subckt sg13cmos5l_nand3b_1 Y A_N B C VDD VSS
X0 a_318_122# C VSS VSS sg13_lv_nmos ad=0.1406p pd=1.12u as=0.18575p ps=1.26u w=0.74u l=0.13u
X1 a_420_122# B a_318_122# VSS sg13_lv_nmos ad=0.1406p pd=1.12u as=0.1406p ps=1.12u w=0.74u l=0.13u
X2 Y a_94_160# a_420_122# VSS sg13_lv_nmos ad=0.3404p pd=2.4u as=0.1406p ps=1.12u w=0.74u l=0.13u
X3 VSS A_N a_94_160# VSS sg13_lv_nmos ad=0.18575p pd=1.26u as=0.187p ps=1.78u w=0.55u l=0.13u
X4 VDD A_N a_94_160# VDD sg13_lv_pmos ad=0.2198p pd=1.53u as=0.2856p ps=2.36u w=0.84u l=0.13u
X5 Y C VDD VDD sg13_lv_pmos ad=0.2128p pd=1.5u as=0.2198p ps=1.53u w=1.12u l=0.13u
X6 VDD B Y VDD sg13_lv_pmos ad=0.2128p pd=1.5u as=0.2128p ps=1.5u w=1.12u l=0.13u
X7 Y a_94_160# VDD VDD sg13_lv_pmos ad=0.3808p pd=2.92u as=0.2128p ps=1.5u w=1.12u l=0.13u
.ends

.subckt sg13cmos5l_tiehi L_HI VDD VSS
X0 L_HI a_222_366# VDD VDD sg13_lv_pmos ad=0.3927p pd=2.99u as=0.76727p ps=3.885u w=1.155u l=0.13u
X1 VDD a_23_195# a_23_429# VDD sg13_lv_pmos ad=0.76727p pd=3.885u as=0.2442p ps=2.06u w=0.66u l=0.13u
X2 a_222_366# a_23_429# VSS VSS sg13_lv_nmos ad=0.27427p pd=2.28u as=0.49637p ps=3.565u w=0.795u l=0.13u
X3 VSS a_23_195# a_23_195# VSS sg13_lv_nmos ad=0.49637p pd=3.565u as=0.111p ps=1.34u w=0.3u l=0.13u
.ends

.subckt housekeeping_top CSB SCK SDI SDO analog_bus_ena[0] analog_bus_ena[1] analog_bus_ena[2]
+ analog_bus_ena[3] bandgap_ena bandgap_sink1[0] bandgap_sink1[1] bandgap_sink1[2]
+ bandgap_sink2[0] bandgap_sink2[1] bandgap_trim[0] bandgap_trim[10] bandgap_trim[11]
+ bandgap_trim[12] bandgap_trim[13] bandgap_trim[14] bandgap_trim[15] bandgap_trim[1]
+ bandgap_trim[2] bandgap_trim[3] bandgap_trim[4] bandgap_trim[5] bandgap_trim[6]
+ bandgap_trim[7] bandgap_trim[8] bandgap_trim[9] biasgen_coarse biasgen_ena biasgen_fine
+ biasgen_ref_vbg clk clk_out dbus_in_left[0] dbus_in_left[10] dbus_in_left[11] dbus_in_left[1]
+ dbus_in_left[2] dbus_in_left[3] dbus_in_left[4] dbus_in_left[5] dbus_in_left[6]
+ dbus_in_left[7] dbus_in_left[8] dbus_in_left[9] dbus_in_right[0] dbus_in_right[10]
+ dbus_in_right[11] dbus_in_right[1] dbus_in_right[2] dbus_in_right[3] dbus_in_right[4]
+ dbus_in_right[5] dbus_in_right[6] dbus_in_right[7] dbus_in_right[8] dbus_in_right[9]
+ dbus_out[0] dbus_out[10] dbus_out[11] dbus_out[12] dbus_out[13] dbus_out[14] dbus_out[15]
+ dbus_out[16] dbus_out[17] dbus_out[18] dbus_out[19] dbus_out[1] dbus_out[20] dbus_out[21]
+ dbus_out[22] dbus_out[23] dbus_out[2] dbus_out[3] dbus_out[4] dbus_out[5] dbus_out[6]
+ dbus_out[7] dbus_out[8] dbus_out[9] idac1_value[0] idac1_value[1] idac1_value[2]
+ idac1_value[3] idac1_value[4] idac2_value[0] idac2_value[1] idac2_value[2] idac2_value[3]
+ idac2_value[4] io_in[0] io_in[10] io_in[11] io_in[1] io_in[2] io_in[3] io_in[4]
+ io_in[5] io_in[6] io_in[7] io_in[8] io_in[9] io_oe[0] io_oe[10] io_oe[11] io_oe[1]
+ io_oe[2] io_oe[3] io_oe[4] io_oe[5] io_oe[6] io_oe[7] io_oe[8] io_oe[9] io_out[0]
+ io_out[10] io_out[11] io_out[1] io_out[2] io_out[3] io_out[4] io_out[5] io_out[6]
+ io_out[7] io_out[8] io_out[9] mask_rev_in[0] mask_rev_in[10] mask_rev_in[11] mask_rev_in[12]
+ mask_rev_in[13] mask_rev_in[14] mask_rev_in[15] mask_rev_in[16] mask_rev_in[17]
+ mask_rev_in[18] mask_rev_in[19] mask_rev_in[1] mask_rev_in[20] mask_rev_in[21] mask_rev_in[22]
+ mask_rev_in[23] mask_rev_in[24] mask_rev_in[25] mask_rev_in[26] mask_rev_in[27]
+ mask_rev_in[28] mask_rev_in[29] mask_rev_in[2] mask_rev_in[30] mask_rev_in[31] mask_rev_in[3]
+ mask_rev_in[4] mask_rev_in[5] mask_rev_in[6] mask_rev_in[7] mask_rev_in[8] mask_rev_in[9]
+ porb proj_1v2_ena proj_3v3_ena proj_dig_ena proj_ena proj_ibias_ena[0] proj_ibias_ena[1]
+ proj_sel[0] proj_sel[1] proj_sel[2] proj_sel[3] proj_sel[4] proj_vbias_ena project_zero
+ reset sdo_ena sram_addr[0] sram_addr[1] sram_addr[2] sram_addr[3] sram_addr[4] sram_addr[5]
+ sram_addr[6] sram_addr[7] sram_addr[8] sram_addr[9] sram_clk sram_idata[0] sram_idata[1]
+ sram_idata[2] sram_idata[3] sram_idata[4] sram_idata[5] sram_idata[6] sram_idata[7]
+ sram_odata[0] sram_odata[1] sram_odata[2] sram_odata[3] sram_odata[4] sram_odata[5]
+ sram_odata[6] sram_odata[7] sram_read sram_write voltgen_ena[0] voltgen_ena[1] voltgen_ena[2]
+ voltgen_high voltgen_sink1[0] voltgen_sink1[1] voltgen_sink1[2] voltgen_sink2[0]
+ voltgen_sink2[1] voltgen_sink2[2] voltgen_source[0] voltgen_source[1] voltgen_source[2]
+ voltgen_source[3] voltgen_source[4] voltgen_value[0] voltgen_value[1] voltgen_value[2]
+ _7075_/Q _3465_/Y vddd vssd
XFILLER_7_2592 vddd vssd sg13cmos5l_decap_8
XFILLER_23_1661 vddd vssd sg13cmos5l_decap_8
Xoutbuffers\[32\] bandgap_sink1[0] _7062_/Q vddd vssd sg13cmos5l_buf_16
XFILLER_3_1788 vddd vssd sg13cmos5l_decap_8
X_6914_ _6914_/Y _6914_/A _6914_/B_N vddd vssd sg13cmos5l_nor2b_1
XFILLER_17_2100 vddd vssd sg13cmos5l_decap_8
X_6845_ _6845_/Y _6914_/A _6913_/B_N vddd vssd sg13cmos5l_nor2b_1
X_6776_ _6776_/X _6776_/A0 _6732_/A _6776_/S vddd vssd sg13cmos5l_mux2_1
XFILLER_23_667 vddd vssd sg13cmos5l_decap_8
XFILLER_22_155 vddd vssd sg13cmos5l_decap_4
X_3988_ _3988_/Y wire9/X _3986_/Y _3987_/Y vddd vssd sg13cmos5l_a21oi_1
XFILLER_17_2177 vddd vssd sg13cmos5l_decap_8
XFILLER_13_2019 vddd vssd sg13cmos5l_decap_8
X_5727_ _5729_/C _5727_/A _5727_/B _5728_/C vddd vssd sg13cmos5l_nand3_1
XFILLER_30_2399 vddd vssd sg13cmos5l_decap_8
XFILLER_30_1632 vddd vssd sg13cmos5l_decap_8
X_5658_ _5673_/C _7198_/Q _7199_/Q vddd vssd sg13cmos5l_nand2_1
XFILLER_30_1665 vddd vssd sg13cmos5l_decap_4
X_4609_ _4610_/B _4609_/A _7014_/D vddd vssd sg13cmos5l_xnor2_1
X_5589_ _5589_/Y _5589_/A _5589_/B _5589_/C vddd vssd sg13cmos5l_nor3_1
XFILLER_7_7 vddd vssd sg13cmos5l_decap_4
X_7328_ _7328_/Q _7328_/CLK _7328_/D _6842_/Y vddd vssd sg13cmos5l_dfrbpq_1
XFILLER_8_2312 vddd vssd sg13cmos5l_decap_8
XFILLER_28_2251 vddd vssd sg13cmos5l_decap_4
X_7259_ _7259_/Q _7264_/CLK _7259_/D _6954_/B_N vddd vssd sg13cmos5l_dfrbpq_1
XFILLER_24_2137 vddd vssd sg13cmos5l_decap_8
XFILLER_24_1436 vddd vssd sg13cmos5l_decap_4
Xhold1040 _6747_/A _7062_/Q vddd vssd sg13cmos5l_dlygate4sd3_1
XFILLER_24_1458 vddd vssd sg13cmos5l_decap_8
Xhold1051 _5945_/B _5944_/Y vddd vssd sg13cmos5l_dlygate4sd3_1
Xhold1084 _3517_/A _7279_/Q vddd vssd sg13cmos5l_dlygate4sd3_1
Xhold1062 _6688_/A _7024_/Q vddd vssd sg13cmos5l_dlygate4sd3_1
Xhold1073 _4408_/B _4407_/Y vddd vssd sg13cmos5l_dlygate4sd3_1
Xhold1095 _7076_/D _6769_/X vddd vssd sg13cmos5l_dlygate4sd3_1
XFILLER_26_41 vddd vssd sg13cmos5l_decap_8
XFILLER_22_1193 vddd vssd sg13cmos5l_decap_8
XFILLER_13_2520 vddd vssd sg13cmos5l_decap_8
XFILLER_13_2597 vddd vssd sg13cmos5l_decap_8
XFILLER_29_1314 vddd vssd sg13cmos5l_decap_8
XFILLER_7_1143 vddd vssd sg13cmos5l_decap_8
XFILLER_20_2535 vddd vssd sg13cmos5l_decap_8
Xwire18 wire18/X wire18/A vddd vssd sg13cmos5l_buf_2
Xwire29 wire29/X wire29/A vddd vssd sg13cmos5l_buf_4
X_4960_ _4960_/Y _4961_/A _4960_/B vddd vssd sg13cmos5l_nand2_1
X_3911_ _3911_/Y _3925_/A _3962_/A vddd vssd sg13cmos5l_nand2_1
X_4891_ _4892_/B _4891_/A _4891_/B _4891_/C _4891_/D vddd vssd sg13cmos5l_and4_1
XFILLER_32_475 vddd vssd sg13cmos5l_decap_8
X_6630_ _6630_/X _6630_/A0 _6782_/A _6632_/S vddd vssd sg13cmos5l_mux2_1
XFILLER_18_2486 vddd vssd sg13cmos5l_decap_8
X_3842_ _3842_/Y _7132_/Q _3842_/B vddd vssd sg13cmos5l_nand2b_1
XFILLER_20_626 vddd vssd sg13cmos5l_decap_8
XFILLER_18_1774 vddd vssd sg13cmos5l_decap_8
X_6561_ _6567_/S _6561_/A _6702_/B vddd vssd sg13cmos5l_nand2_1
X_3773_ _3773_/Y _3771_/Y _3772_/Y _3770_/Y vddd vssd sg13cmos5l_o21ai_1
XFILLER_14_1627 vddd vssd sg13cmos5l_decap_8
X_5512_ _5527_/B _7178_/Q _5515_/B vddd vssd sg13cmos5l_nor2_1
XFILLER_12_2041 vddd vssd sg13cmos5l_decap_4
X_6492_ _7198_/D _6492_/A1 _6496_/B hold955/X vddd vssd sg13cmos5l_o21ai_1
X_5443_ _5443_/Y _5526_/A _5441_/Y _5442_/Y vddd vssd sg13cmos5l_a21oi_1
X_5374_ _5374_/X _5464_/A _5374_/B vddd vssd sg13cmos5l_or2_1
X_7113_ _7113_/Q _7119_/CLK _7113_/D _6966_/B_N vddd vssd sg13cmos5l_dfrbpq_1
X_4325_ _4326_/C _4325_/A _4325_/B vddd vssd sg13cmos5l_and2_1
Xfanout127 _4684_/A _4546_/A vddd vssd sg13cmos5l_buf_1
Xfanout138 _3938_/A _3867_/B vddd vssd sg13cmos5l_buf_1
Xfanout105 _3889_/A _3896_/A vddd vssd sg13cmos5l_buf_1
Xfanout116 _6789_/B _6762_/C vddd vssd sg13cmos5l_buf_1
XFILLER_25_2468 vddd vssd sg13cmos5l_decap_8
X_7044_ _7044_/Q _7367_/CLK _7044_/D _6835_/B_N vddd vssd sg13cmos5l_dfrbpq_1
X_4256_ _4258_/C _7096_/Q _4256_/B vddd vssd sg13cmos5l_nand2b_1
Xfanout149 _6167_/B1 _6278_/A1 vddd vssd sg13cmos5l_buf_1
X_4187_ _4187_/Y _7029_/Q _6696_/A _6687_/A _7024_/Q vddd vssd sg13cmos5l_a22oi_1
XFILLER_27_247 vddd vssd sg13cmos5l_decap_8
XFILLER_23_1480 vddd vssd sg13cmos5l_decap_4
XFILLER_3_1596 vddd vssd sg13cmos5l_decap_8
XFILLER_23_475 vddd vssd sg13cmos5l_decap_4
X_6828_ _6828_/Y _6835_/A _6835_/B_N vddd vssd sg13cmos5l_nor2b_1
XFILLER_32_2439 vddd vssd sg13cmos5l_decap_8
X_6759_ _6759_/Y _6759_/A _6761_/S vddd vssd sg13cmos5l_nor2_1
XFILLER_7_619 vddd vssd sg13cmos5l_decap_8
XFILLER_12_21 vddd vssd sg13cmos5l_decap_8
XFILLER_30_1440 vddd vssd sg13cmos5l_decap_8
XFILLER_8_2175 vddd vssd sg13cmos5l_decap_4
XFILLER_8_2197 vddd vssd sg13cmos5l_decap_8
XFILLER_18_214 vddd vssd sg13cmos5l_decap_4
XFILLER_14_442 vddd vssd sg13cmos5l_decap_8
XFILLER_18_1048 vddd vssd sg13cmos5l_decap_8
XFILLER_10_670 vddd vssd sg13cmos5l_decap_8
XFILLER_9_1205 vddd vssd sg13cmos5l_decap_8
XFILLER_29_1177 vddd vssd sg13cmos5l_decap_8
X_4110_ _4110_/Y _7251_/Q _6590_/A vddd vssd sg13cmos5l_nor2_1
X_5090_ _6075_/A _5204_/A _7245_/Q _5266_/A vddd vssd sg13cmos5l_nor3_1
X_4041_ _4041_/Y _7208_/Q _6506_/A _3934_/Y vddd vssd sg13cmos5l_o21ai_1
XFILLER_0_2415 vddd vssd sg13cmos5l_decap_8
XFILLER_4_2573 vddd vssd sg13cmos5l_decap_8
XFILLER_20_2365 vddd vssd sg13cmos5l_decap_8
XFILLER_25_729 vddd vssd sg13cmos5l_decap_8
XFILLER_20_1653 vddd vssd sg13cmos5l_decap_8
XFILLER_0_1747 vddd vssd sg13cmos5l_decap_8
X_5992_ _5992_/Y _7290_/Q _3579_/Y _5193_/B vddd vssd sg13cmos5l_a21oi_1
X_4943_ _4943_/Y _4943_/A _4943_/B _4943_/C vddd vssd sg13cmos5l_nor3_1
XFILLER_32_261 vddd vssd sg13cmos5l_decap_8
X_4874_ _4891_/A _4874_/A _4874_/B vddd vssd sg13cmos5l_nor2_1
X_6613_ _6613_/X _6613_/A0 _6773_/A _6614_/S vddd vssd sg13cmos5l_mux2_1
X_3825_ _3825_/X _7077_/Q _3821_/Y _6753_/A vddd vssd sg13cmos5l_a21o_1
XFILLER_31_2450 vddd vssd sg13cmos5l_decap_8
X_6544_ _6544_/Y _6544_/A1 _6543_/B _6543_/Y vddd vssd sg13cmos5l_a21oi_1
X_3756_ _3756_/X _3758_/A _3756_/B vddd vssd sg13cmos5l_and2_1
X_6475_ _6481_/B _6475_/A _6475_/B vddd vssd sg13cmos5l_nand2_1
X_3687_ _3878_/B _3753_/C _3753_/D vddd vssd sg13cmos5l_or2_1
X_5426_ _5441_/C _7166_/Q _7167_/Q vddd vssd sg13cmos5l_nand2_1
XFILLER_27_1807 vddd vssd sg13cmos5l_decap_8
X_5357_ _5359_/A _5789_/A _5354_/Y _5356_/Y vddd vssd sg13cmos5l_a21oi_1
X_5288_ _5288_/Y _5308_/D _5319_/A _5286_/Y vddd vssd sg13cmos5l_o21ai_1
X_4308_ _4308_/Y _4308_/A _4308_/B vddd vssd sg13cmos5l_xnor2_1
X_7027_ _7027_/Q _7201_/CLK _7027_/D fanout369/X vddd vssd sg13cmos5l_dfrbpq_1
X_4239_ _4240_/C _7073_/Q _3821_/Y _4241_/A2 vddd vssd sg13cmos5l_a21oi_1
XFILLER_21_2129 vddd vssd sg13cmos5l_decap_8
XFILLER_25_1564 vddd vssd sg13cmos5l_decap_8
XFILLER_28_556 vddd vssd sg13cmos5l_decap_8
XFILLER_24_751 vddd vssd sg13cmos5l_decap_8
XFILLER_19_1313 vddd vssd sg13cmos5l_decap_8
XFILLER_11_401 vddd vssd sg13cmos5l_decap_8
XFILLER_32_2247 vddd vssd sg13cmos5l_decap_8
XFILLER_23_42 vddd vssd sg13cmos5l_decap_8
XFILLER_10_2512 vddd vssd sg13cmos5l_decap_8
XFILLER_10_2589 vddd vssd sg13cmos5l_decap_8
XFILLER_3_633 vddd vssd sg13cmos5l_decap_8
Xtiedowns\[31\] dbus_in_left[11] vddd vssd sg13cmos5l_antennanp
XFILLER_4_1102 vddd vssd sg13cmos5l_decap_4
XFILLER_24_1096 vddd vssd sg13cmos5l_decap_8
XFILLER_19_534 vddd vssd sg13cmos5l_decap_4
XFILLER_0_35 vddd vssd sg13cmos5l_decap_8
XFILLER_4_1157 vddd vssd sg13cmos5l_decap_8
XFILLER_21_209 vddd vssd sg13cmos5l_decap_8
XFILLER_15_2423 vddd vssd sg13cmos5l_decap_8
XFILLER_15_795 vddd vssd sg13cmos5l_decap_8
XFILLER_15_1722 vddd vssd sg13cmos5l_decap_8
X_4590_ _4593_/B _4590_/A _4590_/B vddd vssd sg13cmos5l_nor2_1
X_3610_ _6215_/A _3610_/A vddd vssd sg13cmos5l_inv_1
XFILLER_7_950 vddd vssd sg13cmos5l_decap_8
X_3541_ _3541_/Y _5319_/A vddd vssd sg13cmos5l_inv_1
Xhold906 hold906/X hold906/A vddd vssd sg13cmos5l_dlygate4sd3_1
Xhold928 hold928/X _6598_/Y vddd vssd sg13cmos5l_dlygate4sd3_1
Xhold917 hold917/X _4960_/Y vddd vssd sg13cmos5l_dlygate4sd3_1
X_3472_ _3472_/Y _4655_/A vddd vssd sg13cmos5l_inv_1
X_6260_ _6260_/Y _3497_/Y _6207_/S _6259_/Y vddd vssd sg13cmos5l_a21oi_1
XFILLER_6_482 vddd vssd sg13cmos5l_decap_4
Xhold939 hold939/X _4957_/Y vddd vssd sg13cmos5l_dlygate4sd3_1
X_6191_ _6192_/A _6189_/Y _6190_/Y _5237_/B vddd vssd sg13cmos5l_o21ai_1
X_5211_ _6188_/C _5211_/A _7289_/Q vddd vssd sg13cmos5l_nand2_1
XFILLER_26_2563 vddd vssd sg13cmos5l_decap_8
X_5142_ _5149_/B _5223_/B _5174_/B vddd vssd sg13cmos5l_nor2_1
XFILLER_29_0 vddd vssd sg13cmos5l_decap_8
XFILLER_22_1704 vddd vssd sg13cmos5l_decap_4
X_5073_ _5259_/A _7258_/Q _7259_/Q vddd vssd sg13cmos5l_nand2_1
X_4024_ _6072_/A dbus_in_left[2] dbus_in_right[2] vddd vssd sg13cmos5l_nor2_1
XFILLER_0_2234 vddd vssd sg13cmos5l_decap_8
XFILLER_25_548 vddd vssd sg13cmos5l_decap_8
XFILLER_20_1472 vddd vssd sg13cmos5l_decap_8
XFILLER_0_1533 vddd vssd sg13cmos5l_decap_4
X_5975_ _5977_/B _5873_/A _5972_/Y _5973_/Y _5971_/Y _5976_/B vddd vssd sg13cmos5l_a221oi_1
XFILLER_0_1588 vddd vssd sg13cmos5l_decap_8
X_4926_ _4942_/B _4946_/A _4949_/A vddd vssd sg13cmos5l_and2_1
X_4857_ _4857_/Y _4862_/A _4867_/B _4856_/B vddd vssd sg13cmos5l_o21ai_1
XFILLER_21_787 vddd vssd sg13cmos5l_decap_8
X_3808_ _3810_/C _7093_/Q _4172_/A2 wire85/X vddd vssd sg13cmos5l_a21oi_1
XFILLER_31_2280 vddd vssd sg13cmos5l_decap_8
X_6527_ _6527_/X _6558_/A hold872/X _6528_/S vddd vssd sg13cmos5l_mux2_1
X_4788_ _4790_/B _4798_/A _4788_/B vddd vssd sg13cmos5l_nand2_1
X_3739_ _4259_/B _6301_/A _3933_/A vddd vssd sg13cmos5l_nor2_1
XFILLER_10_1118 vddd vssd sg13cmos5l_decap_8
X_6458_ _7180_/D _6458_/A1 _6459_/B _6457_/Y vddd vssd sg13cmos5l_a21oi_1
X_5409_ _5414_/C _5526_/A _7162_/Q _7163_/Q _5416_/B vddd vssd sg13cmos5l_nand4_1
X_6389_ _6389_/Y _6344_/A _6388_/B _6389_/B1 vddd vssd sg13cmos5l_o21ai_1
XFILLER_5_1411 vddd vssd sg13cmos5l_decap_4
XFILLER_5_2178 vddd vssd sg13cmos5l_decap_8
XFILLER_9_1591 vddd vssd sg13cmos5l_decap_8
XFILLER_29_854 vddd vssd sg13cmos5l_decap_4
XFILLER_18_42 vddd vssd sg13cmos5l_decap_8
XFILLER_3_1190 vddd vssd sg13cmos5l_decap_8
XFILLER_32_2000 vddd vssd sg13cmos5l_decap_8
XFILLER_19_1198 vddd vssd sg13cmos5l_decap_8
Xwire111 _3875_/A _3908_/A vddd vssd sg13cmos5l_buf_4
XFILLER_8_714 vddd vssd sg13cmos5l_decap_8
XFILLER_32_1387 vddd vssd sg13cmos5l_decap_8
Xtiedowns\[79\] clkload0/A vddd vssd sg13cmos5l_antennanp
XFILLER_10_2364 vddd vssd sg13cmos5l_decap_4
XFILLER_4_953 vddd vssd sg13cmos5l_decap_8
XFILLER_22_7 vddd vssd sg13cmos5l_decap_8
XFILLER_21_2493 vddd vssd sg13cmos5l_decap_8
X_5760_ _5760_/Y _5762_/A _7213_/Q _5760_/C vddd vssd sg13cmos5l_nor3_1
X_5691_ _5691_/X _7202_/Q _7203_/Q vddd vssd sg13cmos5l_and2_1
X_4711_ _4711_/Y _4771_/A1 _3598_/Y _4771_/B1 _4710_/X vddd vssd sg13cmos5l_a22oi_1
X_4642_ _4642_/Y _4662_/A _4642_/B vddd vssd sg13cmos5l_xnor2_1
XFILLER_11_2128 vddd vssd sg13cmos5l_decap_8
X_4573_ _4573_/Y _4577_/A _4620_/B vddd vssd sg13cmos5l_nor2_1
X_7361_ _7361_/Q _7363_/CLK _7361_/D _6875_/Y vddd vssd sg13cmos5l_dfrbpq_1
Xhold703 _4414_/A _7352_/Q vddd vssd sg13cmos5l_dlygate4sd3_1
Xhold736 hold736/X _4861_/Y vddd vssd sg13cmos5l_dlygate4sd3_1
X_7292_ _7292_/Q _7292_/CLK _7292_/D fanout373/X vddd vssd sg13cmos5l_dfrbpq_1
XFILLER_7_780 vddd vssd sg13cmos5l_decap_8
Xhold714 hold714/X _6790_/Y vddd vssd sg13cmos5l_dlygate4sd3_1
X_3524_ _4912_/A _4828_/A vddd vssd sg13cmos5l_inv_1
X_6312_ _6312_/Y _6312_/A _6789_/B vddd vssd sg13cmos5l_nor2_1
Xhold725 _7360_/D _4354_/X vddd vssd sg13cmos5l_dlygate4sd3_1
X_6243_ _6243_/Y _4208_/X _5251_/A _5253_/B vddd vssd sg13cmos5l_a21oi_1
Xhold747 _7139_/D _6381_/Y vddd vssd sg13cmos5l_dlygate4sd3_1
Xhold758 hold758/X _4339_/Y vddd vssd sg13cmos5l_dlygate4sd3_1
Xhold769 hold769/X _6386_/Y vddd vssd sg13cmos5l_dlygate4sd3_1
Xoutbuffers\[62\] voltgen_ena[2] _7052_/Q vddd vssd sg13cmos5l_buf_16
XFILLER_26_2360 vddd vssd sg13cmos5l_decap_8
X_6174_ _6174_/Y _4207_/Y _5193_/C _6172_/Y _6173_/Y _6175_/B vddd vssd sg13cmos5l_a221oi_1
Xhold1425 _4548_/A1 _5659_/A vddd vssd sg13cmos5l_dlygate4sd3_1
Xhold1403 _6407_/A1 _5327_/A vddd vssd sg13cmos5l_dlygate4sd3_1
Xhold1414 hold1414/X _7212_/Q vddd vssd sg13cmos5l_dlygate4sd3_1
XFILLER_6_2454 vddd vssd sg13cmos5l_decap_4
X_5125_ _5133_/C _5125_/A _5172_/B vddd vssd sg13cmos5l_nand2_1
Xhold1458 _3612_/A _7050_/Q vddd vssd sg13cmos5l_dlygate4sd3_1
Xhold1447 _6649_/A0 _5212_/B vddd vssd sg13cmos5l_dlygate4sd3_1
X_5056_ _6039_/B _7272_/Q _7273_/Q _5239_/A vddd vssd sg13cmos5l_nor3_1
Xhold1436 hold1436/X _7237_/Q vddd vssd sg13cmos5l_dlygate4sd3_1
XFILLER_6_2487 vddd vssd sg13cmos5l_decap_8
Xhold1469 _6733_/A1 _3624_/Y vddd vssd sg13cmos5l_dlygate4sd3_1
X_4007_ _4008_/D _7272_/Q wire89/X wire88/X _7276_/Q vddd vssd sg13cmos5l_a22oi_1
XFILLER_6_1797 vddd vssd sg13cmos5l_decap_4
XFILLER_25_301 vddd vssd sg13cmos5l_decap_8
XFILLER_0_2086 vddd vssd sg13cmos5l_decap_8
X_5958_ _5958_/Y _6219_/A _5968_/B _5972_/A vddd vssd sg13cmos5l_nor3_1
Xclkbuf_leaf_28_SCK_regs _7123_/CLK clkload7/A vddd vssd sg13cmos5l_buf_8
XFILLER_16_2039 vddd vssd sg13cmos5l_decap_8
X_4909_ _4909_/Y _4909_/A1 wire17/X _4909_/B1 vddd vssd sg13cmos5l_o21ai_1
X_5889_ _5890_/C _5889_/A _5889_/B vddd vssd sg13cmos5l_nor2_1
XFILLER_14_1073 vddd vssd sg13cmos5l_decap_4
XFILLER_20_21 vddd vssd sg13cmos5l_decap_8
XFILLER_20_98 vddd vssd sg13cmos5l_decap_8
XFILLER_0_488 vddd vssd sg13cmos5l_decap_8
XFILLER_29_63 vddd vssd sg13cmos5l_decap_8
XFILLER_25_1180 vddd vssd sg13cmos5l_decap_4
XFILLER_28_172 vddd vssd sg13cmos5l_decap_8
XFILLER_16_2540 vddd vssd sg13cmos5l_decap_8
XFILLER_12_595 vddd vssd sg13cmos5l_decap_4
XFILLER_32_1151 vddd vssd sg13cmos5l_decap_8
XFILLER_6_23 vddd vssd sg13cmos5l_decap_8
XANTENNA_5 SDI vddd vssd sg13cmos5l_antennanp
XFILLER_6_67 vddd vssd sg13cmos5l_decap_8
XFILLER_6_89 vddd vssd sg13cmos5l_decap_8
XFILLER_10_2183 vddd vssd sg13cmos5l_decap_4
XFILLER_6_1027 vddd vssd sg13cmos5l_decap_8
XFILLER_23_2566 vddd vssd sg13cmos5l_decap_8
XFILLER_23_1854 vddd vssd sg13cmos5l_decap_4
X_6930_ _6930_/Y _6948_/A _6968_/B_N vddd vssd sg13cmos5l_nor2b_1
X_6861_ _6861_/Y _6966_/A _6945_/B_N vddd vssd sg13cmos5l_nor2b_1
XFILLER_17_2326 vddd vssd sg13cmos5l_decap_8
XFILLER_17_2315 vddd vssd sg13cmos5l_decap_8
X_6792_ _6792_/Y _6792_/A _6801_/B vddd vssd sg13cmos5l_nor2_1
X_5812_ _5812_/Y _7218_/Q _7219_/Q _5812_/C _7221_/Q vddd vssd sg13cmos5l_nor4_1
XFILLER_22_326 vddd vssd sg13cmos5l_decap_8
X_5743_ _5743_/Y _5762_/A _5743_/B vddd vssd sg13cmos5l_nor2_1
Xoutbuffers\[6\] proj_vbias_ena _7035_/Q vddd vssd sg13cmos5l_buf_16
XFILLER_30_2504 vddd vssd sg13cmos5l_decap_8
XFILLER_17_1658 vddd vssd sg13cmos5l_decap_4
XFILLER_30_381 vddd vssd sg13cmos5l_decap_8
X_5674_ _5674_/Y _7200_/Q _7201_/Q _5674_/C vddd vssd sg13cmos5l_nor3_1
XFILLER_15_2083 vddd vssd sg13cmos5l_decap_8
X_4625_ _4628_/B _4625_/A _4653_/A vddd vssd sg13cmos5l_nor2b_1
XFILLER_11_1202 vddd vssd sg13cmos5l_decap_4
Xhold511 _7021_/D _3468_/Y vddd vssd sg13cmos5l_dlygate4sd3_1
XFILLER_30_1869 vddd vssd sg13cmos5l_decap_8
X_7344_ _7344_/Q _7348_/CLK _7344_/D _6858_/Y vddd vssd sg13cmos5l_dfrbpq_1
X_4556_ _4556_/Y _4556_/A _4556_/B vddd vssd sg13cmos5l_nor2_1
Xhold500 _7009_/D hold500/A vddd vssd sg13cmos5l_dlygate4sd3_1
XFILLER_11_1246 vddd vssd sg13cmos5l_decap_8
Xhold533 _7002_/D _4971_/Y vddd vssd sg13cmos5l_dlygate4sd3_1
XFILLER_28_2433 vddd vssd sg13cmos5l_decap_8
Xhold522 _3632_/B _7001_/Q vddd vssd sg13cmos5l_dlygate4sd3_1
X_3507_ _3507_/Y _7141_/Q vddd vssd sg13cmos5l_inv_1
Xhold544 _4775_/B _6985_/Q vddd vssd sg13cmos5l_dlygate4sd3_1
Xhold555 _7000_/D _6810_/X vddd vssd sg13cmos5l_dlygate4sd3_1
X_7275_ _7275_/Q _7285_/CLK _7275_/D fanout383/X vddd vssd sg13cmos5l_dfrbpq_1
X_4487_ _4487_/Y _7083_/Q _4501_/B _4566_/A1 vddd vssd sg13cmos5l_a21oi_1
Xhold566 _4091_/A _7390_/Q vddd vssd sg13cmos5l_dlygate4sd3_1
Xhold588 hold588/X _3793_/Y vddd vssd sg13cmos5l_dlygate4sd3_1
Xhold577 _3791_/A _7395_/Q vddd vssd sg13cmos5l_dlygate4sd3_1
Xhold599 _4309_/B _7377_/Q vddd vssd sg13cmos5l_dlygate4sd3_1
X_6226_ _6227_/C _6224_/X _6225_/X _6232_/C vddd vssd sg13cmos5l_a21oi_1
X_6157_ _6157_/Y _6154_/Y _6155_/Y _6158_/B vddd vssd sg13cmos5l_o21ai_1
Xhold1200 _6435_/A1 _5429_/B vddd vssd sg13cmos5l_dlygate4sd3_1
Xhold1211 _7283_/D _6643_/X vddd vssd sg13cmos5l_dlygate4sd3_1
Xhold1233 _6744_/A1 _3619_/Y vddd vssd sg13cmos5l_dlygate4sd3_1
Xhold1222 _7248_/D _6588_/X vddd vssd sg13cmos5l_dlygate4sd3_1
X_5108_ _5131_/A _7242_/Q _7243_/Q _5176_/B vddd vssd sg13cmos5l_nor3_1
Xhold1255 _7064_/D _6750_/X vddd vssd sg13cmos5l_dlygate4sd3_1
Xhold1244 _6693_/A1 _4010_/A vddd vssd sg13cmos5l_dlygate4sd3_1
Xhold1266 _7063_/D _6749_/X vddd vssd sg13cmos5l_dlygate4sd3_1
X_6088_ _6088_/X _6088_/A _6088_/B vddd vssd sg13cmos5l_and2_1
Xhold1299 _6724_/A0 _7048_/Q vddd vssd sg13cmos5l_dlygate4sd3_1
Xhold1277 hold1277/X _7173_/Q vddd vssd sg13cmos5l_dlygate4sd3_1
Xhold1288 _6551_/A1 _5868_/C vddd vssd sg13cmos5l_dlygate4sd3_1
X_5039_ _5042_/C _5204_/A _7245_/Q _5222_/A vddd vssd sg13cmos5l_nor3_1
XFILLER_6_1594 vddd vssd sg13cmos5l_decap_4
XFILLER_25_142 vddd vssd sg13cmos5l_decap_8
XFILLER_2_1469 vddd vssd sg13cmos5l_decap_8
XFILLER_15_21 vddd vssd sg13cmos5l_decap_8
XFILLER_5_514 vddd vssd sg13cmos5l_decap_8
XFILLER_31_86 vddd vssd sg13cmos5l_decap_8
XFILLER_11_2470 vddd vssd sg13cmos5l_decap_8
XFILLER_5_569 vddd vssd sg13cmos5l_decap_8
XFILLER_11_1780 vddd vssd sg13cmos5l_decap_8
XFILLER_27_1220 vddd vssd sg13cmos5l_decap_8
XFILLER_17_621 vddd vssd sg13cmos5l_decap_4
XFILLER_18_1912 vddd vssd sg13cmos5l_decap_8
XFILLER_31_156 vddd vssd sg13cmos5l_decap_8
XFILLER_18_1956 vddd vssd sg13cmos5l_decap_8
XFILLER_13_860 vddd vssd sg13cmos5l_decap_8
XFILLER_9_842 vddd vssd sg13cmos5l_decap_4
XFILLER_8_341 vddd vssd sg13cmos5l_decap_8
X_4410_ _4410_/Y _4410_/A _4413_/B vddd vssd sg13cmos5l_xnor2_1
X_5390_ _5390_/X _5526_/A _5388_/B _5389_/Y vddd vssd sg13cmos5l_a21o_1
XFILLER_12_1599 vddd vssd sg13cmos5l_decap_8
X_4341_ _4341_/Y _4326_/C _4340_/Y hold758/X vddd vssd sg13cmos5l_o21ai_1
X_7060_ _7060_/Q _7146_/CLK _7060_/D fanout350/X vddd vssd sg13cmos5l_dfrbpq_1
Xfanout309 _4812_/B _4659_/A1 vddd vssd sg13cmos5l_buf_1
X_4272_ _4279_/B _4272_/A _4303_/B vddd vssd sg13cmos5l_nand2_1
X_6011_ _6011_/Y _6009_/Y _6010_/Y _6008_/Y vddd vssd sg13cmos5l_o21ai_1
XFILLER_7_2571 vddd vssd sg13cmos5l_decap_8
XFILLER_23_1640 vddd vssd sg13cmos5l_decap_8
XFILLER_11_0 vddd vssd sg13cmos5l_decap_8
Xoutbuffers\[25\] voltgen_sink2[1] _7071_/Q vddd vssd sg13cmos5l_buf_16
X_6913_ _6913_/Y _6913_/A _6913_/B_N vddd vssd sg13cmos5l_nor2b_1
XFILLER_22_134 vddd vssd sg13cmos5l_decap_8
X_6844_ _6844_/Y _6914_/A _6913_/B_N vddd vssd sg13cmos5l_nor2b_1
X_6775_ _6775_/X _6775_/A0 _6336_/A _6776_/S vddd vssd sg13cmos5l_mux2_1
X_3987_ _3987_/Y _7131_/Q _6363_/A _3717_/Y vddd vssd sg13cmos5l_o21ai_1
XFILLER_32_1909 vddd vssd sg13cmos5l_decap_8
X_5726_ _5730_/B _7206_/Q _7207_/Q _5733_/B vddd vssd sg13cmos5l_nand3_1
XFILLER_30_2378 vddd vssd sg13cmos5l_decap_8
X_5657_ _5674_/C _7198_/Q _7199_/Q vddd vssd sg13cmos5l_nand2b_1
X_4608_ _4608_/Y _4507_/X _4603_/Y _4604_/Y _4605_/Y _4607_/Y vddd vssd sg13cmos5l_a221oi_1
X_5588_ _5589_/C _7188_/Q _7189_/Q _5588_/C vddd vssd sg13cmos5l_nor3_1
X_4539_ _4539_/Y _4539_/A _4539_/B _4539_/C vddd vssd sg13cmos5l_nor3_1
X_7327_ _7327_/Q _7400_/CLK _7327_/D _6841_/Y vddd vssd sg13cmos5l_dfrbpq_1
XFILLER_11_1098 vddd vssd sg13cmos5l_decap_8
X_7258_ _7258_/Q _7258_/CLK _7258_/D fanout381/X vddd vssd sg13cmos5l_dfrbpq_1
XFILLER_28_1562 vddd vssd sg13cmos5l_decap_8
XFILLER_24_1404 vddd vssd sg13cmos5l_decap_8
X_6209_ _6209_/Y _7234_/Q _7235_/Q _6235_/A _6232_/B vddd vssd sg13cmos5l_nor4_1
XFILLER_28_1595 vddd vssd sg13cmos5l_decap_8
X_7189_ _7189_/Q _7189_/CLK _7189_/D fanout363/X vddd vssd sg13cmos5l_dfrbpq_1
Xhold1041 _6748_/B1 _6747_/Y vddd vssd sg13cmos5l_dlygate4sd3_1
Xhold1030 _6740_/A _7058_/Q vddd vssd sg13cmos5l_dlygate4sd3_1
Xhold1085 _6637_/A1 _5020_/B vddd vssd sg13cmos5l_dlygate4sd3_1
Xhold1063 _6689_/B1 _6688_/Y vddd vssd sg13cmos5l_dlygate4sd3_1
Xhold1052 _6978_/D _5945_/Y vddd vssd sg13cmos5l_dlygate4sd3_1
XFILLER_6_1391 vddd vssd sg13cmos5l_decap_8
Xhold1074 _7355_/D _4409_/X vddd vssd sg13cmos5l_dlygate4sd3_1
Xhold1096 _6701_/A0 _7032_/Q vddd vssd sg13cmos5l_dlygate4sd3_1
XFILLER_26_97 vddd vssd sg13cmos5l_decap_8
XFILLER_9_127 vddd vssd sg13cmos5l_decap_8
XFILLER_13_2576 vddd vssd sg13cmos5l_decap_8
XFILLER_5_322 vddd vssd sg13cmos5l_decap_8
XFILLER_6_834 vddd vssd sg13cmos5l_decap_4
XFILLER_10_885 vddd vssd sg13cmos5l_decap_8
XFILLER_13_1897 vddd vssd sg13cmos5l_decap_8
Xtiedowns\[61\] mask_rev_in[17] vddd vssd sg13cmos5l_antennanp
XFILLER_29_1359 vddd vssd sg13cmos5l_decap_8
XFILLER_3_35 vddd vssd sg13cmos5l_decap_8
XFILLER_7_1111 vddd vssd sg13cmos5l_decap_8
XFILLER_3_79 vddd vssd sg13cmos5l_decap_4
XFILLER_20_2514 vddd vssd sg13cmos5l_decap_8
XFILLER_18_952 vddd vssd sg13cmos5l_decap_8
XFILLER_18_996 vddd vssd sg13cmos5l_decap_8
Xoutbuffers\[115\] dbus_out[18] _5823_/Y vddd vssd sg13cmos5l_buf_16
X_4890_ _4891_/D _4890_/A _4890_/B _4895_/A _4890_/D vddd vssd sg13cmos5l_nor4_1
X_3910_ _6554_/A _3924_/A _3961_/A vddd vssd sg13cmos5l_nor2_1
XFILLER_32_454 vddd vssd sg13cmos5l_decap_8
XFILLER_18_2465 vddd vssd sg13cmos5l_decap_8
X_3841_ _3841_/Y _7140_/Q _4183_/B1 _6363_/A vddd vssd sg13cmos5l_o21ai_1
X_3772_ _3772_/Y _7296_/Q _4189_/B1 vddd vssd sg13cmos5l_nor2b_1
XFILLER_18_1753 vddd vssd sg13cmos5l_decap_8
X_6560_ _6560_/X _6520_/A hold763/X _6560_/S vddd vssd sg13cmos5l_mux2_1
X_5511_ _5511_/Y _7180_/Q _5511_/B vddd vssd sg13cmos5l_nor2_1
XFILLER_12_2020 vddd vssd sg13cmos5l_decap_8
X_6491_ _6491_/Y _6491_/A _6496_/B vddd vssd sg13cmos5l_nand2_1
XFILLER_9_672 vddd vssd sg13cmos5l_decap_8
X_5442_ _5442_/Y _5442_/A _7169_/Q _5442_/C vddd vssd sg13cmos5l_nor3_1
X_5373_ _5389_/C _5373_/A _7159_/Q vddd vssd sg13cmos5l_nand2_1
XFILLER_29_2583 vddd vssd sg13cmos5l_decap_8
X_7112_ _7112_/Q _7119_/CLK _7112_/D _6958_/B_N vddd vssd sg13cmos5l_dfrbpq_1
X_4324_ _4325_/B _4339_/B _4346_/A vddd vssd sg13cmos5l_and2_1
X_7043_ _7043_/Q _7071_/CLK _7043_/D _6835_/B_N vddd vssd sg13cmos5l_dfrbpq_1
XFILLER_25_2447 vddd vssd sg13cmos5l_decap_8
XFILLER_25_1702 vddd vssd sg13cmos5l_decap_8
Xfanout128 _4792_/A _4546_/A vddd vssd sg13cmos5l_buf_1
Xfanout117 _6762_/C _6300_/Y vddd vssd sg13cmos5l_buf_1
XFILLER_5_2519 vddd vssd sg13cmos5l_decap_8
Xfanout106 _3896_/A _3707_/Y vddd vssd sg13cmos5l_buf_1
Xfanout139 _3940_/A _3902_/B vddd vssd sg13cmos5l_buf_1
XFILLER_9_1965 vddd vssd sg13cmos5l_decap_8
X_4255_ _4258_/B _7104_/Q _6312_/A _4254_/Y vddd vssd sg13cmos5l_o21ai_1
X_4186_ _4186_/Y _3727_/B _3835_/B _3609_/Y vddd vssd sg13cmos5l_a21oi_1
XFILLER_7_2390 vddd vssd sg13cmos5l_decap_8
XFILLER_27_215 vddd vssd sg13cmos5l_decap_8
XFILLER_23_1492 vddd vssd sg13cmos5l_decap_8
XFILLER_3_1575 vddd vssd sg13cmos5l_decap_4
XFILLER_24_977 vddd vssd sg13cmos5l_decap_8
X_6827_ _6827_/Y _6913_/A _6840_/B_N vddd vssd sg13cmos5l_nor2b_1
XFILLER_32_2418 vddd vssd sg13cmos5l_decap_8
XFILLER_32_1706 vddd vssd sg13cmos5l_decap_4
XFILLER_11_616 vddd vssd sg13cmos5l_decap_4
X_6758_ _6758_/X _6769_/A1 _6758_/A1 _6761_/S vddd vssd sg13cmos5l_mux2_1
X_6689_ _7024_/D _6704_/A1 _6695_/S _6689_/B1 vddd vssd sg13cmos5l_o21ai_1
X_5709_ _5733_/B _7208_/Q _7209_/Q vddd vssd sg13cmos5l_nor2_1
XFILLER_4_2029 vddd vssd sg13cmos5l_decap_8
XFILLER_19_727 vddd vssd sg13cmos5l_decap_8
XFILLER_8_1497 vddd vssd sg13cmos5l_decap_8
XFILLER_30_969 vddd vssd sg13cmos5l_decap_8
XFILLER_6_642 vddd vssd sg13cmos5l_decap_8
XFILLER_6_686 vddd vssd sg13cmos5l_decap_8
XFILLER_5_185 vddd vssd sg13cmos5l_decap_8
X_4040_ _4040_/X _4040_/A _4040_/B _4040_/C vddd vssd sg13cmos5l_and3_1
XFILLER_20_2333 vddd vssd sg13cmos5l_decap_4
XFILLER_4_2552 vddd vssd sg13cmos5l_decap_8
X_5991_ _5991_/X hold816/X _5990_/Y _5991_/S vddd vssd sg13cmos5l_mux2_1
XFILLER_18_760 vddd vssd sg13cmos5l_decap_4
XFILLER_0_1726 vddd vssd sg13cmos5l_decap_8
X_4942_ _4943_/C _4942_/A _4942_/B vddd vssd sg13cmos5l_nor2_1
XFILLER_21_903 vddd vssd sg13cmos5l_decap_8
X_4873_ _4874_/B _4937_/A _7144_/Q _4872_/X vddd vssd sg13cmos5l_o21ai_1
XFILLER_14_2104 vddd vssd sg13cmos5l_decap_4
X_6612_ _6612_/X _6612_/A0 _6788_/A1 _6614_/S vddd vssd sg13cmos5l_mux2_1
X_3824_ _3824_/Y _3818_/Y _3820_/Y _3822_/Y _3694_/Y vddd vssd sg13cmos5l_a22oi_1
XFILLER_14_2137 vddd vssd sg13cmos5l_decap_8
X_6543_ _6543_/Y _6552_/A _6543_/B vddd vssd sg13cmos5l_nor2_1
X_3755_ _3756_/B _3755_/A _3922_/B vddd vssd sg13cmos5l_nand2_1
XFILLER_31_1761 vddd vssd sg13cmos5l_decap_4
X_6474_ _6474_/X _6459_/A _6474_/A1 _6474_/S vddd vssd sg13cmos5l_mux2_1
X_3686_ _3686_/Y _6301_/A _6762_/A vddd vssd sg13cmos5l_nor2_1
Xoutbuffers\[92\] io_out[7] wire12/X vddd vssd sg13cmos5l_buf_16
X_5425_ _5442_/C _7166_/Q _7167_/Q vddd vssd sg13cmos5l_nand2b_1
XFILLER_29_2380 vddd vssd sg13cmos5l_decap_8
X_5356_ _5356_/Y _5326_/A _5341_/Y _5344_/Y _5353_/Y _5354_/Y vddd vssd sg13cmos5l_a221oi_1
X_5287_ _5287_/Y _5294_/B _7148_/Q _5544_/A vddd vssd sg13cmos5l_nor3_1
X_4307_ _7372_/D _4307_/A _4307_/B vddd vssd sg13cmos5l_and2_1
XFILLER_9_2485 vddd vssd sg13cmos5l_decap_8
X_7026_ _7026_/Q _7199_/CLK _7026_/D fanout369/X vddd vssd sg13cmos5l_dfrbpq_1
X_4238_ _4240_/B _7146_/Q _4238_/B vddd vssd sg13cmos5l_nand2_1
XFILLER_28_524 vddd vssd sg13cmos5l_decap_8
X_4169_ _4169_/Y _4169_/A _6786_/B _6395_/A vddd vssd sg13cmos5l_nor3_1
XFILLER_24_730 vddd vssd sg13cmos5l_decap_8
XFILLER_23_21 vddd vssd sg13cmos5l_decap_8
XFILLER_32_2226 vddd vssd sg13cmos5l_decap_4
XFILLER_7_417 vddd vssd sg13cmos5l_decap_8
XFILLER_23_98 vddd vssd sg13cmos5l_decap_8
XFILLER_10_2568 vddd vssd sg13cmos5l_decap_8
XFILLER_30_1282 vddd vssd sg13cmos5l_decap_8
XFILLER_2_122 vddd vssd sg13cmos5l_decap_8
XFILLER_10_1889 vddd vssd sg13cmos5l_decap_4
Xtiedowns\[24\] dbus_in_left[4] vddd vssd sg13cmos5l_antennanp
XFILLER_19_502 vddd vssd sg13cmos5l_decap_4
XFILLER_0_14 vddd vssd sg13cmos5l_decap_8
XFILLER_19_1881 vddd vssd sg13cmos5l_decap_4
XFILLER_15_1701 vddd vssd sg13cmos5l_decap_8
XFILLER_9_56 vddd vssd sg13cmos5l_decap_8
XFILLER_15_2479 vddd vssd sg13cmos5l_decap_8
X_3540_ _5294_/C _5566_/A vddd vssd sg13cmos5l_inv_1
Xhold907 hold907/X _4952_/A vddd vssd sg13cmos5l_dlygate4sd3_1
Xhold918 _7304_/D _4962_/Y vddd vssd sg13cmos5l_dlygate4sd3_1
X_3471_ _3471_/Y _4540_/A vddd vssd sg13cmos5l_inv_1
X_5210_ _6177_/B _7266_/Q _7267_/Q _5242_/B vddd vssd sg13cmos5l_or3_1
Xhold929 _6425_/A _7162_/Q vddd vssd sg13cmos5l_dlygate4sd3_1
X_6190_ _6190_/Y _4114_/X _5234_/B _5218_/X vddd vssd sg13cmos5l_o21ai_1
XFILLER_26_2542 vddd vssd sg13cmos5l_decap_8
X_5141_ _5150_/C _5141_/A _5173_/B vddd vssd sg13cmos5l_nor2_1
XFILLER_9_1014 vddd vssd sg13cmos5l_decap_4
XFILLER_26_1830 vddd vssd sg13cmos5l_decap_8
X_5072_ _5072_/X _7292_/Q _5072_/B _5072_/C _5072_/D vddd vssd sg13cmos5l_or4_1
X_4023_ _4023_/Y _4020_/Y _4021_/Y _4022_/Y vddd vssd sg13cmos5l_o21ai_1
XFILLER_0_2213 vddd vssd sg13cmos5l_decap_8
XFILLER_20_2174 vddd vssd sg13cmos5l_decap_8
X_5974_ _5976_/B _5974_/A _5974_/B vddd vssd sg13cmos5l_and2_1
X_4925_ _4949_/A _4925_/A _4925_/B vddd vssd sg13cmos5l_and2_1
Xtiedowns\[8\] io_in[0] vddd vssd sg13cmos5l_antennanp
X_4856_ _4856_/Y _4832_/B _4856_/B vddd vssd sg13cmos5l_nand2b_1
X_3807_ _3810_/B _7109_/Q _4253_/A vddd vssd sg13cmos5l_nand2_1
X_6526_ _7215_/D _6526_/A1 _6528_/S _6525_/Y vddd vssd sg13cmos5l_a21oi_1
X_4787_ _4787_/Y _4787_/A1 _4815_/A _4786_/Y vddd vssd sg13cmos5l_o21ai_1
X_3738_ _3933_/A _3874_/C _3938_/A vddd vssd sg13cmos5l_or2_1
X_3669_ _3753_/B _4353_/A _4355_/A _3672_/S vddd vssd sg13cmos5l_mux2_1
X_6457_ _6457_/Y _6472_/A _6459_/B vddd vssd sg13cmos5l_nor2_1
X_5408_ _5414_/B _5416_/B _5408_/B vddd vssd sg13cmos5l_nand2_1
X_6388_ _6388_/Y _6388_/A _6388_/B vddd vssd sg13cmos5l_nand2_1
X_5339_ _5360_/C _5348_/B _7154_/Q vddd vssd sg13cmos5l_nand2b_1
XFILLER_25_2052 vddd vssd sg13cmos5l_decap_8
XFILLER_5_1434 vddd vssd sg13cmos5l_decap_4
XFILLER_29_833 vddd vssd sg13cmos5l_decap_8
XFILLER_18_21 vddd vssd sg13cmos5l_decap_8
X_7009_ _7009_/Q _7335_/CLK _7009_/D _6956_/Y vddd vssd sg13cmos5l_dfrbpq_1
XFILLER_18_98 vddd vssd sg13cmos5l_decap_8
XFILLER_19_1144 vddd vssd sg13cmos5l_decap_8
XFILLER_12_744 vddd vssd sg13cmos5l_decap_8
XFILLER_32_2089 vddd vssd sg13cmos5l_decap_8
Xwire145 _3654_/C wire146/X vddd vssd sg13cmos5l_buf_4
XFILLER_32_1366 vddd vssd sg13cmos5l_decap_8
XFILLER_4_932 vddd vssd sg13cmos5l_decap_8
XFILLER_4_965 vddd vssd sg13cmos5l_decap_8
XFILLER_15_7 vddd vssd sg13cmos5l_decap_8
XFILLER_21_2472 vddd vssd sg13cmos5l_decap_8
XFILLER_21_1771 vddd vssd sg13cmos5l_decap_8
XFILLER_1_1832 vddd vssd sg13cmos5l_decap_8
X_5690_ _5690_/Y _7202_/Q _5690_/B vddd vssd sg13cmos5l_nor2_1
X_4710_ _4710_/X _6813_/A _7009_/D vddd vssd sg13cmos5l_xor2_1
X_4641_ _4653_/B _4674_/A _4642_/B vddd vssd sg13cmos5l_nor2_1
X_4572_ _4572_/Y _4577_/A _4572_/B vddd vssd sg13cmos5l_xnor2_1
X_7360_ _7360_/Q _7386_/CLK _7360_/D _6874_/Y vddd vssd sg13cmos5l_dfrbpq_1
X_3523_ _5234_/A _3523_/A vddd vssd sg13cmos5l_inv_1
X_6311_ _6311_/Y hold819/X _6805_/B _6310_/Y vddd vssd sg13cmos5l_o21ai_1
Xhold715 _4965_/B _7378_/Q vddd vssd sg13cmos5l_dlygate4sd3_1
Xhold704 _4415_/C _4414_/Y vddd vssd sg13cmos5l_dlygate4sd3_1
X_7291_ _7291_/Q _7291_/CLK _7291_/D fanout376/X vddd vssd sg13cmos5l_dfrbpq_1
Xhold737 _7325_/D _4865_/Y vddd vssd sg13cmos5l_dlygate4sd3_1
Xhold726 _4412_/A _7353_/Q vddd vssd sg13cmos5l_dlygate4sd3_1
Xhold748 _5936_/A _6975_/Q vddd vssd sg13cmos5l_dlygate4sd3_1
X_6242_ _6242_/Y _6240_/Y _6242_/B vddd vssd sg13cmos5l_nand2b_1
Xhold759 _7363_/D _4341_/Y vddd vssd sg13cmos5l_dlygate4sd3_1
XFILLER_28_1969 vddd vssd sg13cmos5l_decap_8
X_6173_ _6173_/Y _4114_/X _5216_/C _5193_/C vddd vssd sg13cmos5l_a21oi_1
XFILLER_6_2433 vddd vssd sg13cmos5l_decap_8
Xoutbuffers\[55\] bandgap_ena _7057_/Q vddd vssd sg13cmos5l_buf_16
Xhold1404 _7152_/D _6407_/X vddd vssd sg13cmos5l_dlygate4sd3_1
Xhold1415 _6519_/A1 _5762_/A vddd vssd sg13cmos5l_dlygate4sd3_1
XFILLER_6_2466 vddd vssd sg13cmos5l_decap_8
X_5124_ _5166_/B _7265_/Q _7264_/Q vddd vssd sg13cmos5l_nand2b_1
Xhold1459 _6728_/A1 _3612_/Y vddd vssd sg13cmos5l_dlygate4sd3_1
Xhold1426 _7345_/D _4548_/X vddd vssd sg13cmos5l_dlygate4sd3_1
XFILLER_26_1693 vddd vssd sg13cmos5l_decap_8
X_5055_ _5239_/A _7270_/Q _7271_/Q vddd vssd sg13cmos5l_nand2b_1
Xhold1437 _6567_/A1 _6232_/B vddd vssd sg13cmos5l_dlygate4sd3_1
Xhold1448 _6376_/A _7137_/Q vddd vssd sg13cmos5l_dlygate4sd3_1
XFILLER_22_1568 vddd vssd sg13cmos5l_decap_8
X_4006_ _4008_/C _5208_/A wire90/X vddd vssd sg13cmos5l_nand2_1
XFILLER_0_2021 vddd vssd sg13cmos5l_decap_8
XFILLER_6_1776 vddd vssd sg13cmos5l_decap_8
XFILLER_0_1353 vddd vssd sg13cmos5l_decap_8
X_5957_ _5957_/Y _5970_/C _5956_/Y _5972_/A vddd vssd sg13cmos5l_o21ai_1
X_4908_ wire18/A _4920_/A _4908_/B _4908_/C vddd vssd sg13cmos5l_nor3_1
XFILLER_21_574 vddd vssd sg13cmos5l_decap_8
XFILLER_16_1339 vddd vssd sg13cmos5l_decap_8
X_5888_ _5889_/B _5888_/A _5901_/D vddd vssd sg13cmos5l_nor2_1
X_4839_ _4839_/Y hold845/A sram_odata[6] _4838_/Y vddd vssd sg13cmos5l_a21oi_1
XFILLER_5_707 vddd vssd sg13cmos5l_decap_8
Xclkbuf_3_7_0_clk_regs clkbuf_3_7_0_clk_regs/X clkbuf_0_clk_regs/X vddd vssd sg13cmos5l_buf_8
X_6509_ _6509_/Y _6532_/A _6512_/B vddd vssd sg13cmos5l_nand2_1
XFILLER_20_77 vddd vssd sg13cmos5l_decap_8
XFILLER_27_2169 vddd vssd sg13cmos5l_decap_8
XFILLER_29_42 vddd vssd sg13cmos5l_decap_8
XFILLER_0_467 vddd vssd sg13cmos5l_decap_8
XFILLER_21_1001 vddd vssd sg13cmos5l_decap_8
XFILLER_29_652 vddd vssd sg13cmos5l_decap_8
XFILLER_28_151 vddd vssd sg13cmos5l_decap_8
XFILLER_16_379 vddd vssd sg13cmos5l_decap_8
XFILLER_32_1130 vddd vssd sg13cmos5l_decap_8
XFILLER_16_2596 vddd vssd sg13cmos5l_decap_8
XANTENNA_6 SDI vddd vssd sg13cmos5l_antennanp
XFILLER_10_2162 vddd vssd sg13cmos5l_decap_8
XFILLER_23_2545 vddd vssd sg13cmos5l_decap_8
X_6860_ _6860_/Y _6961_/A _6964_/B_N vddd vssd sg13cmos5l_nor2b_1
XFILLER_1_2396 vddd vssd sg13cmos5l_decap_8
XFILLER_23_817 vddd vssd sg13cmos5l_decap_8
XFILLER_1_1695 vddd vssd sg13cmos5l_decap_4
X_6791_ _7088_/D _6727_/A _6801_/B hold714/X vddd vssd sg13cmos5l_a21oi_1
X_5811_ _5811_/Y _5811_/A _5811_/B vddd vssd sg13cmos5l_nor2_1
X_5742_ _5743_/B _5294_/C _5758_/A _5764_/B _5828_/B2 _5752_/B vddd vssd sg13cmos5l_a221oi_1
X_5673_ _5673_/Y _5673_/A _7201_/Q _5673_/C vddd vssd sg13cmos5l_nor3_1
XFILLER_15_2073 vddd vssd sg13cmos5l_decap_4
X_4624_ _4624_/Y _4623_/Y _4647_/B vddd vssd sg13cmos5l_nand2b_1
Xhold501 _7015_/D hold501/A vddd vssd sg13cmos5l_dlygate4sd3_1
X_7343_ _7343_/Q _7343_/CLK _7343_/D _6857_/Y vddd vssd sg13cmos5l_dfrbpq_1
X_4555_ _4556_/B _4578_/A _5623_/A vddd vssd sg13cmos5l_nor2b_1
Xhold534 _4655_/B _6991_/Q vddd vssd sg13cmos5l_dlygate4sd3_1
Xhold512 _4540_/A _7016_/Q vddd vssd sg13cmos5l_dlygate4sd3_1
XFILLER_28_2412 vddd vssd sg13cmos5l_decap_8
Xhold523 _6982_/D _3632_/Y vddd vssd sg13cmos5l_dlygate4sd3_1
X_3506_ _3506_/Y _7142_/Q vddd vssd sg13cmos5l_inv_1
Xhold545 _6986_/D _3487_/Y vddd vssd sg13cmos5l_dlygate4sd3_1
X_7274_ _7274_/Q _7276_/CLK _7274_/D fanout383/X vddd vssd sg13cmos5l_dfrbpq_1
X_4486_ _4493_/A _4486_/A _4486_/B _4486_/C vddd vssd sg13cmos5l_nor3_1
Xhold567 hold567/X _4091_/Y vddd vssd sg13cmos5l_dlygate4sd3_1
Xhold556 _6812_/A _6989_/Q vddd vssd sg13cmos5l_dlygate4sd3_1
Xhold578 hold578/X _3791_/Y vddd vssd sg13cmos5l_dlygate4sd3_1
XFILLER_28_2489 vddd vssd sg13cmos5l_decap_8
Xhold589 _7394_/D _3817_/Y vddd vssd sg13cmos5l_dlygate4sd3_1
X_6225_ _6225_/X _6225_/A _7236_/Q vddd vssd sg13cmos5l_or2_1
X_6156_ _6156_/Y _6156_/A _6156_/B vddd vssd sg13cmos5l_nor2_1
Xhold1223 _6734_/A1 _7055_/Q vddd vssd sg13cmos5l_dlygate4sd3_1
Xhold1201 _3518_/A _7288_/Q vddd vssd sg13cmos5l_dlygate4sd3_1
XFILLER_22_2055 vddd vssd sg13cmos5l_decap_8
Xhold1234 _7060_/D _6744_/Y vddd vssd sg13cmos5l_dlygate4sd3_1
X_5107_ _5176_/B _5204_/A _5204_/B vddd vssd sg13cmos5l_nand2_1
XFILLER_6_1540 vddd vssd sg13cmos5l_decap_4
Xhold1212 _6613_/A0 _7264_/Q vddd vssd sg13cmos5l_dlygate4sd3_1
XFILLER_6_2274 vddd vssd sg13cmos5l_decap_4
Xhold1256 _6735_/A1 _7056_/Q vddd vssd sg13cmos5l_dlygate4sd3_1
Xhold1245 _7026_/D _6693_/Y vddd vssd sg13cmos5l_dlygate4sd3_1
Xhold1267 _6721_/A0 _7046_/Q vddd vssd sg13cmos5l_dlygate4sd3_1
X_6087_ _6087_/Y _6267_/A1 _5134_/B _6085_/Y _6086_/Y _6088_/B vddd vssd sg13cmos5l_a221oi_1
XFILLER_6_1562 vddd vssd sg13cmos5l_decap_8
Xhold1278 _6444_/A1 _5475_/B vddd vssd sg13cmos5l_dlygate4sd3_1
Xhold1289 _3588_/A _7226_/Q vddd vssd sg13cmos5l_dlygate4sd3_1
X_5038_ _5222_/A _7243_/Q _7242_/Q vddd vssd sg13cmos5l_nand2b_1
XFILLER_25_121 vddd vssd sg13cmos5l_decap_8
XFILLER_14_806 vddd vssd sg13cmos5l_decap_8
XFILLER_0_1150 vddd vssd sg13cmos5l_decap_4
XFILLER_25_187 vddd vssd sg13cmos5l_decap_8
X_6989_ _6989_/Q _7335_/CLK _6989_/D _6936_/Y vddd vssd sg13cmos5l_dfrbpq_1
XFILLER_0_1194 vddd vssd sg13cmos5l_decap_8
XFILLER_15_77 vddd vssd sg13cmos5l_decap_8
XFILLER_31_65 vddd vssd sg13cmos5l_decap_8
XFILLER_27_1265 vddd vssd sg13cmos5l_decap_8
XFILLER_0_242 vddd vssd sg13cmos5l_decap_8
XFILLER_1_765 vddd vssd sg13cmos5l_decap_8
XFILLER_23_1107 vddd vssd sg13cmos5l_decap_8
XFILLER_17_666 vddd vssd sg13cmos5l_decap_8
XFILLER_32_669 vddd vssd sg13cmos5l_decap_8
XFILLER_31_135 vddd vssd sg13cmos5l_decap_8
XFILLER_16_2382 vddd vssd sg13cmos5l_decap_4
XFILLER_8_320 vddd vssd sg13cmos5l_decap_8
XFILLER_8_375 vddd vssd sg13cmos5l_decap_8
XFILLER_9_898 vddd vssd sg13cmos5l_decap_8
XFILLER_12_1578 vddd vssd sg13cmos5l_decap_8
X_4340_ _4340_/Y _4325_/A _4321_/Y _4325_/B vddd vssd sg13cmos5l_a21oi_1
XFILLER_4_570 vddd vssd sg13cmos5l_decap_8
X_4271_ _4303_/B _5279_/A _4315_/A vddd vssd sg13cmos5l_nor2b_1
XFILLER_10_1291 vddd vssd sg13cmos5l_decap_8
XFILLER_7_2550 vddd vssd sg13cmos5l_decap_8
X_6010_ _6010_/Y _7336_/Q _7301_/Q _6057_/B vddd vssd sg13cmos5l_a21oi_1
X_6912_ _6912_/Y _6914_/A _6913_/B_N vddd vssd sg13cmos5l_nor2b_1
Xoutbuffers\[18\] clk_out outbuffers\[18\]/A vddd vssd sg13cmos5l_buf_16
XFILLER_23_614 vddd vssd sg13cmos5l_decap_8
X_6843_ _6843_/Y _6913_/A _6913_/B_N vddd vssd sg13cmos5l_nor2b_1
XFILLER_22_113 vddd vssd sg13cmos5l_decap_8
X_6774_ _7079_/D _6285_/B _6776_/S _6773_/Y vddd vssd sg13cmos5l_o21ai_1
X_3986_ _3986_/Y _3508_/Y wire81/X _3842_/B vddd vssd sg13cmos5l_a21oi_1
XFILLER_22_179 vddd vssd sg13cmos5l_decap_8
XFILLER_17_1456 vddd vssd sg13cmos5l_decap_8
X_5725_ _5729_/A _7208_/Q _5724_/Y _5723_/Y vddd vssd sg13cmos5l_o21ai_1
X_5656_ _5669_/A _5673_/A _5656_/B vddd vssd sg13cmos5l_nor2_1
X_4607_ _4607_/Y _3497_/Y _4595_/X _4606_/Y vddd vssd sg13cmos5l_a21oi_1
X_5587_ _5588_/C _5502_/A _5564_/Y _5572_/Y _5530_/A _5586_/Y vddd vssd sg13cmos5l_a221oi_1
X_4538_ _4539_/C _4531_/A _4524_/Y _4537_/Y vddd vssd sg13cmos5l_a21oi_1
X_7326_ _7326_/Q _7401_/CLK _7326_/D _6840_/Y vddd vssd sg13cmos5l_dfrbpq_1
XFILLER_28_2264 vddd vssd sg13cmos5l_decap_8
X_4469_ _4625_/A _4674_/A _4674_/B vddd vssd sg13cmos5l_nor2_1
X_7257_ _7257_/Q _7258_/CLK _7257_/D fanout382/X vddd vssd sg13cmos5l_dfrbpq_1
X_6208_ _6208_/X _5193_/B _6207_/X _6206_/Y vddd vssd sg13cmos5l_a21o_1
XFILLER_8_1613 vddd vssd sg13cmos5l_decap_4
XFILLER_8_1635 vddd vssd sg13cmos5l_decap_8
XFILLER_28_1574 vddd vssd sg13cmos5l_decap_8
X_7188_ _7188_/Q _7231_/CLK _7188_/D fanout363/X vddd vssd sg13cmos5l_dfrbpq_1
Xhold1031 _6741_/B1 _6740_/Y vddd vssd sg13cmos5l_dlygate4sd3_1
X_6139_ _6139_/Y _7296_/Q _3629_/Y _5193_/B vddd vssd sg13cmos5l_a21oi_1
XFILLER_8_1679 vddd vssd sg13cmos5l_decap_8
Xhold1020 _7219_/D _6533_/Y vddd vssd sg13cmos5l_dlygate4sd3_1
Xhold1042 _6686_/A0 _7322_/Q vddd vssd sg13cmos5l_dlygate4sd3_1
Xhold1075 _6705_/A0 _7034_/Q vddd vssd sg13cmos5l_dlygate4sd3_1
Xhold1064 hold482/A hold1510/X vddd vssd sg13cmos5l_dlygate4sd3_1
Xhold1053 _3599_/A _7110_/Q vddd vssd sg13cmos5l_dlygate4sd3_1
Xhold1097 _7032_/D _6701_/X vddd vssd sg13cmos5l_dlygate4sd3_1
Xhold1086 _7279_/D _6637_/Y vddd vssd sg13cmos5l_dlygate4sd3_1
XFILLER_26_21 vddd vssd sg13cmos5l_decap_8
XFILLER_27_997 vddd vssd sg13cmos5l_decap_8
XFILLER_26_76 vddd vssd sg13cmos5l_decap_8
XFILLER_14_636 vddd vssd sg13cmos5l_decap_8
Xclkbuf_leaf_12_SCK_regs _7200_/CLK clkload5/A vddd vssd sg13cmos5l_buf_8
XFILLER_13_2555 vddd vssd sg13cmos5l_decap_8
XFILLER_10_853 vddd vssd sg13cmos5l_decap_8
XFILLER_13_1876 vddd vssd sg13cmos5l_decap_8
XFILLER_29_2028 vddd vssd sg13cmos5l_decap_8
Xtiedowns\[54\] mask_rev_in[10] vddd vssd sg13cmos5l_antennanp
XFILLER_3_14 vddd vssd sg13cmos5l_decap_8
XFILLER_3_58 vddd vssd sg13cmos5l_decap_8
XFILLER_7_1178 vddd vssd sg13cmos5l_decap_8
XFILLER_24_1972 vddd vssd sg13cmos5l_decap_8
XFILLER_18_931 vddd vssd sg13cmos5l_decap_8
XFILLER_18_2444 vddd vssd sg13cmos5l_decap_8
X_3840_ _3840_/Y _6711_/A _3838_/Y _3839_/Y vddd vssd sg13cmos5l_a21oi_1
Xoutbuffers\[108\] dbus_out[11] _5620_/Y vddd vssd sg13cmos5l_buf_16
X_3771_ _3771_/Y _7038_/Q _6696_/A _4189_/B1 vddd vssd sg13cmos5l_a21oi_1
X_5510_ _5511_/B _5294_/C _5523_/A _5529_/B _5828_/B2 _5518_/B vddd vssd sg13cmos5l_a221oi_1
X_6490_ _6496_/B _6490_/A _6545_/B vddd vssd sg13cmos5l_nand2_1
X_5441_ _5441_/Y _5442_/A _5441_/B _5441_/C vddd vssd sg13cmos5l_nor3_1
X_5372_ _5383_/B _5372_/A _5384_/C vddd vssd sg13cmos5l_nor2_1
XFILLER_29_2562 vddd vssd sg13cmos5l_decap_8
X_7111_ _7111_/Q _7111_/CLK _7111_/D _6933_/B_N vddd vssd sg13cmos5l_dfrbpq_1
X_4323_ _4346_/A _4348_/A _4357_/B _4323_/C vddd vssd sg13cmos5l_and3_1
Xfanout107 _6696_/A _3706_/Y vddd vssd sg13cmos5l_buf_1
XFILLER_25_2426 vddd vssd sg13cmos5l_decap_8
X_7042_ _7042_/Q _7071_/CLK _7042_/D _6835_/B_N vddd vssd sg13cmos5l_dfrbpq_1
Xfanout129 _4546_/A hold1393/X vddd vssd sg13cmos5l_buf_1
Xfanout118 _6753_/B fanout122/X vddd vssd sg13cmos5l_buf_1
X_4254_ _4254_/Y _3601_/Y _6329_/A _4253_/Y vddd vssd sg13cmos5l_o21ai_1
X_4185_ _4193_/A _7282_/Q _6640_/A vddd vssd sg13cmos5l_nand2_1
XFILLER_23_2183 vddd vssd sg13cmos5l_decap_4
XFILLER_24_956 vddd vssd sg13cmos5l_decap_8
XFILLER_24_923 vddd vssd sg13cmos5l_decap_8
XFILLER_23_400 vddd vssd sg13cmos5l_decap_4
XFILLER_19_1518 vddd vssd sg13cmos5l_decap_8
X_6826_ _6826_/Y _6913_/A _6840_/B_N vddd vssd sg13cmos5l_nor2b_1
X_6757_ _6757_/X _6767_/A _6757_/A1 _6761_/S vddd vssd sg13cmos5l_mux2_1
XFILLER_17_1231 vddd vssd sg13cmos5l_decap_8
X_5708_ _5727_/B _7206_/Q _7207_/Q vddd vssd sg13cmos5l_nor2_1
X_3969_ _6402_/A _4057_/B _6395_/B vddd vssd sg13cmos5l_nor2_1
X_6688_ _6688_/Y _6688_/A _6695_/S vddd vssd sg13cmos5l_nand2_1
X_5639_ _5640_/B _5627_/Y _5628_/Y _5638_/A vddd vssd sg13cmos5l_o21ai_1
XFILLER_12_56 vddd vssd sg13cmos5l_decap_8
XFILLER_30_1486 vddd vssd sg13cmos5l_decap_8
XFILLER_8_2111 vddd vssd sg13cmos5l_decap_4
X_7309_ _7309_/Q _7328_/CLK _7309_/D _6831_/Y vddd vssd sg13cmos5l_dfrbpq_1
XFILLER_28_2072 vddd vssd sg13cmos5l_decap_8
XFILLER_28_1360 vddd vssd sg13cmos5l_decap_8
XFILLER_19_706 vddd vssd sg13cmos5l_decap_8
XFILLER_8_1476 vddd vssd sg13cmos5l_decap_8
XFILLER_18_205 vddd vssd sg13cmos5l_decap_4
XFILLER_18_238 vddd vssd sg13cmos5l_decap_8
XFILLER_15_912 vddd vssd sg13cmos5l_decap_8
XFILLER_18_1017 vddd vssd sg13cmos5l_decap_4
XFILLER_4_2520 vddd vssd sg13cmos5l_decap_8
XFILLER_24_2481 vddd vssd sg13cmos5l_decap_8
X_5990_ _5990_/Y _3492_/Y _4339_/C _4330_/B vddd vssd sg13cmos5l_a21oi_1
XFILLER_18_783 vddd vssd sg13cmos5l_decap_8
X_4941_ _4941_/Y _4943_/B _4940_/Y _4939_/Y vddd vssd sg13cmos5l_o21ai_1
X_4872_ _4872_/X _4940_/A _7143_/Q vddd vssd sg13cmos5l_or2_1
X_3823_ _6156_/A dbus_in_left[4] dbus_in_right[4] vddd vssd sg13cmos5l_or2_1
X_6611_ _7262_/D _6635_/A1 _6614_/S hold975/X vddd vssd sg13cmos5l_a21oi_1
XFILLER_32_296 vddd vssd sg13cmos5l_decap_8
XFILLER_20_425 vddd vssd sg13cmos5l_decap_8
XFILLER_18_1562 vddd vssd sg13cmos5l_decap_8
XFILLER_14_1415 vddd vssd sg13cmos5l_decap_4
X_6542_ _7224_/D _6558_/A _6542_/A1 _6543_/B vddd vssd sg13cmos5l_mux2_1
X_3754_ _3758_/A _3755_/A _3925_/B _4179_/A1 vddd vssd sg13cmos5l_a21oi_1
XFILLER_31_2485 vddd vssd sg13cmos5l_decap_8
X_3685_ _6762_/A _3940_/A _3938_/A vddd vssd sg13cmos5l_or2_1
X_6473_ _7188_/D _6473_/A1 _6474_/S _6472_/Y vddd vssd sg13cmos5l_a21oi_1
XFILLER_9_492 vddd vssd sg13cmos5l_decap_8
Xoutbuffers\[85\] io_out[0] _6011_/Y vddd vssd sg13cmos5l_buf_16
X_5424_ _5437_/A _7168_/Q _5424_/B vddd vssd sg13cmos5l_nor2_1
XFILLER_12_1161 vddd vssd sg13cmos5l_decap_4
X_5355_ _5355_/Y _5530_/A _5345_/Y _5346_/X _5526_/A vddd vssd sg13cmos5l_a22oi_1
X_5286_ _5286_/Y _5284_/Y _5285_/Y _7148_/Q vddd vssd sg13cmos5l_o21ai_1
X_4306_ _4306_/X _4287_/B _4304_/B _4293_/C vddd vssd sg13cmos5l_a21o_1
XFILLER_9_2464 vddd vssd sg13cmos5l_decap_8
X_7025_ _7025_/Q _7199_/CLK _7025_/D fanout369/X vddd vssd sg13cmos5l_dfrbpq_1
XFILLER_9_1774 vddd vssd sg13cmos5l_decap_8
X_4237_ _4240_/A _4234_/Y _4235_/X _4236_/Y vddd vssd sg13cmos5l_o21ai_1
XFILLER_3_2030 vddd vssd sg13cmos5l_decap_8
X_4168_ _4168_/Y _7105_/Q _4253_/A _4165_/Y _4166_/Y _4167_/X vddd vssd sg13cmos5l_a221oi_1
X_4099_ _4099_/X _4095_/Y _4096_/Y _4098_/Y vddd vssd sg13cmos5l_a21o_1
XFILLER_3_2085 vddd vssd sg13cmos5l_decap_4
XFILLER_3_1384 vddd vssd sg13cmos5l_decap_8
XFILLER_12_904 vddd vssd sg13cmos5l_decap_8
XFILLER_19_1348 vddd vssd sg13cmos5l_decap_8
X_6809_ _6809_/X _6809_/A vddd vssd sg13cmos5l_buf_1
XFILLER_12_948 vddd vssd sg13cmos5l_decap_8
XFILLER_32_1548 vddd vssd sg13cmos5l_decap_8
XFILLER_23_77 vddd vssd sg13cmos5l_decap_8
XFILLER_14_1971 vddd vssd sg13cmos5l_decap_4
XFILLER_10_2547 vddd vssd sg13cmos5l_decap_8
XFILLER_10_1879 vddd vssd sg13cmos5l_decap_4
XFILLER_8_1295 vddd vssd sg13cmos5l_decap_8
Xtiedowns\[17\] io_in[9] vddd vssd sg13cmos5l_antennanp
XFILLER_19_2583 vddd vssd sg13cmos5l_decap_8
XFILLER_9_35 vddd vssd sg13cmos5l_decap_8
XFILLER_19_1860 vddd vssd sg13cmos5l_decap_8
XFILLER_15_2458 vddd vssd sg13cmos5l_decap_8
XFILLER_11_981 vddd vssd sg13cmos5l_decap_8
Xhold919 hold919/X _7281_/Q vddd vssd sg13cmos5l_dlygate4sd3_1
Xhold908 _7307_/D _4953_/Y vddd vssd sg13cmos5l_dlygate4sd3_1
XFILLER_7_985 vddd vssd sg13cmos5l_decap_8
X_3470_ _3470_/Y _4514_/A vddd vssd sg13cmos5l_inv_1
XFILLER_26_2521 vddd vssd sg13cmos5l_decap_8
X_5140_ _5150_/B _5231_/A _5170_/B vddd vssd sg13cmos5l_nor2_1
XFILLER_26_2598 vddd vssd sg13cmos5l_decap_8
XFILLER_22_2429 vddd vssd sg13cmos5l_decap_8
XFILLER_2_690 vddd vssd sg13cmos5l_decap_8
XFILLER_6_1914 vddd vssd sg13cmos5l_decap_4
X_5071_ _5072_/D _5071_/A _6037_/B _5071_/C vddd vssd sg13cmos5l_nand3_1
XFILLER_9_1059 vddd vssd sg13cmos5l_decap_8
XFILLER_26_1864 vddd vssd sg13cmos5l_decap_4
X_4022_ _4022_/Y _5204_/A _6576_/A vddd vssd sg13cmos5l_nand2_1
X_6904__469 _7391_/CLK _7164_/CLK vddd vssd sg13cmos5l_inv_1
XFILLER_0_2203 vddd vssd sg13cmos5l_decap_4
XFILLER_25_539 vddd vssd sg13cmos5l_decap_4
X_5973_ _5973_/Y _5871_/A _5970_/Y _5972_/Y vddd vssd sg13cmos5l_a21oi_1
X_4924_ _4925_/B _4952_/A _4952_/B vddd vssd sg13cmos5l_and2_1
XFILLER_21_734 vddd vssd sg13cmos5l_decap_8
X_4855_ _4855_/Y _4832_/Y _4854_/Y hold611/X vddd vssd sg13cmos5l_o21ai_1
X_3806_ _3810_/A _7117_/Q _6329_/A _3805_/Y vddd vssd sg13cmos5l_o21ai_1
X_4786_ _4786_/Y _4815_/A _4786_/B vddd vssd sg13cmos5l_nand2_1
X_3737_ _3934_/A _3874_/C _3938_/A vddd vssd sg13cmos5l_nor2_1
X_6525_ _6525_/Y _6532_/A _6528_/S vddd vssd sg13cmos5l_nor2_1
XFILLER_14_1245 vddd vssd sg13cmos5l_decap_8
X_3668_ _3753_/A _4348_/A _4353_/A _3672_/S vddd vssd sg13cmos5l_mux2_1
X_6456_ _6456_/X _6464_/A _6456_/A1 _6459_/B vddd vssd sg13cmos5l_mux2_1
X_6387_ _6387_/Y _6801_/A _6388_/B hold769/X vddd vssd sg13cmos5l_o21ai_1
X_5407_ _5414_/A _5403_/Y _5406_/Y _7164_/Q vddd vssd sg13cmos5l_o21ai_1
X_3599_ _3599_/Y _3599_/A vddd vssd sg13cmos5l_inv_1
XFILLER_27_1639 vddd vssd sg13cmos5l_decap_8
XFILLER_25_2020 vddd vssd sg13cmos5l_decap_8
XFILLER_0_616 vddd vssd sg13cmos5l_decap_8
X_5338_ _5361_/A _7154_/Q _5348_/B _5360_/B vddd vssd sg13cmos5l_nor3_1
XFILLER_29_801 vddd vssd sg13cmos5l_decap_8
XFILLER_25_2086 vddd vssd sg13cmos5l_decap_8
X_5269_ _5270_/D _6266_/A _5269_/B _6276_/B _5269_/D vddd vssd sg13cmos5l_nand4_1
X_7008_ _7008_/Q _7338_/CLK _7008_/D _6955_/Y vddd vssd sg13cmos5l_dfrbpq_1
XFILLER_28_322 vddd vssd sg13cmos5l_decap_8
XFILLER_21_1249 vddd vssd sg13cmos5l_decap_8
XFILLER_18_77 vddd vssd sg13cmos5l_decap_8
XFILLER_16_528 vddd vssd sg13cmos5l_decap_4
XFILLER_24_572 vddd vssd sg13cmos5l_decap_8
XFILLER_12_701 vddd vssd sg13cmos5l_decap_8
XFILLER_19_1167 vddd vssd sg13cmos5l_decap_8
XFILLER_11_200 vddd vssd sg13cmos5l_decap_4
XFILLER_32_1345 vddd vssd sg13cmos5l_decap_8
Xwire146 wire146/X _3652_/Y vddd vssd sg13cmos5l_buf_4
XFILLER_14_2491 vddd vssd sg13cmos5l_decap_8
Xwire157 _4267_/B _3760_/Y vddd vssd sg13cmos5l_buf_4
XFILLER_11_288 vddd vssd sg13cmos5l_decap_8
XFILLER_10_2344 vddd vssd sg13cmos5l_decap_8
Xclkbuf_3_1_0_SCK_regs clkload3/A clkbuf_0_SCK_regs/X vddd vssd sg13cmos5l_buf_8
XFILLER_3_465 vddd vssd sg13cmos5l_decap_8
XFILLER_1_0 vddd vssd sg13cmos5l_decap_8
XFILLER_4_988 vddd vssd sg13cmos5l_decap_4
Xfanout290 _5613_/A _7192_/Q vddd vssd sg13cmos5l_buf_1
XFILLER_21_2451 vddd vssd sg13cmos5l_decap_8
X_4640_ _4640_/Y _4640_/A _4640_/B vddd vssd sg13cmos5l_nand2_1
X_4571_ _4582_/B _4577_/A _4572_/B vddd vssd sg13cmos5l_nor2_1
X_6310_ _6310_/Y _6344_/A _6805_/B vddd vssd sg13cmos5l_nand2_1
X_3522_ _3522_/Y _7298_/Q vddd vssd sg13cmos5l_inv_1
X_7290_ _7290_/Q _7301_/CLK _7290_/D fanout375/X vddd vssd sg13cmos5l_dfrbpq_1
Xhold716 hold716/X _4284_/Y vddd vssd sg13cmos5l_dlygate4sd3_1
Xhold705 _7352_/D _4415_/Y vddd vssd sg13cmos5l_dlygate4sd3_1
Xhold727 _4413_/C _4412_/Y vddd vssd sg13cmos5l_dlygate4sd3_1
Xhold749 _5937_/C _5936_/Y vddd vssd sg13cmos5l_dlygate4sd3_1
X_6241_ _6242_/B _4115_/B _5253_/C _5251_/A vddd vssd sg13cmos5l_a21oi_1
Xhold738 _3530_/A _7095_/Q vddd vssd sg13cmos5l_dlygate4sd3_1
X_6172_ _6172_/Y _5214_/A _6170_/X _6171_/Y vddd vssd sg13cmos5l_o21ai_1
X_5123_ _5172_/B _7265_/Q _7264_/Q vddd vssd sg13cmos5l_nor2b_1
XFILLER_26_2395 vddd vssd sg13cmos5l_decap_8
Xhold1405 hold1405/X _7197_/Q vddd vssd sg13cmos5l_dlygate4sd3_1
Xhold1416 _7212_/D _6519_/X vddd vssd sg13cmos5l_dlygate4sd3_1
Xoutbuffers\[48\] bandgap_trim[9] _6291_/Y vddd vssd sg13cmos5l_buf_16
Xhold1438 _6737_/A _7057_/Q vddd vssd sg13cmos5l_dlygate4sd3_1
XFILLER_29_119 vddd vssd sg13cmos5l_decap_8
Xhold1427 hold1427/X _7169_/Q vddd vssd sg13cmos5l_dlygate4sd3_1
XFILLER_6_1744 vddd vssd sg13cmos5l_decap_8
X_5054_ _6041_/S _5208_/A _5209_/B _5242_/A vddd vssd sg13cmos5l_nor3_1
Xhold1449 _6377_/B1 _6376_/Y vddd vssd sg13cmos5l_dlygate4sd3_1
X_4005_ _4008_/B _5223_/A wire91/X vddd vssd sg13cmos5l_nand2_1
XFILLER_22_1547 vddd vssd sg13cmos5l_decap_8
XFILLER_26_826 vddd vssd sg13cmos5l_decap_4
X_5956_ _5956_/Y _5956_/A _7322_/Q vddd vssd sg13cmos5l_nor2_1
XFILLER_0_1398 vddd vssd sg13cmos5l_decap_8
X_4907_ _4908_/C _4916_/B _4913_/A vddd vssd sg13cmos5l_nand2_1
X_5887_ _5889_/A _5901_/A _7231_/Q vddd vssd sg13cmos5l_nor2b_1
X_4838_ _4838_/Y _3654_/B _4837_/Y hold845/A vddd vssd sg13cmos5l_a21oi_1
X_4769_ _4769_/Y _4769_/A1 _4763_/Y _4768_/Y vddd vssd sg13cmos5l_o21ai_1
XFILLER_4_207 vddd vssd sg13cmos5l_decap_8
X_6508_ _7206_/D _6540_/A1 _6512_/B hold856/X vddd vssd sg13cmos5l_a21oi_1
XFILLER_20_56 vddd vssd sg13cmos5l_decap_8
Xclkbuf_leaf_37_SCK_regs _7210_/CLK clkload3/A vddd vssd sg13cmos5l_buf_8
X_6439_ _6439_/Y _6439_/A _6444_/S vddd vssd sg13cmos5l_nand2_1
XFILLER_0_446 vddd vssd sg13cmos5l_decap_8
XFILLER_29_21 vddd vssd sg13cmos5l_decap_8
XFILLER_29_98 vddd vssd sg13cmos5l_decap_8
XFILLER_16_314 vddd vssd sg13cmos5l_decap_8
XFILLER_32_829 vddd vssd sg13cmos5l_decap_8
XFILLER_16_2575 vddd vssd sg13cmos5l_decap_8
XFILLER_16_1863 vddd vssd sg13cmos5l_decap_8
XFILLER_32_1186 vddd vssd sg13cmos5l_decap_8
XANTENNA_7 SDI vddd vssd sg13cmos5l_antennanp
XFILLER_23_2524 vddd vssd sg13cmos5l_decap_8
XFILLER_23_1834 vddd vssd sg13cmos5l_decap_8
XFILLER_0_980 vddd vssd sg13cmos5l_decap_8
X_6790_ _6790_/Y _6790_/A _6801_/B vddd vssd sg13cmos5l_nor2_1
X_5810_ _5811_/B _5804_/Y _5807_/Y _5809_/Y vddd vssd sg13cmos5l_a21oi_1
X_5741_ _5764_/B _7211_/Q _7210_/Q vddd vssd sg13cmos5l_nor2b_1
XFILLER_31_862 vddd vssd sg13cmos5l_decap_4
XFILLER_30_2539 vddd vssd sg13cmos5l_decap_8
X_5672_ _5672_/X _6230_/A _5672_/B vddd vssd sg13cmos5l_and2_1
X_4623_ _4623_/Y _4668_/A _4619_/Y _4622_/Y vddd vssd sg13cmos5l_a21oi_1
X_4554_ _4554_/Y _4550_/Y _4553_/Y _4806_/A vddd vssd sg13cmos5l_o21ai_1
X_7342_ _7342_/Q _7342_/CLK _7342_/D _6856_/Y vddd vssd sg13cmos5l_dfrbpq_1
Xhold502 _7010_/D hold502/A vddd vssd sg13cmos5l_dlygate4sd3_1
Xhold513 _7017_/D _3471_/Y vddd vssd sg13cmos5l_dlygate4sd3_1
Xhold535 _6992_/D _3483_/Y vddd vssd sg13cmos5l_dlygate4sd3_1
Xhold524 _4514_/B _6997_/Q vddd vssd sg13cmos5l_dlygate4sd3_1
X_7273_ _7273_/Q _7273_/CLK _7273_/D fanout384/X vddd vssd sg13cmos5l_dfrbpq_1
X_3505_ _3505_/Y _3505_/A vddd vssd sg13cmos5l_inv_1
Xhold546 _4677_/B _6990_/Q vddd vssd sg13cmos5l_dlygate4sd3_1
X_4485_ _4486_/C _4792_/A _4485_/B vddd vssd sg13cmos5l_nand2_1
Xhold557 _6990_/D _6812_/X vddd vssd sg13cmos5l_dlygate4sd3_1
Xhold579 _7395_/D _3792_/Y vddd vssd sg13cmos5l_dlygate4sd3_1
Xhold568 _7390_/D _4181_/Y vddd vssd sg13cmos5l_dlygate4sd3_1
X_6224_ _6224_/X _6224_/A _6232_/B vddd vssd sg13cmos5l_or2_1
XFILLER_8_2529 vddd vssd sg13cmos5l_decap_8
XFILLER_28_2468 vddd vssd sg13cmos5l_decap_8
X_6155_ _6155_/Y _6152_/Y _6153_/Y _6156_/B vddd vssd sg13cmos5l_o21ai_1
Xhold1224 _7055_/D _6734_/X vddd vssd sg13cmos5l_dlygate4sd3_1
Xhold1202 _6651_/A1 _5211_/A vddd vssd sg13cmos5l_dlygate4sd3_1
X_6086_ _6086_/Y _6037_/A _5132_/B _5134_/B vddd vssd sg13cmos5l_a21oi_1
X_5106_ _5132_/A _7250_/Q _7251_/Q _5145_/B vddd vssd sg13cmos5l_nor3_1
Xhold1213 _7264_/D _6613_/X vddd vssd sg13cmos5l_dlygate4sd3_1
Xhold1257 _7056_/D _6735_/X vddd vssd sg13cmos5l_dlygate4sd3_1
Xhold1246 _6745_/A0 _7061_/Q vddd vssd sg13cmos5l_dlygate4sd3_1
Xhold1235 _3571_/A _7203_/Q vddd vssd sg13cmos5l_dlygate4sd3_1
X_5037_ _5042_/B _5037_/A vddd vssd sg13cmos5l_inv_1
XFILLER_26_612 vddd vssd sg13cmos5l_decap_8
Xhold1268 _7046_/D _6721_/X vddd vssd sg13cmos5l_dlygate4sd3_1
Xhold1279 _7173_/D _6444_/X vddd vssd sg13cmos5l_dlygate4sd3_1
XFILLER_25_100 vddd vssd sg13cmos5l_decap_8
XFILLER_26_689 vddd vssd sg13cmos5l_decap_4
XFILLER_15_56 vddd vssd sg13cmos5l_decap_8
X_6988_ _6988_/Q _7335_/CLK _6988_/D _6935_/Y vddd vssd sg13cmos5l_dfrbpq_1
X_5939_ _5939_/Y _5939_/A _5939_/B vddd vssd sg13cmos5l_nor2_1
XFILLER_16_1126 vddd vssd sg13cmos5l_decap_8
XFILLER_31_44 vddd vssd sg13cmos5l_decap_8
XFILLER_29_1509 vddd vssd sg13cmos5l_decap_8
XFILLER_0_298 vddd vssd sg13cmos5l_decap_8
XFILLER_22_2590 vddd vssd sg13cmos5l_decap_8
XFILLER_32_648 vddd vssd sg13cmos5l_decap_8
XFILLER_31_114 vddd vssd sg13cmos5l_decap_8
XFILLER_16_2361 vddd vssd sg13cmos5l_decap_8
XFILLER_9_822 vddd vssd sg13cmos5l_decap_8
XFILLER_9_877 vddd vssd sg13cmos5l_decap_8
XFILLER_12_1502 vddd vssd sg13cmos5l_decap_8
XFILLER_12_1546 vddd vssd sg13cmos5l_decap_8
XFILLER_8_398 vddd vssd sg13cmos5l_decap_8
XFILLER_28_1008 vddd vssd sg13cmos5l_decap_8
X_4270_ _7388_/D _4303_/A _5279_/B _4270_/C vddd vssd sg13cmos5l_nor3_1
XFILLER_25_1929 vddd vssd sg13cmos5l_decap_4
XFILLER_3_1714 vddd vssd sg13cmos5l_decap_4
XFILLER_3_2448 vddd vssd sg13cmos5l_decap_8
XFILLER_23_1675 vddd vssd sg13cmos5l_decap_4
X_6911_ _6911_/Y _6914_/A _6914_/B_N vddd vssd sg13cmos5l_nor2b_1
X_6842_ _6842_/Y _6913_/A _6913_/B_N vddd vssd sg13cmos5l_nor2b_1
X_6773_ _6773_/Y _6773_/A _6776_/S vddd vssd sg13cmos5l_nand2_1
X_3985_ wire9/A _7061_/Q _6739_/A _3983_/Y vddd vssd sg13cmos5l_o21ai_1
XFILLER_17_1435 vddd vssd sg13cmos5l_decap_8
X_5724_ _5724_/Y _5294_/C _5727_/B _5732_/B _5828_/B2 _5713_/B vddd vssd sg13cmos5l_a221oi_1
XFILLER_30_191 vddd vssd sg13cmos5l_decap_8
X_5655_ _5656_/B _5655_/A _5655_/B vddd vssd sg13cmos5l_nor2_1
XFILLER_17_1479 vddd vssd sg13cmos5l_decap_8
XFILLER_30_1646 vddd vssd sg13cmos5l_decap_8
X_4606_ _4606_/Y _3497_/Y _4595_/X _4460_/B vddd vssd sg13cmos5l_o21ai_1
XFILLER_11_1023 vddd vssd sg13cmos5l_decap_8
X_5586_ _5586_/Y _5586_/A _5586_/B vddd vssd sg13cmos5l_nor2_1
X_7325_ _7325_/Q _7398_/CLK _7325_/D _6839_/Y vddd vssd sg13cmos5l_dfrbpq_1
X_4537_ _4537_/Y _4531_/A _4524_/Y _4818_/B vddd vssd sg13cmos5l_o21ai_1
XFILLER_11_1089 vddd vssd sg13cmos5l_decap_4
X_7256_ _7256_/Q _7258_/CLK _7256_/D fanout382/X vddd vssd sg13cmos5l_dfrbpq_1
X_4468_ _4674_/B _6057_/A _4468_/B vddd vssd sg13cmos5l_nand2_1
X_6207_ _6207_/X _5659_/A _5542_/A _6207_/S vddd vssd sg13cmos5l_mux2_1
X_7187_ _7187_/Q _7189_/CLK _7187_/D fanout362/X vddd vssd sg13cmos5l_dfrbpq_1
X_4399_ _4399_/Y _4399_/A vddd vssd sg13cmos5l_inv_1
X_6138_ _6138_/Y _6185_/C _6137_/A _6137_/Y vddd vssd sg13cmos5l_a21oi_1
XFILLER_8_1658 vddd vssd sg13cmos5l_decap_8
Xhold1010 _6462_/A _7182_/Q vddd vssd sg13cmos5l_dlygate4sd3_1
Xhold1021 _6607_/A0 _7260_/Q vddd vssd sg13cmos5l_dlygate4sd3_1
Xhold1032 _3610_/A _7234_/Q vddd vssd sg13cmos5l_dlygate4sd3_1
XFILLER_6_2083 vddd vssd sg13cmos5l_decap_8
Xhold1076 _7034_/D _6705_/X vddd vssd sg13cmos5l_dlygate4sd3_1
XFILLER_27_921 vddd vssd sg13cmos5l_decap_8
Xhold1065 _5989_/A2 _4937_/A vddd vssd sg13cmos5l_dlygate4sd3_1
Xhold1054 _6326_/A1 _3599_/Y vddd vssd sg13cmos5l_dlygate4sd3_1
X_6069_ _6069_/X _6156_/A _6069_/B vddd vssd sg13cmos5l_or2_1
Xhold1043 _7322_/D _6686_/X vddd vssd sg13cmos5l_dlygate4sd3_1
Xhold1098 _3625_/A _7071_/Q vddd vssd sg13cmos5l_dlygate4sd3_1
Xhold1087 _6671_/A0 _7301_/Q vddd vssd sg13cmos5l_dlygate4sd3_1
XFILLER_26_55 vddd vssd sg13cmos5l_decap_8
XFILLER_14_615 vddd vssd sg13cmos5l_decap_8
XFILLER_14_659 vddd vssd sg13cmos5l_decap_8
XFILLER_22_681 vddd vssd sg13cmos5l_decap_8
XFILLER_13_2534 vddd vssd sg13cmos5l_decap_8
XFILLER_10_832 vddd vssd sg13cmos5l_decap_8
XFILLER_13_1855 vddd vssd sg13cmos5l_decap_8
XFILLER_13_1833 vddd vssd sg13cmos5l_decap_8
XFILLER_5_368 vddd vssd sg13cmos5l_decap_8
Xtiedowns\[47\] mask_rev_in[3] vddd vssd sg13cmos5l_antennanp
XFILLER_7_1157 vddd vssd sg13cmos5l_decap_8
XFILLER_20_2549 vddd vssd sg13cmos5l_decap_8
XFILLER_18_910 vddd vssd sg13cmos5l_decap_8
XFILLER_29_280 vddd vssd sg13cmos5l_decap_8
XFILLER_20_1826 vddd vssd sg13cmos5l_decap_8
XFILLER_2_2492 vddd vssd sg13cmos5l_decap_4
XFILLER_32_401 vddd vssd sg13cmos5l_decap_8
XFILLER_32_489 vddd vssd sg13cmos5l_decap_8
X_3770_ _3770_/Y _3694_/Y _6088_/A _6726_/A vddd vssd sg13cmos5l_a21oi_1
XFILLER_13_692 vddd vssd sg13cmos5l_decap_8
X_5440_ _5440_/X _5789_/A _5440_/B vddd vssd sg13cmos5l_and2_1
XFILLER_9_685 vddd vssd sg13cmos5l_decap_8
X_5371_ _5384_/C _5374_/B _5386_/A vddd vssd sg13cmos5l_nand2b_1
XFILLER_9_2602 vddd vssd sg13cmos5l_decap_4
XFILLER_29_2541 vddd vssd sg13cmos5l_decap_8
XFILLER_25_2405 vddd vssd sg13cmos5l_decap_8
X_7110_ _7110_/Q _7263_/CLK _7110_/D _6952_/B_N vddd vssd sg13cmos5l_dfrbpq_1
X_4322_ _4323_/C _4353_/A _4355_/A _4357_/A vddd vssd sg13cmos5l_and3_1
X_7041_ _7041_/Q _7071_/CLK _7041_/D fanout347/X vddd vssd sg13cmos5l_dfrbpq_1
X_4253_ _4253_/Y _4253_/A _4253_/B vddd vssd sg13cmos5l_nor2_1
Xfanout119 _6475_/B fanout122/X vddd vssd sg13cmos5l_buf_1
XFILLER_29_1873 vddd vssd sg13cmos5l_decap_8
XFILLER_25_1737 vddd vssd sg13cmos5l_decap_4
X_4184_ _4184_/Y _7190_/Q _6475_/A vddd vssd sg13cmos5l_nand2b_1
Xoutbuffers\[30\] bandgap_sink2[0] _7065_/Q vddd vssd sg13cmos5l_buf_16
X_6825_ _6825_/Y _6840_/A _6893_/B_N vddd vssd sg13cmos5l_nor2b_1
X_6756_ _6756_/X _6405_/A _6756_/A1 _6761_/S vddd vssd sg13cmos5l_mux2_1
X_3968_ _3968_/Y _5340_/B _6410_/A vddd vssd sg13cmos5l_nand2_1
XFILLER_32_1719 vddd vssd sg13cmos5l_decap_8
XFILLER_32_990 vddd vssd sg13cmos5l_decap_8
X_5707_ _5707_/X io_in[0] _5706_/A _5706_/Y vddd vssd sg13cmos5l_a21o_1
X_6687_ _6695_/S _6687_/A _6702_/B vddd vssd sg13cmos5l_nand2_1
X_3899_ _4115_/A _3924_/A _3946_/A vddd vssd sg13cmos5l_nor2_1
XFILLER_12_35 vddd vssd sg13cmos5l_decap_8
XFILLER_13_1118 vddd vssd sg13cmos5l_decap_8
X_5638_ _5641_/B _5638_/A _5638_/B vddd vssd sg13cmos5l_nor2_1
XFILLER_12_79 vddd vssd sg13cmos5l_decap_8
X_5569_ _5586_/B _5581_/A _5569_/B vddd vssd sg13cmos5l_nand2_1
X_7308_ _7308_/Q _7400_/CLK _7308_/D _6830_/Y vddd vssd sg13cmos5l_dfrbpq_1
XFILLER_5_7 vddd vssd sg13cmos5l_decap_8
XFILLER_28_2051 vddd vssd sg13cmos5l_decap_8
X_7239_ _7239_/Q _7296_/CLK _7239_/D fanout373/X vddd vssd sg13cmos5l_dfrbpq_1
XFILLER_4_1308 vddd vssd sg13cmos5l_decap_8
XFILLER_24_1247 vddd vssd sg13cmos5l_decap_8
XFILLER_26_261 vddd vssd sg13cmos5l_decap_8
XFILLER_30_927 vddd vssd sg13cmos5l_decap_8
XFILLER_13_1641 vddd vssd sg13cmos5l_decap_8
XFILLER_10_684 vddd vssd sg13cmos5l_decap_8
XFILLER_13_1685 vddd vssd sg13cmos5l_decap_8
XFILLER_24_2460 vddd vssd sg13cmos5l_decap_8
XFILLER_20_1612 vddd vssd sg13cmos5l_decap_8
XFILLER_0_2429 vddd vssd sg13cmos5l_decap_8
XFILLER_4_2587 vddd vssd sg13cmos5l_decap_8
XFILLER_20_2379 vddd vssd sg13cmos5l_decap_8
XFILLER_20_1667 vddd vssd sg13cmos5l_decap_8
Xoutbuffers\[120\] dbus_out[23] _5978_/Y vddd vssd sg13cmos5l_buf_16
X_4940_ _4940_/Y _4940_/A _4943_/A vddd vssd sg13cmos5l_xnor2_1
X_4871_ _4874_/A _4925_/A _7140_/Q _4870_/X vddd vssd sg13cmos5l_o21ai_1
XFILLER_17_283 vddd vssd sg13cmos5l_decap_8
XFILLER_32_275 vddd vssd sg13cmos5l_decap_8
X_3822_ _3822_/Y dbus_in_left[4] dbus_in_right[4] vddd vssd sg13cmos5l_nor2_1
X_6610_ _6610_/Y _6610_/A _6614_/S vddd vssd sg13cmos5l_nor2_1
X_6541_ _6541_/X _6532_/A _6541_/A1 _6543_/B vddd vssd sg13cmos5l_mux2_1
XFILLER_31_2464 vddd vssd sg13cmos5l_decap_8
X_3753_ _6395_/A _3753_/A _3753_/B _3753_/C _3753_/D vddd vssd sg13cmos5l_or4_1
XFILLER_14_1438 vddd vssd sg13cmos5l_decap_8
X_3684_ _3867_/B _3753_/A _3753_/B vddd vssd sg13cmos5l_nand2_1
X_6472_ _6472_/Y _6472_/A _6474_/S vddd vssd sg13cmos5l_nor2_1
X_5423_ _5424_/B _5423_/A _5423_/B vddd vssd sg13cmos5l_nor2_1
X_5354_ _5354_/Y _7154_/Q _7155_/Q _5354_/C vddd vssd sg13cmos5l_nor3_1
X_4305_ _4305_/Y _4305_/A _4307_/A vddd vssd sg13cmos5l_xnor2_1
Xoutbuffers\[78\] io_oe[5] _5152_/Y vddd vssd sg13cmos5l_buf_16
X_5285_ _5285_/Y _6009_/A _5308_/D vddd vssd sg13cmos5l_nor2b_1
X_7024_ _7024_/Q _7199_/CLK _7024_/D fanout369/X vddd vssd sg13cmos5l_dfrbpq_1
XFILLER_25_1534 vddd vssd sg13cmos5l_decap_4
XFILLER_9_1753 vddd vssd sg13cmos5l_decap_8
X_4236_ _4236_/Y _7150_/Q _6402_/A vddd vssd sg13cmos5l_nand2b_1
XFILLER_25_1578 vddd vssd sg13cmos5l_decap_8
X_4167_ _4167_/X _7087_/Q _3848_/B _6779_/A vddd vssd sg13cmos5l_a21o_1
XFILLER_3_2064 vddd vssd sg13cmos5l_decap_8
X_4098_ _4098_/Y _4098_/A vddd vssd sg13cmos5l_inv_1
XFILLER_3_1341 vddd vssd sg13cmos5l_decap_8
XFILLER_19_1327 vddd vssd sg13cmos5l_decap_8
XFILLER_24_787 vddd vssd sg13cmos5l_decap_8
X_6808_ _6808_/X _6808_/A vddd vssd sg13cmos5l_buf_1
XFILLER_11_415 vddd vssd sg13cmos5l_decap_8
XFILLER_12_927 vddd vssd sg13cmos5l_decap_8
XFILLER_32_1516 vddd vssd sg13cmos5l_decap_8
XFILLER_23_56 vddd vssd sg13cmos5l_decap_8
X_6739_ _6745_/S _6739_/A _6762_/C vddd vssd sg13cmos5l_nor2_1
XFILLER_20_993 vddd vssd sg13cmos5l_decap_8
XFILLER_10_2526 vddd vssd sg13cmos5l_decap_8
XFILLER_10_1836 vddd vssd sg13cmos5l_decap_8
XFILLER_30_1295 vddd vssd sg13cmos5l_decap_4
XFILLER_3_647 vddd vssd sg13cmos5l_decap_8
Xfanout450 _6727_/A SDI vddd vssd sg13cmos5l_buf_1
XFILLER_8_1263 vddd vssd sg13cmos5l_decap_8
XFILLER_24_1077 vddd vssd sg13cmos5l_decap_8
XFILLER_0_49 vddd vssd sg13cmos5l_decap_8
XFILLER_15_721 vddd vssd sg13cmos5l_decap_8
XFILLER_19_2562 vddd vssd sg13cmos5l_decap_8
XFILLER_9_14 vddd vssd sg13cmos5l_decap_8
XFILLER_30_735 vddd vssd sg13cmos5l_decap_8
XFILLER_15_2437 vddd vssd sg13cmos5l_decap_8
XFILLER_11_960 vddd vssd sg13cmos5l_decap_8
XFILLER_13_2183 vddd vssd sg13cmos5l_decap_4
XFILLER_6_441 vddd vssd sg13cmos5l_decap_4
XFILLER_7_964 vddd vssd sg13cmos5l_decap_8
Xhold909 _3505_/A _7314_/Q vddd vssd sg13cmos5l_dlygate4sd3_1
XFILLER_26_2500 vddd vssd sg13cmos5l_decap_8
XFILLER_26_2577 vddd vssd sg13cmos5l_decap_8
X_5070_ _5071_/C _6049_/B _6049_/C _6050_/A vddd vssd sg13cmos5l_a21oi_1
X_4021_ _4021_/Y _7248_/Q _6583_/A _3898_/B vddd vssd sg13cmos5l_o21ai_1
XFILLER_22_1729 vddd vssd sg13cmos5l_decap_8
XFILLER_0_2248 vddd vssd sg13cmos5l_decap_4
X_5972_ _5972_/Y _5972_/A _7241_/Q _5972_/C vddd vssd sg13cmos5l_nor3_1
XFILLER_4_1683 vddd vssd sg13cmos5l_decap_8
XFILLER_20_1486 vddd vssd sg13cmos5l_decap_4
X_4923_ _4952_/B _4955_/A _4955_/B vddd vssd sg13cmos5l_and2_1
XFILLER_0_1547 vddd vssd sg13cmos5l_decap_8
XFILLER_18_2083 vddd vssd sg13cmos5l_decap_8
X_4854_ _4854_/Y _4853_/A sram_odata[3] _4853_/Y vddd vssd sg13cmos5l_o21ai_1
X_3805_ _3805_/Y _3802_/Y _3805_/B vddd vssd sg13cmos5l_nand2b_1
XFILLER_20_245 vddd vssd sg13cmos5l_decap_4
X_4785_ _4789_/B _4756_/B _4782_/B _4821_/A vddd vssd sg13cmos5l_o21ai_1
X_3736_ _3736_/Y _3593_/Y _4256_/B _3731_/Y _3735_/Y vddd vssd sg13cmos5l_a22oi_1
X_6524_ _7214_/D _6540_/A1 _6528_/S hold965/X vddd vssd sg13cmos5l_o21ai_1
X_3667_ _6301_/A _3713_/A _3878_/A vddd vssd sg13cmos5l_or2_1
X_6455_ _7178_/D _6492_/A1 _6459_/B hold945/X vddd vssd sg13cmos5l_o21ai_1
X_6386_ _6386_/Y _6386_/A _6388_/B vddd vssd sg13cmos5l_nand2_1
X_5406_ _5406_/Y _5410_/B _5405_/X _5404_/Y vddd vssd sg13cmos5l_o21ai_1
X_3598_ _3598_/Y _3598_/A vddd vssd sg13cmos5l_inv_1
XFILLER_27_1618 vddd vssd sg13cmos5l_decap_8
X_5337_ _5360_/B _5337_/A vddd vssd sg13cmos5l_inv_1
X_5268_ _6273_/A _5269_/D vddd vssd sg13cmos5l_inv_1
X_7007_ _7007_/Q _7335_/CLK _7007_/D _6954_/Y vddd vssd sg13cmos5l_dfrbpq_1
X_4219_ _4219_/Y _5721_/A _3929_/Y _4217_/X _4218_/Y _6498_/A vddd vssd sg13cmos5l_a221oi_1
XFILLER_28_301 vddd vssd sg13cmos5l_decap_8
XFILLER_25_1364 vddd vssd sg13cmos5l_decap_8
X_5199_ _5217_/A _6181_/B _6181_/C vddd vssd sg13cmos5l_nand2_1
XFILLER_18_56 vddd vssd sg13cmos5l_decap_8
XFILLER_19_1135 vddd vssd sg13cmos5l_decap_4
XFILLER_32_2058 vddd vssd sg13cmos5l_decap_8
XFILLER_14_2470 vddd vssd sg13cmos5l_decap_8
XFILLER_14_1780 vddd vssd sg13cmos5l_decap_8
XFILLER_10_2389 vddd vssd sg13cmos5l_decap_4
XFILLER_3_444 vddd vssd sg13cmos5l_decap_8
XFILLER_21_2430 vddd vssd sg13cmos5l_decap_8
Xfanout291 _5583_/B hold1407/X vddd vssd sg13cmos5l_buf_1
Xfanout280 _5901_/A hold1358/X vddd vssd sg13cmos5l_buf_1
Xclkbuf_leaf_7_SCK_regs _7367_/CLK clkload4/A vddd vssd sg13cmos5l_buf_8
XFILLER_15_1511 vddd vssd sg13cmos5l_decap_8
X_4570_ _4570_/Y _4570_/A _4570_/B vddd vssd sg13cmos5l_nand2_1
XFILLER_15_1588 vddd vssd sg13cmos5l_decap_8
X_3521_ _3521_/Y _7297_/Q vddd vssd sg13cmos5l_inv_1
XFILLER_32_1880 vddd vssd sg13cmos5l_decap_4
Xhold706 _6364_/A _7128_/Q vddd vssd sg13cmos5l_dlygate4sd3_1
Xhold728 _7353_/D _4413_/Y vddd vssd sg13cmos5l_dlygate4sd3_1
Xhold717 _7378_/D _4285_/Y vddd vssd sg13cmos5l_dlygate4sd3_1
X_6240_ _6240_/Y _6240_/A1 _6239_/B _6239_/Y _5253_/A _5253_/C vddd vssd sg13cmos5l_a221oi_1
Xhold739 hold739/X _3530_/Y vddd vssd sg13cmos5l_dlygate4sd3_1
X_6171_ _6171_/Y _4027_/Y _5214_/A _5216_/C vddd vssd sg13cmos5l_a21oi_1
X_5122_ _5131_/C _6181_/B _5178_/B vddd vssd sg13cmos5l_and2_1
XFILLER_26_2374 vddd vssd sg13cmos5l_decap_8
Xhold1406 _6489_/A1 _5647_/B vddd vssd sg13cmos5l_dlygate4sd3_1
XFILLER_27_0 vddd vssd sg13cmos5l_decap_8
XFILLER_6_1723 vddd vssd sg13cmos5l_decap_8
Xhold1439 _6738_/B1 _6737_/Y vddd vssd sg13cmos5l_dlygate4sd3_1
Xhold1417 hold1417/X _7300_/Q vddd vssd sg13cmos5l_dlygate4sd3_1
X_5053_ _5242_/A _7266_/Q _7267_/Q vddd vssd sg13cmos5l_nand2b_1
Xhold1428 _6437_/A1 _5441_/B vddd vssd sg13cmos5l_dlygate4sd3_1
X_4004_ _4004_/Y _7064_/Q _6746_/A vddd vssd sg13cmos5l_nor2b_1
XFILLER_22_1537 vddd vssd sg13cmos5l_decap_4
XFILLER_25_315 vddd vssd sg13cmos5l_decap_8
XFILLER_26_849 vddd vssd sg13cmos5l_decap_8
XFILLER_20_1272 vddd vssd sg13cmos5l_decap_8
X_5955_ _5970_/C _7238_/Q _7239_/Q vddd vssd sg13cmos5l_nand2_1
XFILLER_21_510 vddd vssd sg13cmos5l_decap_8
X_4906_ _4913_/A _3641_/Y _3654_/C _4905_/Y vddd vssd sg13cmos5l_a21oi_1
X_5886_ _5890_/B _6219_/A _5901_/B _5886_/C vddd vssd sg13cmos5l_nand3b_1
X_4837_ _4837_/Y _4841_/B _3647_/C _4836_/B vddd vssd sg13cmos5l_o21ai_1
X_4768_ _4768_/Y _4739_/B _4757_/B _4769_/A1 vddd vssd sg13cmos5l_o21ai_1
X_3719_ _3961_/A _3874_/B _3835_/B vddd vssd sg13cmos5l_nand2b_1
X_4699_ _4699_/Y _4762_/B _3599_/Y _4698_/Y vddd vssd sg13cmos5l_a21oi_1
X_6507_ _6507_/Y _6507_/A _6512_/B vddd vssd sg13cmos5l_nor2_1
XFILLER_20_35 vddd vssd sg13cmos5l_decap_8
XFILLER_11_1986 vddd vssd sg13cmos5l_decap_8
X_6438_ _6444_/S _6438_/A _6475_/B vddd vssd sg13cmos5l_nand2_1
X_6369_ _6369_/X hold837/X _6732_/A _6372_/S vddd vssd sg13cmos5l_mux2_1
XFILLER_29_77 vddd vssd sg13cmos5l_decap_8
XFILLER_28_120 vddd vssd sg13cmos5l_decap_8
XFILLER_28_186 vddd vssd sg13cmos5l_decap_8
XFILLER_16_337 vddd vssd sg13cmos5l_decap_4
XFILLER_32_808 vddd vssd sg13cmos5l_decap_8
XFILLER_16_2554 vddd vssd sg13cmos5l_decap_8
XFILLER_16_1842 vddd vssd sg13cmos5l_decap_4
XFILLER_32_1165 vddd vssd sg13cmos5l_decap_8
Xtiedowns\[77\] _4972_/A vddd vssd sg13cmos5l_antennanp
XANTENNA_8 SDI vddd vssd sg13cmos5l_antennanp
XFILLER_6_37 vddd vssd sg13cmos5l_decap_8
XFILLER_23_2503 vddd vssd sg13cmos5l_decap_8
XFILLER_20_7 vddd vssd sg13cmos5l_decap_8
X_5740_ _5740_/X _5758_/A _5764_/A vddd vssd sg13cmos5l_and2_1
XFILLER_30_340 vddd vssd sg13cmos5l_decap_8
XFILLER_30_2518 vddd vssd sg13cmos5l_decap_8
X_5671_ _5671_/Y _5841_/A _5669_/B _5669_/Y _5663_/Y _5672_/B vddd vssd sg13cmos5l_a221oi_1
X_4622_ _4622_/Y _4668_/A _4622_/B vddd vssd sg13cmos5l_nor2_1
XFILLER_15_1352 vddd vssd sg13cmos5l_decap_8
X_7341_ _7341_/Q _7342_/CLK _7341_/D _6855_/Y vddd vssd sg13cmos5l_dfrbpq_1
X_4553_ _4553_/Y _4553_/A _4553_/B vddd vssd sg13cmos5l_nor2_1
XFILLER_15_1396 vddd vssd sg13cmos5l_decap_8
Xhold514 _4540_/B _6996_/Q vddd vssd sg13cmos5l_dlygate4sd3_1
Xhold525 _6998_/D _3478_/Y vddd vssd sg13cmos5l_dlygate4sd3_1
Xhold503 _7014_/D hold503/A vddd vssd sg13cmos5l_dlygate4sd3_1
Xhold536 _4609_/A _6993_/Q vddd vssd sg13cmos5l_dlygate4sd3_1
X_7272_ _7272_/Q _7273_/CLK _7272_/D fanout383/X vddd vssd sg13cmos5l_dfrbpq_1
X_4484_ _4485_/B _4501_/B _4484_/B vddd vssd sg13cmos5l_nand2_1
X_3504_ _3504_/Y _4831_/B vddd vssd sg13cmos5l_inv_1
XFILLER_28_2447 vddd vssd sg13cmos5l_decap_8
Xhold547 _6991_/D _3484_/Y vddd vssd sg13cmos5l_dlygate4sd3_1
Xhold558 _5946_/B _6979_/Q vddd vssd sg13cmos5l_dlygate4sd3_1
Xhold569 _3860_/A _7393_/Q vddd vssd sg13cmos5l_dlygate4sd3_1
X_6223_ _6227_/B _6235_/C _6228_/C vddd vssd sg13cmos5l_nor2_1
XFILLER_8_2508 vddd vssd sg13cmos5l_decap_8
Xoutbuffers\[60\] voltgen_ena[0] _7050_/Q vddd vssd sg13cmos5l_buf_16
XFILLER_26_2171 vddd vssd sg13cmos5l_decap_8
X_6154_ _6154_/Y _6154_/A _6154_/B vddd vssd sg13cmos5l_nor2_1
XFILLER_8_1829 vddd vssd sg13cmos5l_decap_8
Xhold1203 _7288_/D _6651_/Y vddd vssd sg13cmos5l_dlygate4sd3_1
Xhold1214 _6742_/A0 _7059_/Q vddd vssd sg13cmos5l_dlygate4sd3_1
X_6085_ _6085_/Y _6083_/Y _6085_/B vddd vssd sg13cmos5l_nand2b_1
X_5105_ _5145_/B _7253_/Q _7252_/Q vddd vssd sg13cmos5l_nand2b_1
Xhold1225 _3591_/A _7229_/Q vddd vssd sg13cmos5l_dlygate4sd3_1
XFILLER_6_2254 vddd vssd sg13cmos5l_decap_8
Xhold1247 _7061_/D _6745_/X vddd vssd sg13cmos5l_dlygate4sd3_1
XFILLER_22_2079 vddd vssd sg13cmos5l_decap_8
XFILLER_22_1334 vddd vssd sg13cmos5l_decap_8
Xhold1236 _6502_/A1 _5690_/B vddd vssd sg13cmos5l_dlygate4sd3_1
Xhold1258 _4301_/A _7374_/Q vddd vssd sg13cmos5l_dlygate4sd3_1
X_5036_ _5037_/A _5074_/C _5232_/A vddd vssd sg13cmos5l_nand2_1
Xhold1269 _3552_/A _7159_/Q vddd vssd sg13cmos5l_dlygate4sd3_1
XFILLER_25_156 vddd vssd sg13cmos5l_decap_8
XFILLER_20_1091 vddd vssd sg13cmos5l_decap_8
X_6987_ _6987_/Q _7335_/CLK _6987_/D _6934_/Y vddd vssd sg13cmos5l_dfrbpq_1
X_5938_ _5942_/B _5939_/A _5939_/B vddd vssd sg13cmos5l_and2_1
XFILLER_15_35 vddd vssd sg13cmos5l_decap_8
XFILLER_22_841 vddd vssd sg13cmos5l_decap_8
XFILLER_16_1105 vddd vssd sg13cmos5l_decap_8
X_5869_ _5869_/Y _5841_/A _5863_/Y _5868_/Y vddd vssd sg13cmos5l_a21oi_1
XFILLER_31_23 vddd vssd sg13cmos5l_decap_8
XFILLER_7_1317 vddd vssd sg13cmos5l_decap_8
XFILLER_0_277 vddd vssd sg13cmos5l_decap_8
XFILLER_13_896 vddd vssd sg13cmos5l_decap_8
XFILLER_16_1650 vddd vssd sg13cmos5l_decap_8
XFILLER_12_2248 vddd vssd sg13cmos5l_decap_4
XFILLER_12_1525 vddd vssd sg13cmos5l_decap_4
XFILLER_25_1908 vddd vssd sg13cmos5l_decap_8
XFILLER_7_2585 vddd vssd sg13cmos5l_decap_8
XFILLER_23_1654 vddd vssd sg13cmos5l_decap_8
XFILLER_23_1698 vddd vssd sg13cmos5l_decap_8
X_6910_ _6910_/Y _6914_/A _6913_/B_N vddd vssd sg13cmos5l_nor2b_1
X_6841_ _6841_/Y _6913_/A _6874_/B_N vddd vssd sg13cmos5l_nor2b_1
X_6772_ _7078_/D _6772_/A1 _6776_/S _6771_/Y vddd vssd sg13cmos5l_o21ai_1
XFILLER_22_148 vddd vssd sg13cmos5l_decap_8
X_3984_ _6390_/A _3984_/A _3984_/B vddd vssd sg13cmos5l_nand2_1
Xoutbuffers\[4\] analog_bus_ena[2] _7038_/Q vddd vssd sg13cmos5l_buf_16
X_5723_ _5723_/Y _5719_/Y _5720_/Y _5718_/Y vddd vssd sg13cmos5l_o21ai_1
XFILLER_30_170 vddd vssd sg13cmos5l_decap_8
X_5654_ _5655_/B _6212_/A1 _5677_/C _7201_/Q vddd vssd sg13cmos5l_o21ai_1
X_4605_ _4605_/Y _4169_/A _4579_/Y _4758_/B1 vddd vssd sg13cmos5l_a21oi_1
XFILLER_11_1002 vddd vssd sg13cmos5l_decap_4
X_5585_ _5589_/B _7186_/Q _7187_/Q _7188_/Q _7189_/Q vddd vssd sg13cmos5l_nor4_1
X_7324_ _7324_/Q _7398_/CLK _7324_/D _6838_/Y vddd vssd sg13cmos5l_dfrbpq_1
X_4536_ _4539_/B _4536_/A _4536_/B _4536_/C vddd vssd sg13cmos5l_nor3_1
XFILLER_28_2244 vddd vssd sg13cmos5l_decap_8
X_7255_ _7255_/Q _7258_/CLK _7255_/D fanout381/X vddd vssd sg13cmos5l_dfrbpq_1
XFILLER_8_2305 vddd vssd sg13cmos5l_decap_8
X_4467_ _4468_/B _4698_/A _4713_/A vddd vssd sg13cmos5l_nor2b_1
XFILLER_28_2299 vddd vssd sg13cmos5l_decap_8
X_6206_ _6206_/Y _3495_/Y _7299_/Q _6204_/Y _6205_/Y _5233_/A vddd vssd sg13cmos5l_a221oi_1
X_7186_ _7186_/Q _7189_/CLK _7186_/D fanout361/X vddd vssd sg13cmos5l_dfrbpq_1
X_4398_ _4398_/Y hold659/X _5926_/A _4396_/Y _4419_/A vddd vssd sg13cmos5l_a22oi_1
Xhold1000 _6343_/A1 _3607_/Y vddd vssd sg13cmos5l_dlygate4sd3_1
XFILLER_24_1418 vddd vssd sg13cmos5l_decap_4
X_6137_ _6137_/Y _6137_/A _6137_/B _6137_/C vddd vssd sg13cmos5l_nor3_1
Xhold1011 _6463_/B1 _6462_/Y vddd vssd sg13cmos5l_dlygate4sd3_1
Xhold1022 _7260_/D _6607_/X vddd vssd sg13cmos5l_dlygate4sd3_1
Xhold1033 _6563_/A1 _6215_/A vddd vssd sg13cmos5l_dlygate4sd3_1
Xhold1066 _6505_/A1 _7205_/Q vddd vssd sg13cmos5l_dlygate4sd3_1
Xhold1055 _7110_/D _6326_/Y vddd vssd sg13cmos5l_dlygate4sd3_1
Xhold1044 _3598_/A _7109_/Q vddd vssd sg13cmos5l_dlygate4sd3_1
X_6068_ _6068_/Y _6154_/A _5099_/B _6069_/B vddd vssd sg13cmos5l_o21ai_1
Xhold1099 _6760_/A1 _3625_/Y vddd vssd sg13cmos5l_dlygate4sd3_1
XFILLER_22_1186 vddd vssd sg13cmos5l_decap_8
XFILLER_22_1175 vddd vssd sg13cmos5l_decap_4
X_5019_ _5024_/B _7272_/Q _7273_/Q _5231_/A vddd vssd sg13cmos5l_nor3_1
Xhold1088 _7301_/D _6671_/X vddd vssd sg13cmos5l_dlygate4sd3_1
Xhold1077 hold812/A _7379_/Q vddd vssd sg13cmos5l_dlygate4sd3_1
XFILLER_22_660 vddd vssd sg13cmos5l_decap_8
XFILLER_13_2513 vddd vssd sg13cmos5l_decap_8
XFILLER_17_1992 vddd vssd sg13cmos5l_decap_8
XFILLER_5_336 vddd vssd sg13cmos5l_decap_4
XFILLER_10_899 vddd vssd sg13cmos5l_decap_8
XFILLER_29_1307 vddd vssd sg13cmos5l_decap_8
Xclkbuf_leaf_21_SCK_regs _7119_/CLK clkload7/A vddd vssd sg13cmos5l_buf_8
XFILLER_7_1136 vddd vssd sg13cmos5l_decap_8
XFILLER_20_2528 vddd vssd sg13cmos5l_decap_8
XFILLER_17_421 vddd vssd sg13cmos5l_decap_8
XFILLER_2_1792 vddd vssd sg13cmos5l_decap_8
XFILLER_32_468 vddd vssd sg13cmos5l_decap_8
XFILLER_20_619 vddd vssd sg13cmos5l_decap_8
XFILLER_18_2479 vddd vssd sg13cmos5l_decap_8
XFILLER_18_1767 vddd vssd sg13cmos5l_decap_8
XFILLER_12_2034 vddd vssd sg13cmos5l_decap_8
XFILLER_8_185 vddd vssd sg13cmos5l_decap_4
XFILLER_29_2520 vddd vssd sg13cmos5l_decap_8
X_5370_ _5383_/A _5386_/A _5370_/B vddd vssd sg13cmos5l_nor2_1
XFILLER_12_1366 vddd vssd sg13cmos5l_decap_8
X_4321_ _4321_/Y _4342_/A _5279_/A vddd vssd sg13cmos5l_nand2_1
XFILLER_29_2597 vddd vssd sg13cmos5l_decap_8
XFILLER_29_1830 vddd vssd sg13cmos5l_decap_8
X_7040_ _7040_/Q _7367_/CLK _7040_/D _6917_/B_N vddd vssd sg13cmos5l_dfrbpq_1
X_4252_ _4253_/B _7120_/Q _6346_/A wire7/X _4251_/Y vddd vssd sg13cmos5l_a22oi_1
XFILLER_4_391 vddd vssd sg13cmos5l_decap_8
Xfanout109 _3924_/A _3919_/A vddd vssd sg13cmos5l_buf_1
X_4183_ _4183_/Y _7144_/Q _6390_/A _4183_/B1 vddd vssd sg13cmos5l_o21ai_1
XFILLER_27_229 vddd vssd sg13cmos5l_decap_8
XFILLER_3_1545 vddd vssd sg13cmos5l_decap_4
Xoutbuffers\[23\] voltgen_source[4] _7077_/Q vddd vssd sg13cmos5l_buf_16
X_6824_ _6824_/X _7082_/Q vddd vssd sg13cmos5l_buf_1
X_6755_ _7067_/D _6755_/A1 _6761_/S _6754_/Y vddd vssd sg13cmos5l_a21oi_1
XFILLER_23_468 vddd vssd sg13cmos5l_decap_8
X_3967_ _3967_/X _5374_/B _4144_/B _6410_/A vddd vssd sg13cmos5l_a21o_1
X_5706_ _5706_/Y _5706_/A _5706_/B _5706_/C vddd vssd sg13cmos5l_nor3_1
XFILLER_17_1277 vddd vssd sg13cmos5l_decap_8
X_3898_ _3898_/Y _7245_/Q _3898_/B vddd vssd sg13cmos5l_nor2_1
XFILLER_12_14 vddd vssd sg13cmos5l_decap_8
X_6686_ _6686_/X _6686_/A0 sram_odata[7] _6686_/S vddd vssd sg13cmos5l_mux2_1
X_5637_ _5638_/B _3568_/Y _5625_/Y _5636_/Y vddd vssd sg13cmos5l_a21oi_1
X_5568_ _5580_/A _5566_/Y _5567_/Y _3564_/Y vddd vssd sg13cmos5l_o21ai_1
X_4519_ _4522_/B _4792_/A _4519_/B vddd vssd sg13cmos5l_and2_1
X_7307_ _7307_/Q _7400_/CLK _7307_/D _6829_/Y vddd vssd sg13cmos5l_dfrbpq_1
X_5499_ _5499_/Y _5499_/A vddd vssd sg13cmos5l_inv_1
X_7238_ _7238_/Q _7292_/CLK _7238_/D fanout373/X vddd vssd sg13cmos5l_dfrbpq_1
X_7169_ _7169_/Q _7214_/CLK _7169_/D fanout359/X vddd vssd sg13cmos5l_dfrbpq_1
XFILLER_27_741 vddd vssd sg13cmos5l_decap_8
XFILLER_27_774 vddd vssd sg13cmos5l_decap_4
XFILLER_2_1077 vddd vssd sg13cmos5l_decap_8
XFILLER_26_295 vddd vssd sg13cmos5l_decap_8
XFILLER_14_435 vddd vssd sg13cmos5l_decap_8
XFILLER_10_663 vddd vssd sg13cmos5l_decap_8
XFILLER_2_895 vddd vssd sg13cmos5l_decap_4
XFILLER_4_2566 vddd vssd sg13cmos5l_decap_8
XFILLER_20_2358 vddd vssd sg13cmos5l_decap_8
XFILLER_0_2408 vddd vssd sg13cmos5l_decap_8
XFILLER_20_1646 vddd vssd sg13cmos5l_decap_8
XFILLER_18_752 vddd vssd sg13cmos5l_decap_4
XFILLER_17_262 vddd vssd sg13cmos5l_decap_8
XFILLER_32_210 vddd vssd sg13cmos5l_decap_8
X_4870_ _4870_/X _4946_/A _7141_/Q vddd vssd sg13cmos5l_or2_1
XFILLER_32_254 vddd vssd sg13cmos5l_decap_8
Xoutbuffers\[113\] dbus_out[16] _5767_/Y vddd vssd sg13cmos5l_buf_16
X_3821_ _3821_/Y _6762_/A _6762_/B vddd vssd sg13cmos5l_nor2_1
X_6540_ _7222_/D _6540_/A1 _6543_/B hold899/X vddd vssd sg13cmos5l_o21ai_1
XFILLER_31_2443 vddd vssd sg13cmos5l_decap_8
XFILLER_18_1597 vddd vssd sg13cmos5l_decap_8
X_3752_ _3925_/B _3938_/B _4009_/B vddd vssd sg13cmos5l_nor2_1
X_6471_ _7187_/D _6464_/A _6471_/A1 _6474_/S vddd vssd sg13cmos5l_mux2_1
X_3683_ _4081_/B _3683_/A _3877_/A vddd vssd sg13cmos5l_nand2_1
X_5422_ _5423_/B _3539_/A _5445_/C _5441_/B vddd vssd sg13cmos5l_o21ai_1
XFILLER_12_1141 vddd vssd sg13cmos5l_decap_8
X_5353_ _5353_/Y _5345_/Y _5352_/Y _5350_/Y vddd vssd sg13cmos5l_a21oi_1
X_4304_ _4307_/A _4281_/C _4304_/B vddd vssd sg13cmos5l_nand2b_1
XFILLER_29_2394 vddd vssd sg13cmos5l_decap_8
X_5284_ _5284_/Y _7146_/Q _7147_/Q vddd vssd sg13cmos5l_nand2_1
X_7023_ sdo_ena _7023_/CLK _7023_/D _3631_/Y vddd vssd sg13cmos5l_dfrbpq_1
XFILLER_4_81 vddd vssd sg13cmos5l_decap_8
XFILLER_9_2499 vddd vssd sg13cmos5l_decap_8
X_4235_ _4235_/X _7154_/Q _6410_/A _6402_/A vddd vssd sg13cmos5l_a21o_1
X_4166_ _4166_/Y _3602_/Y _3863_/B _4253_/A vddd vssd sg13cmos5l_a21oi_1
XFILLER_28_549 vddd vssd sg13cmos5l_decap_8
XFILLER_3_1320 vddd vssd sg13cmos5l_decap_8
X_4097_ _4098_/A _7283_/Q _6640_/A _6646_/A _5212_/B wire91/A vddd vssd sg13cmos5l_a221oi_1
XFILLER_19_2007 vddd vssd sg13cmos5l_decap_4
XFILLER_24_744 vddd vssd sg13cmos5l_decap_8
XFILLER_23_210 vddd vssd sg13cmos5l_decap_8
XFILLER_19_1306 vddd vssd sg13cmos5l_decap_8
X_6807_ _6807_/X _6807_/A vddd vssd sg13cmos5l_buf_1
X_4999_ _5008_/C _7278_/Q _7279_/Q _5223_/A _5224_/A vddd vssd sg13cmos5l_nor4_1
XFILLER_23_35 vddd vssd sg13cmos5l_decap_8
X_6738_ _7057_/D _6738_/A1 _6776_/S _6738_/B1 vddd vssd sg13cmos5l_a21oi_1
XFILLER_10_2505 vddd vssd sg13cmos5l_decap_8
X_6669_ _6669_/Y _6669_/A1 _6671_/S _6668_/Y vddd vssd sg13cmos5l_o21ai_1
XFILLER_20_972 vddd vssd sg13cmos5l_decap_8
XFILLER_3_626 vddd vssd sg13cmos5l_decap_8
Xfanout440 _5748_/A fanout443/X vddd vssd sg13cmos5l_buf_1
XFILLER_8_1231 vddd vssd sg13cmos5l_decap_4
Xfanout451 _6898_/A _6899_/A vddd vssd sg13cmos5l_buf_1
XFILLER_21_1922 vddd vssd sg13cmos5l_decap_4
XFILLER_0_28 vddd vssd sg13cmos5l_decap_8
XFILLER_19_2541 vddd vssd sg13cmos5l_decap_8
XFILLER_15_2416 vddd vssd sg13cmos5l_decap_8
XFILLER_15_788 vddd vssd sg13cmos5l_decap_8
XFILLER_15_1715 vddd vssd sg13cmos5l_decap_8
XFILLER_14_287 vddd vssd sg13cmos5l_decap_4
XFILLER_15_1759 vddd vssd sg13cmos5l_decap_8
XFILLER_7_943 vddd vssd sg13cmos5l_decap_8
XFILLER_10_471 vddd vssd sg13cmos5l_decap_8
XFILLER_9_1028 vddd vssd sg13cmos5l_decap_8
XFILLER_26_2556 vddd vssd sg13cmos5l_decap_8
X_4020_ _4020_/Y _7252_/Q _3894_/B _4018_/Y _4019_/Y _3892_/Y vddd vssd sg13cmos5l_a221oi_1
XFILLER_0_2227 vddd vssd sg13cmos5l_decap_8
XFILLER_4_1662 vddd vssd sg13cmos5l_decap_8
XFILLER_20_2188 vddd vssd sg13cmos5l_decap_4
XFILLER_20_1465 vddd vssd sg13cmos5l_decap_8
X_5971_ _5971_/Y _5971_/A1 _5969_/C _5969_/Y vddd vssd sg13cmos5l_o21ai_1
X_4922_ _4955_/B _4958_/A _4958_/B vddd vssd sg13cmos5l_and2_1
X_4853_ _4853_/Y _4853_/A _4853_/B _4853_/C vddd vssd sg13cmos5l_nand3_1
XFILLER_21_758 vddd vssd sg13cmos5l_decap_8
X_3804_ _3805_/B _7133_/Q _3842_/B wire81/X _3507_/Y _3803_/Y vddd vssd sg13cmos5l_a221oi_1
X_4784_ _4790_/A _4784_/A _4784_/B vddd vssd sg13cmos5l_nand2_1
X_3735_ _3735_/Y _7119_/Q _3863_/B _4253_/A _7111_/Q _4256_/B vddd vssd sg13cmos5l_a221oi_1
X_6523_ _6523_/Y _6523_/A _6528_/S vddd vssd sg13cmos5l_nand2_1
Xoutbuffers\[90\] io_out[5] _6120_/Y vddd vssd sg13cmos5l_buf_16
X_6454_ _6454_/Y _6454_/A _6459_/B vddd vssd sg13cmos5l_nand2_1
X_3666_ _3666_/Y _3713_/A _3878_/A vddd vssd sg13cmos5l_nor2_1
X_5405_ _5405_/X _5807_/A1 _4757_/A _7165_/Q vddd vssd sg13cmos5l_mux2_1
X_6385_ _6385_/Y _6777_/A _6388_/B hold677/X vddd vssd sg13cmos5l_o21ai_1
X_3597_ _3597_/Y _3597_/A vddd vssd sg13cmos5l_inv_1
X_5336_ _5337_/A _7156_/Q _7157_/Q vddd vssd sg13cmos5l_nor2_1
XFILLER_25_2044 vddd vssd sg13cmos5l_decap_4
X_5267_ _5269_/D _5267_/A _5267_/B vddd vssd sg13cmos5l_or2_1
XFILLER_9_2285 vddd vssd sg13cmos5l_decap_4
XFILLER_25_2066 vddd vssd sg13cmos5l_decap_8
X_7006_ _7006_/Q _7336_/CLK _7006_/D _6953_/Y vddd vssd sg13cmos5l_dfrbpq_1
XFILLER_5_2138 vddd vssd sg13cmos5l_decap_8
X_4218_ _4218_/Y _7210_/Q _6514_/A _3929_/Y vddd vssd sg13cmos5l_a21oi_1
XFILLER_29_847 vddd vssd sg13cmos5l_decap_8
XFILLER_18_35 vddd vssd sg13cmos5l_decap_8
X_5198_ _6181_/C _7256_/Q _7257_/Q vddd vssd sg13cmos5l_nor2b_1
X_4149_ _4149_/Y _3615_/Y _3821_/Y _6753_/A vddd vssd sg13cmos5l_a21oi_1
XFILLER_8_707 vddd vssd sg13cmos5l_decap_8
XFILLER_11_257 vddd vssd sg13cmos5l_decap_4
Xclkload0 clkload0/Y clkload0/A vddd vssd sg13cmos5l_inv_4
XFILLER_10_2335 vddd vssd sg13cmos5l_decap_4
XFILLER_4_946 vddd vssd sg13cmos5l_decap_8
Xtiedowns\[22\] dbus_in_left[2] vddd vssd sg13cmos5l_antennanp
Xfanout292 _5569_/B hold1396/X vddd vssd sg13cmos5l_buf_1
Xfanout270 _5209_/B _7269_/Q vddd vssd sg13cmos5l_buf_1
Xfanout281 _5837_/B hold1383/X vddd vssd sg13cmos5l_buf_1
XFILLER_21_2486 vddd vssd sg13cmos5l_decap_8
XFILLER_21_1785 vddd vssd sg13cmos5l_decap_4
XFILLER_19_1681 vddd vssd sg13cmos5l_decap_8
XFILLER_15_1556 vddd vssd sg13cmos5l_decap_8
XFILLER_32_2593 vddd vssd sg13cmos5l_decap_8
X_3520_ _3520_/Y _3520_/A vddd vssd sg13cmos5l_inv_1
Xhold707 hold707/X _6364_/Y vddd vssd sg13cmos5l_dlygate4sd3_1
Xhold718 _4317_/A _7366_/Q vddd vssd sg13cmos5l_dlygate4sd3_1
XFILLER_7_773 vddd vssd sg13cmos5l_decap_8
Xhold729 _4841_/B _7329_/Q vddd vssd sg13cmos5l_dlygate4sd3_1
X_6170_ _6170_/X _6170_/A _6170_/B vddd vssd sg13cmos5l_and2_1
XFILLER_26_2353 vddd vssd sg13cmos5l_decap_8
X_5121_ _5178_/B _7257_/Q _7256_/Q vddd vssd sg13cmos5l_nor2b_1
Xhold1407 hold1407/X _7189_/Q vddd vssd sg13cmos5l_dlygate4sd3_1
XFILLER_6_1702 vddd vssd sg13cmos5l_decap_8
XFILLER_6_2447 vddd vssd sg13cmos5l_decap_8
Xhold1418 _6670_/A0 _6207_/S vddd vssd sg13cmos5l_dlygate4sd3_1
Xhold1429 hold1429/X _7168_/Q vddd vssd sg13cmos5l_dlygate4sd3_1
X_5052_ _6049_/C _5130_/A _5247_/B vddd vssd sg13cmos5l_nor2_1
X_4003_ _4003_/Y _4001_/Y _4002_/Y hold575/X vddd vssd sg13cmos5l_o21ai_1
XFILLER_20_1240 vddd vssd sg13cmos5l_decap_8
XFILLER_0_2035 vddd vssd sg13cmos5l_decap_8
X_5954_ _5972_/C _7238_/Q _7239_/Q vddd vssd sg13cmos5l_nand2b_1
X_4905_ _4905_/Y _4905_/A _4905_/B vddd vssd sg13cmos5l_nor2_1
X_5885_ _5890_/A _5899_/C _5884_/Y _7232_/Q vddd vssd sg13cmos5l_o21ai_1
X_4836_ _4836_/Y _4832_/B _4836_/B vddd vssd sg13cmos5l_nand2b_1
Xtiedowns\[6\] sram_odata[6] vddd vssd sg13cmos5l_antennanp
XFILLER_21_566 vddd vssd sg13cmos5l_decap_4
X_6506_ _6512_/B _6506_/A _6762_/C vddd vssd sg13cmos5l_nor2_1
X_4767_ _4767_/Y _4766_/Y _4767_/B vddd vssd sg13cmos5l_nand2b_1
XFILLER_20_14 vddd vssd sg13cmos5l_decap_8
X_4698_ _4698_/Y _4698_/A _4698_/B vddd vssd sg13cmos5l_nor2_1
X_3718_ _3718_/Y _3874_/B _3936_/B vddd vssd sg13cmos5l_nor2_1
X_3649_ _3652_/B _5936_/A _6978_/Q _5942_/A vddd vssd sg13cmos5l_nor3_1
X_6437_ _7169_/D _6459_/A _6437_/A1 _6437_/S vddd vssd sg13cmos5l_mux2_1
X_6368_ _6368_/X hold799/X _6336_/A _6372_/S vddd vssd sg13cmos5l_mux2_1
X_5319_ _5320_/C _5319_/A _7153_/Q vddd vssd sg13cmos5l_nor2_1
X_6299_ _6299_/Y _6299_/A _7388_/Q vddd vssd sg13cmos5l_nor2b_1
XFILLER_9_2093 vddd vssd sg13cmos5l_decap_8
XFILLER_29_56 vddd vssd sg13cmos5l_decap_8
XFILLER_5_1223 vddd vssd sg13cmos5l_decap_8
XFILLER_28_165 vddd vssd sg13cmos5l_decap_8
XFILLER_25_861 vddd vssd sg13cmos5l_decap_8
XFILLER_0_2591 vddd vssd sg13cmos5l_decap_8
XFILLER_16_2533 vddd vssd sg13cmos5l_decap_8
XFILLER_32_1144 vddd vssd sg13cmos5l_decap_8
XFILLER_6_16 vddd vssd sg13cmos5l_decap_8
XFILLER_12_1718 vddd vssd sg13cmos5l_decap_8
XANTENNA_9 SDI vddd vssd sg13cmos5l_antennanp
XFILLER_10_2132 vddd vssd sg13cmos5l_decap_8
XFILLER_10_1453 vddd vssd sg13cmos5l_decap_4
XFILLER_10_2176 vddd vssd sg13cmos5l_decap_8
XFILLER_6_1009 vddd vssd sg13cmos5l_decap_4
XFILLER_23_2559 vddd vssd sg13cmos5l_decap_8
XFILLER_23_1847 vddd vssd sg13cmos5l_decap_8
XFILLER_19_132 vddd vssd sg13cmos5l_decap_4
XFILLER_5_2491 vddd vssd sg13cmos5l_decap_8
XFILLER_13_7 vddd vssd sg13cmos5l_decap_8
XFILLER_22_319 vddd vssd sg13cmos5l_decap_8
X_5670_ _5672_/B _7198_/Q _7199_/Q _5670_/C vddd vssd sg13cmos5l_nor3_1
XFILLER_19_2190 vddd vssd sg13cmos5l_decap_8
XFILLER_15_393 vddd vssd sg13cmos5l_decap_8
X_4621_ _4622_/B _4620_/B _3602_/Y _4620_/Y vddd vssd sg13cmos5l_a21oi_1
XFILLER_15_1342 vddd vssd sg13cmos5l_decap_4
XFILLER_32_2390 vddd vssd sg13cmos5l_decap_8
X_7340_ _7340_/Q _7342_/CLK _7340_/D _6854_/Y vddd vssd sg13cmos5l_dfrbpq_1
X_4552_ _4553_/B _4551_/B _3605_/Y _4551_/Y vddd vssd sg13cmos5l_a21oi_1
XFILLER_15_1375 vddd vssd sg13cmos5l_decap_8
XFILLER_11_1239 vddd vssd sg13cmos5l_decap_8
Xhold526 _3475_/A _7002_/Q vddd vssd sg13cmos5l_dlygate4sd3_1
Xhold515 _6997_/D _3479_/Y vddd vssd sg13cmos5l_dlygate4sd3_1
Xhold504 _7013_/D hold504/A vddd vssd sg13cmos5l_dlygate4sd3_1
X_4483_ _4486_/B _4803_/A _4483_/B vddd vssd sg13cmos5l_nor2_1
X_7271_ _7271_/Q _7297_/CLK _7271_/D fanout383/X vddd vssd sg13cmos5l_dfrbpq_1
X_3503_ _3503_/Y _6009_/A vddd vssd sg13cmos5l_inv_1
Xhold537 _6994_/D _3481_/Y vddd vssd sg13cmos5l_dlygate4sd3_1
XFILLER_28_2426 vddd vssd sg13cmos5l_decap_8
Xhold559 _6980_/D _5946_/X vddd vssd sg13cmos5l_dlygate4sd3_1
Xhold548 _4677_/A _7010_/Q vddd vssd sg13cmos5l_dlygate4sd3_1
X_6222_ _6228_/C _7237_/Q _7236_/Q vddd vssd sg13cmos5l_nand2b_1
X_6153_ _6153_/Y _6088_/A _5183_/A _6154_/B vddd vssd sg13cmos5l_o21ai_1
Xoutbuffers\[53\] bandgap_trim[14] _6298_/Y vddd vssd sg13cmos5l_buf_16
Xhold1215 _7059_/D _6742_/X vddd vssd sg13cmos5l_dlygate4sd3_1
Xhold1204 _6712_/A _7040_/Q vddd vssd sg13cmos5l_dlygate4sd3_1
X_6084_ _6085_/B _6263_/A1 _5132_/C _5132_/B vddd vssd sg13cmos5l_a21oi_1
X_5104_ _5180_/B _7253_/Q _7252_/Q vddd vssd sg13cmos5l_nor2b_1
Xhold1248 _6756_/A1 _7068_/Q vddd vssd sg13cmos5l_dlygate4sd3_1
XFILLER_22_1302 vddd vssd sg13cmos5l_decap_8
Xhold1237 _3563_/A _7183_/Q vddd vssd sg13cmos5l_dlygate4sd3_1
Xhold1226 _6553_/A1 _3591_/Y vddd vssd sg13cmos5l_dlygate4sd3_1
X_5035_ _5232_/A _7259_/Q _7258_/Q vddd vssd sg13cmos5l_nor2b_1
Xhold1259 _4964_/A _4310_/C vddd vssd sg13cmos5l_dlygate4sd3_1
XFILLER_6_1587 vddd vssd sg13cmos5l_decap_8
XFILLER_25_135 vddd vssd sg13cmos5l_decap_8
XFILLER_15_14 vddd vssd sg13cmos5l_decap_8
X_6986_ _6986_/Q _7336_/CLK _6986_/D _6933_/Y vddd vssd sg13cmos5l_dfrbpq_1
XFILLER_22_820 vddd vssd sg13cmos5l_decap_8
X_5937_ _5937_/Y _5945_/A _5939_/B _5937_/C vddd vssd sg13cmos5l_nor3_1
XFILLER_22_897 vddd vssd sg13cmos5l_decap_8
XFILLER_21_341 vddd vssd sg13cmos5l_decap_4
X_5868_ _5868_/Y _7226_/Q _7227_/Q _5868_/C _7229_/Q vddd vssd sg13cmos5l_nor4_1
XFILLER_21_374 vddd vssd sg13cmos5l_decap_8
X_4819_ _4819_/Y _3503_/Y _4798_/A _4818_/Y vddd vssd sg13cmos5l_o21ai_1
X_5799_ _5813_/D _7219_/Q _7218_/Q vddd vssd sg13cmos5l_nor2b_1
XFILLER_5_507 vddd vssd sg13cmos5l_decap_8
XFILLER_11_2463 vddd vssd sg13cmos5l_decap_8
XFILLER_31_79 vddd vssd sg13cmos5l_decap_8
XFILLER_11_1751 vddd vssd sg13cmos5l_decap_8
XFILLER_11_1762 vddd vssd sg13cmos5l_decap_8
XFILLER_27_1213 vddd vssd sg13cmos5l_decap_8
XFILLER_7_1307 vddd vssd sg13cmos5l_decap_4
XFILLER_0_256 vddd vssd sg13cmos5l_decap_4
XFILLER_31_149 vddd vssd sg13cmos5l_decap_8
XFILLER_13_853 vddd vssd sg13cmos5l_decap_8
XFILLER_9_835 vddd vssd sg13cmos5l_decap_8
XFILLER_8_334 vddd vssd sg13cmos5l_decap_8
XFILLER_10_1261 vddd vssd sg13cmos5l_decap_4
XFILLER_27_2492 vddd vssd sg13cmos5l_decap_8
XFILLER_7_1830 vddd vssd sg13cmos5l_decap_8
XFILLER_7_2564 vddd vssd sg13cmos5l_decap_8
XFILLER_23_1622 vddd vssd sg13cmos5l_decap_8
Xclkbuf_3_6_0_clk_regs clkbuf_3_6_0_clk_regs/X clkbuf_0_clk_regs/X vddd vssd sg13cmos5l_buf_8
X_6840_ _6840_/Y _6840_/A _6840_/B_N vddd vssd sg13cmos5l_nor2b_1
X_6771_ _6771_/Y _6782_/A _6776_/S vddd vssd sg13cmos5l_nand2_1
XFILLER_23_628 vddd vssd sg13cmos5l_decap_8
X_3983_ _3983_/Y _3978_/Y _3979_/Y _3982_/Y vddd vssd sg13cmos5l_o21ai_1
XFILLER_22_127 vddd vssd sg13cmos5l_decap_8
XFILLER_17_2138 vddd vssd sg13cmos5l_decap_8
X_5722_ _5728_/C _7209_/Q _7208_/Q vddd vssd sg13cmos5l_nor2b_1
X_5653_ _5655_/A _6211_/A _7198_/Q _7199_/Q vddd vssd sg13cmos5l_nor3_1
X_5584_ _5589_/A _5789_/A _5581_/Y _5582_/Y _5580_/Y _5583_/Y vddd vssd sg13cmos5l_a221oi_1
X_4604_ _4604_/Y _6121_/A _4628_/A vddd vssd sg13cmos5l_xnor2_1
X_4535_ _4535_/Y _4536_/C vddd vssd sg13cmos5l_inv_1
X_7323_ _7323_/Q _7342_/CLK _7323_/D _6837_/Y vddd vssd sg13cmos5l_dfrbpq_1
Xclkbuf_0_SCK_regs clkbuf_0_SCK_regs/X clkbuf_regs_1_SCK/X vddd vssd sg13cmos5l_buf_8
X_7254_ _7254_/Q _7258_/CLK _7254_/D fanout382/X vddd vssd sg13cmos5l_dfrbpq_1
X_4466_ _4713_/A _6012_/A _4712_/B vddd vssd sg13cmos5l_and2_1
XFILLER_28_1555 vddd vssd sg13cmos5l_decap_8
XFILLER_28_1533 vddd vssd sg13cmos5l_decap_4
X_7185_ _7185_/Q _7200_/CLK _7185_/D fanout361/X vddd vssd sg13cmos5l_dfrbpq_1
X_6205_ _6205_/Y _6276_/A _5233_/B _7299_/Q vddd vssd sg13cmos5l_a21oi_1
X_4397_ _4419_/A _5926_/A _4420_/B vddd vssd sg13cmos5l_and2_1
X_6136_ _6137_/C _6136_/A _6136_/B vddd vssd sg13cmos5l_nor2_1
XFILLER_8_1649 vddd vssd sg13cmos5l_decap_4
Xhold1001 _6641_/A _7282_/Q vddd vssd sg13cmos5l_dlygate4sd3_1
Xhold1023 _6654_/A _7290_/Q vddd vssd sg13cmos5l_dlygate4sd3_1
Xhold1012 hold478/A hold1504/X vddd vssd sg13cmos5l_dlygate4sd3_1
XFILLER_6_1340 vddd vssd sg13cmos5l_decap_8
XFILLER_6_2074 vddd vssd sg13cmos5l_decap_4
Xhold1067 _7205_/D _6505_/X vddd vssd sg13cmos5l_dlygate4sd3_1
Xhold1045 _6324_/A1 _3598_/Y vddd vssd sg13cmos5l_dlygate4sd3_1
Xhold1056 _4269_/A _7388_/Q vddd vssd sg13cmos5l_dlygate4sd3_1
Xhold1034 _3549_/A _7156_/Q vddd vssd sg13cmos5l_dlygate4sd3_1
X_6067_ _6067_/Y _6177_/A _5100_/B _6066_/Y vddd vssd sg13cmos5l_a21oi_1
X_5018_ _5231_/A _7271_/Q _7270_/Q vddd vssd sg13cmos5l_nand2b_1
Xhold1089 _3576_/A _7209_/Q vddd vssd sg13cmos5l_dlygate4sd3_1
Xhold1078 _5280_/A2 _3638_/B vddd vssd sg13cmos5l_dlygate4sd3_1
XFILLER_6_1384 vddd vssd sg13cmos5l_decap_8
XFILLER_14_606 vddd vssd sg13cmos5l_decap_4
X_6969_ _6969_/Y _6969_/A _6969_/B_N vddd vssd sg13cmos5l_nor2b_1
XFILLER_13_149 vddd vssd sg13cmos5l_decap_4
XFILLER_10_812 vddd vssd sg13cmos5l_decap_8
XFILLER_13_2569 vddd vssd sg13cmos5l_decap_8
XFILLER_6_827 vddd vssd sg13cmos5l_decap_8
XFILLER_10_878 vddd vssd sg13cmos5l_decap_8
XFILLER_3_28 vddd vssd sg13cmos5l_decap_8
Xhold890 _3629_/A _7321_/Q vddd vssd sg13cmos5l_dlygate4sd3_1
XFILLER_7_1104 vddd vssd sg13cmos5l_decap_8
XFILLER_24_1931 vddd vssd sg13cmos5l_decap_4
XFILLER_20_2507 vddd vssd sg13cmos5l_decap_8
XFILLER_24_1986 vddd vssd sg13cmos5l_decap_8
XFILLER_18_945 vddd vssd sg13cmos5l_decap_8
XFILLER_18_989 vddd vssd sg13cmos5l_decap_8
XFILLER_32_447 vddd vssd sg13cmos5l_decap_8
XFILLER_18_2458 vddd vssd sg13cmos5l_decap_8
XFILLER_16_2171 vddd vssd sg13cmos5l_decap_8
XFILLER_9_665 vddd vssd sg13cmos5l_decap_8
XFILLER_12_1378 vddd vssd sg13cmos5l_decap_4
X_4320_ _4320_/X _4342_/A _5279_/A vddd vssd sg13cmos5l_and2_1
XFILLER_29_2576 vddd vssd sg13cmos5l_decap_8
X_4251_ _4251_/Y _7128_/Q _3842_/B _6346_/A vddd vssd sg13cmos5l_a21oi_1
XFILLER_9_1903 vddd vssd sg13cmos5l_decap_8
XFILLER_25_1717 vddd vssd sg13cmos5l_decap_8
XFILLER_23_2142 vddd vssd sg13cmos5l_decap_8
X_4182_ _4182_/Y _4182_/A _4182_/B vddd vssd sg13cmos5l_nand2_1
XFILLER_27_208 vddd vssd sg13cmos5l_decap_8
XFILLER_3_2236 vddd vssd sg13cmos5l_decap_8
Xoutbuffers\[16\] proj_sel[3] _7027_/Q vddd vssd sg13cmos5l_buf_16
X_6823_ _6823_/Y _6917_/A _6915_/B_N vddd vssd sg13cmos5l_nor2b_1
X_6754_ _6754_/Y _6754_/A _6761_/S vddd vssd sg13cmos5l_nor2_1
XFILLER_11_609 vddd vssd sg13cmos5l_decap_8
X_3966_ _6410_/A wire95/A _3966_/B vddd vssd sg13cmos5l_and2_1
X_5705_ _5706_/C _5875_/A _5705_/B _5705_/C vddd vssd sg13cmos5l_nor3_1
XFILLER_17_1245 vddd vssd sg13cmos5l_decap_8
X_6685_ _7321_/D hold891/X _6686_/S _6684_/Y vddd vssd sg13cmos5l_o21ai_1
X_5636_ _5636_/Y _5779_/A1 _7197_/Q _5624_/Y vddd vssd sg13cmos5l_o21ai_1
X_3897_ _3897_/Y _7249_/Q _3892_/Y _3894_/Y _3891_/Y _6576_/A vddd vssd sg13cmos5l_a221oi_1
X_5567_ _5567_/Y _3539_/A _5579_/A _5583_/B vddd vssd sg13cmos5l_o21ai_1
XFILLER_12_2591 vddd vssd sg13cmos5l_decap_8
XFILLER_28_2020 vddd vssd sg13cmos5l_decap_8
X_4518_ _4519_/B _4515_/Y _4517_/Y _4500_/Y vddd vssd sg13cmos5l_o21ai_1
X_7306_ _7306_/Q _7328_/CLK _7306_/D _6828_/Y vddd vssd sg13cmos5l_dfrbpq_1
X_5498_ _5499_/A _5498_/A _5498_/B _5498_/C _5498_/D vddd vssd sg13cmos5l_nand4_1
X_4449_ _4572_/B _6121_/A _4619_/A vddd vssd sg13cmos5l_nor2_1
X_7237_ _7237_/Q _7292_/CLK _7237_/D fanout373/X vddd vssd sg13cmos5l_dfrbpq_1
X_7168_ _7168_/Q _7210_/CLK _7168_/D fanout359/X vddd vssd sg13cmos5l_dfrbpq_1
X_7099_ _7099_/Q _7111_/CLK _7099_/D fanout404/X vddd vssd sg13cmos5l_dfrbpq_1
X_6119_ _6119_/Y _3520_/Y _7320_/Q _6167_/B1 vddd vssd sg13cmos5l_o21ai_1
XFILLER_23_981 vddd vssd sg13cmos5l_decap_8
XFILLER_6_635 vddd vssd sg13cmos5l_decap_8
Xtiedowns\[52\] mask_rev_in[8] vddd vssd sg13cmos5l_antennanp
XFILLER_24_2495 vddd vssd sg13cmos5l_decap_8
XFILLER_20_2304 vddd vssd sg13cmos5l_decap_4
XFILLER_4_2545 vddd vssd sg13cmos5l_decap_8
XFILLER_4_2534 vddd vssd sg13cmos5l_decap_4
XFILLER_0_1719 vddd vssd sg13cmos5l_decap_8
XFILLER_18_2200 vddd vssd sg13cmos5l_decap_8
XFILLER_18_797 vddd vssd sg13cmos5l_decap_8
X_3820_ _3820_/Y _7294_/Q _4189_/B1 _6687_/A _7028_/Q vddd vssd sg13cmos5l_a22oi_1
XFILLER_18_1521 vddd vssd sg13cmos5l_decap_8
XFILLER_31_2422 vddd vssd sg13cmos5l_decap_8
Xoutbuffers\[106\] dbus_out[9] _5563_/Y vddd vssd sg13cmos5l_buf_16
X_3751_ _3751_/Y _3786_/A wire95/X vddd vssd sg13cmos5l_nand2_1
XFILLER_18_1576 vddd vssd sg13cmos5l_decap_8
X_6470_ _7186_/D _6492_/A1 _6474_/S _6469_/Y vddd vssd sg13cmos5l_o21ai_1
X_3682_ _3682_/X _3683_/A _3877_/A vddd vssd sg13cmos5l_and2_1
XFILLER_12_1120 vddd vssd sg13cmos5l_decap_8
XFILLER_31_2499 vddd vssd sg13cmos5l_decap_8
X_5421_ _5423_/A _5566_/A _7166_/Q _7167_/Q vddd vssd sg13cmos5l_nor3_1
X_5352_ _5352_/Y _5484_/A _7156_/Q _5351_/X vddd vssd sg13cmos5l_o21ai_1
XFILLER_29_2373 vddd vssd sg13cmos5l_decap_8
X_4303_ _4304_/B _4303_/A _4303_/B vddd vssd sg13cmos5l_nand2_1
X_7022_ _7022_/Q clkload1/A _7022_/D _6969_/Y vddd vssd sg13cmos5l_dfrbpq_1
X_5283_ _5283_/Y _7024_/Q _7027_/Q _7026_/Q _5283_/D vddd vssd sg13cmos5l_nor4_1
XFILLER_4_60 vddd vssd sg13cmos5l_decap_8
XFILLER_9_1711 vddd vssd sg13cmos5l_decap_8
XFILLER_9_2478 vddd vssd sg13cmos5l_decap_8
XFILLER_25_2259 vddd vssd sg13cmos5l_decap_4
X_4234_ _4234_/Y _5373_/A _4144_/B _4232_/X _4233_/Y _6410_/A vddd vssd sg13cmos5l_a221oi_1
X_4165_ _4165_/Y wire6/X _4162_/X _4164_/Y vddd vssd sg13cmos5l_o21ai_1
XFILLER_9_1788 vddd vssd sg13cmos5l_decap_8
XFILLER_28_517 vddd vssd sg13cmos5l_decap_8
XFILLER_7_1490 vddd vssd sg13cmos5l_decap_8
X_4096_ _4096_/Y _7291_/Q _6653_/A vddd vssd sg13cmos5l_nand2b_1
X_6806_ _7096_/D SDI _6805_/B hold623/X vddd vssd sg13cmos5l_a21oi_1
XFILLER_32_2219 vddd vssd sg13cmos5l_decap_8
XFILLER_23_14 vddd vssd sg13cmos5l_decap_8
X_4998_ _5010_/B _5245_/A _7251_/Q _7252_/Q _7253_/Q vddd vssd sg13cmos5l_nor4_1
X_6737_ _6737_/Y _6737_/A _6776_/S vddd vssd sg13cmos5l_nor2_1
XFILLER_20_951 vddd vssd sg13cmos5l_decap_8
X_3949_ _6453_/A _3980_/A _6395_/B vddd vssd sg13cmos5l_nor2_1
X_6668_ _6668_/Y _6668_/A _6671_/S vddd vssd sg13cmos5l_nand2_1
X_5619_ _5619_/Y _5502_/A _5617_/Y _5618_/Y _5616_/Y _5591_/Y vddd vssd sg13cmos5l_a221oi_1
X_6599_ _7254_/D _6635_/A1 _6602_/S hold928/X vddd vssd sg13cmos5l_a21oi_1
XFILLER_30_1275 vddd vssd sg13cmos5l_decap_8
XFILLER_2_115 vddd vssd sg13cmos5l_decap_8
Xfanout441 _5861_/A fanout443/X vddd vssd sg13cmos5l_buf_1
XFILLER_8_1210 vddd vssd sg13cmos5l_decap_8
Xfanout430 _5526_/A _5730_/A vddd vssd sg13cmos5l_buf_1
Xfanout452 _6916_/A _6899_/A vddd vssd sg13cmos5l_buf_1
XFILLER_21_1989 vddd vssd sg13cmos5l_decap_4
XFILLER_19_2520 vddd vssd sg13cmos5l_decap_8
XFILLER_19_2597 vddd vssd sg13cmos5l_decap_8
XFILLER_19_1874 vddd vssd sg13cmos5l_decap_8
XFILLER_9_49 vddd vssd sg13cmos5l_decap_8
XFILLER_6_410 vddd vssd sg13cmos5l_decap_8
XFILLER_11_995 vddd vssd sg13cmos5l_decap_8
XFILLER_6_454 vddd vssd sg13cmos5l_decap_8
XFILLER_13_1451 vddd vssd sg13cmos5l_decap_8
XFILLER_7_999 vddd vssd sg13cmos5l_decap_8
XFILLER_26_2535 vddd vssd sg13cmos5l_decap_8
XFILLER_9_1007 vddd vssd sg13cmos5l_decap_8
XFILLER_24_1591 vddd vssd sg13cmos5l_decap_8
XFILLER_20_2167 vddd vssd sg13cmos5l_decap_8
XFILLER_18_561 vddd vssd sg13cmos5l_decap_4
X_5970_ _5970_/Y _7240_/Q _7241_/Q _5970_/C vddd vssd sg13cmos5l_nor3_1
X_4921_ _4958_/B _4961_/A _4961_/B vddd vssd sg13cmos5l_and2_1
X_4852_ _4853_/C _4852_/A _4852_/B vddd vssd sg13cmos5l_nand2_1
X_3803_ _3803_/Y _7125_/Q _3717_/Y _6329_/A vddd vssd sg13cmos5l_o21ai_1
X_4783_ _4784_/B _4460_/A _4780_/Y _4782_/Y _4818_/B _4507_/B vddd vssd sg13cmos5l_a221oi_1
X_3734_ _6312_/A _3734_/A wire95/X vddd vssd sg13cmos5l_nand2_1
X_6522_ _6528_/S _6522_/A _6545_/B vddd vssd sg13cmos5l_nand2_1
XFILLER_9_270 vddd vssd sg13cmos5l_decap_8
X_3665_ _3665_/X _3693_/B _3928_/A vddd vssd sg13cmos5l_or2_1
X_6453_ _6459_/B _6453_/A _6475_/B vddd vssd sg13cmos5l_nand2_1
Xoutbuffers\[83\] io_oe[10] _5254_/Y vddd vssd sg13cmos5l_buf_16
X_5404_ _5404_/Y _5464_/A _7165_/Q _5408_/B vddd vssd sg13cmos5l_o21ai_1
X_6384_ _6384_/Y _6384_/A _6388_/B vddd vssd sg13cmos5l_nand2_1
X_3596_ _3596_/Y _3596_/A vddd vssd sg13cmos5l_inv_1
X_5335_ _5335_/Y _5590_/A1 _5331_/X _5334_/Y _5330_/Y vddd vssd sg13cmos5l_a22oi_1
XFILLER_25_2034 vddd vssd sg13cmos5l_decap_4
XFILLER_5_2117 vddd vssd sg13cmos5l_decap_4
X_5266_ _6276_/B _5266_/A _6185_/D vddd vssd sg13cmos5l_or2_1
X_7005_ _7005_/Q _7335_/CLK _7005_/D _6952_/Y vddd vssd sg13cmos5l_dfrbpq_1
X_4217_ _4217_/X _4214_/Y _4215_/Y _4216_/Y vddd vssd sg13cmos5l_a21o_1
XFILLER_9_1552 vddd vssd sg13cmos5l_decap_8
XFILLER_29_815 vddd vssd sg13cmos5l_decap_4
XFILLER_18_14 vddd vssd sg13cmos5l_decap_8
XFILLER_5_1427 vddd vssd sg13cmos5l_decap_8
X_5197_ _5216_/B _7246_/Q _7247_/Q _5258_/B vddd vssd sg13cmos5l_nor3_1
X_4148_ _4148_/X _7147_/Q _4238_/B _3821_/Y vddd vssd sg13cmos5l_a21o_1
X_4079_ _4079_/Y _7090_/Q _6789_/A _4081_/B vddd vssd sg13cmos5l_o21ai_1
XFILLER_24_586 vddd vssd sg13cmos5l_decap_4
XFILLER_11_214 vddd vssd sg13cmos5l_decap_8
Xclkload1 clkload1/Y clkload1/A vddd vssd sg13cmos5l_inv_1
XFILLER_32_1359 vddd vssd sg13cmos5l_decap_8
XFILLER_10_1657 vddd vssd sg13cmos5l_decap_4
XFILLER_3_479 vddd vssd sg13cmos5l_decap_4
XFILLER_26_1108 vddd vssd sg13cmos5l_decap_8
Xfanout271 _5208_/A _7268_/Q vddd vssd sg13cmos5l_buf_1
Xfanout282 _5791_/B _5794_/B vddd vssd sg13cmos5l_buf_1
XFILLER_8_1073 vddd vssd sg13cmos5l_decap_8
Xfanout260 _6979_/D _4909_/B1 vddd vssd sg13cmos5l_buf_1
XFILLER_21_2465 vddd vssd sg13cmos5l_decap_8
Xfanout293 _5581_/A hold1367/X vddd vssd sg13cmos5l_buf_1
Xtiedowns\[15\] io_in[7] vddd vssd sg13cmos5l_antennanp
XFILLER_1_1825 vddd vssd sg13cmos5l_decap_8
XFILLER_15_2214 vddd vssd sg13cmos5l_decap_4
XFILLER_30_556 vddd vssd sg13cmos5l_decap_8
XFILLER_32_2572 vddd vssd sg13cmos5l_decap_8
XFILLER_30_578 vddd vssd sg13cmos5l_decap_4
XFILLER_10_280 vddd vssd sg13cmos5l_decap_8
Xhold708 hold708/X _7280_/Q vddd vssd sg13cmos5l_dlygate4sd3_1
Xhold719 hold719/X _3492_/Y vddd vssd sg13cmos5l_dlygate4sd3_1
XFILLER_26_2343 vddd vssd sg13cmos5l_decap_4
X_5120_ _5132_/D _5207_/A _5175_/B vddd vssd sg13cmos5l_and2_1
X_5051_ _5069_/B _5074_/C _5241_/A vddd vssd sg13cmos5l_nand2_1
XFILLER_26_1686 vddd vssd sg13cmos5l_decap_8
XFILLER_26_1653 vddd vssd sg13cmos5l_decap_8
Xhold1419 _7300_/D _6670_/X vddd vssd sg13cmos5l_dlygate4sd3_1
Xhold1408 _6474_/A1 _5583_/B vddd vssd sg13cmos5l_dlygate4sd3_1
X_4002_ _4002_/Y _4089_/A _4267_/B _7023_/D vddd vssd sg13cmos5l_o21ai_1
XFILLER_0_2014 vddd vssd sg13cmos5l_decap_8
XFILLER_6_1769 vddd vssd sg13cmos5l_decap_8
XFILLER_19_870 vddd vssd sg13cmos5l_decap_8
XFILLER_4_1471 vddd vssd sg13cmos5l_decap_8
XFILLER_0_1346 vddd vssd sg13cmos5l_decap_8
XFILLER_20_1296 vddd vssd sg13cmos5l_decap_8
X_5953_ _5953_/Y _5951_/X _5952_/Y _5972_/A vddd vssd sg13cmos5l_a21oi_1
X_4904_ _4908_/B _4905_/B _4904_/B vddd vssd sg13cmos5l_nor2_1
X_5884_ _5884_/Y _7320_/Q _5901_/D vddd vssd sg13cmos5l_nor2b_1
X_4835_ _4835_/Y _4832_/Y _4834_/Y hold617/X vddd vssd sg13cmos5l_o21ai_1
X_4766_ _4766_/Y _4656_/A _4765_/Y _4804_/B1 vddd vssd sg13cmos5l_o21ai_1
X_6505_ _6505_/X _6552_/A _6505_/A1 _6505_/S vddd vssd sg13cmos5l_mux2_1
X_3717_ _3717_/Y _3984_/B wire98/X vddd vssd sg13cmos5l_nand2_1
X_4697_ _4697_/Y _4697_/A _4697_/B vddd vssd sg13cmos5l_nand2_1
X_3648_ _3654_/B _3648_/A vddd vssd sg13cmos5l_inv_1
X_6436_ _7168_/D _6472_/A _6436_/A1 _6437_/S vddd vssd sg13cmos5l_mux2_1
X_6367_ _6367_/X hold797/X _6317_/A _6372_/S vddd vssd sg13cmos5l_mux2_1
X_3579_ _3579_/Y _7315_/Q vddd vssd sg13cmos5l_inv_1
X_5318_ _5320_/B _7150_/Q _5318_/B vddd vssd sg13cmos5l_nor2_1
X_6298_ _6298_/Y _3628_/Y _6287_/B _6294_/A vddd vssd sg13cmos5l_a21oi_1
XFILLER_29_35 vddd vssd sg13cmos5l_decap_8
X_5249_ _5253_/C _5249_/A _5262_/B vddd vssd sg13cmos5l_nor2_1
XFILLER_28_144 vddd vssd sg13cmos5l_decap_8
XFILLER_25_840 vddd vssd sg13cmos5l_decap_8
XFILLER_16_2512 vddd vssd sg13cmos5l_decap_8
Xclkbuf_leaf_15_SCK_regs _7301_/CLK clkload9/A vddd vssd sg13cmos5l_buf_8
XFILLER_16_2589 vddd vssd sg13cmos5l_decap_8
XFILLER_8_505 vddd vssd sg13cmos5l_decap_4
XFILLER_32_1123 vddd vssd sg13cmos5l_decap_8
XFILLER_23_2538 vddd vssd sg13cmos5l_decap_8
XFILLER_0_994 vddd vssd sg13cmos5l_decap_4
XFILLER_5_2470 vddd vssd sg13cmos5l_decap_8
XFILLER_15_372 vddd vssd sg13cmos5l_decap_8
X_4620_ _4620_/Y _5542_/A _4620_/B vddd vssd sg13cmos5l_nor2_1
XFILLER_15_2066 vddd vssd sg13cmos5l_decap_8
X_4551_ _4551_/Y _5623_/A _4551_/B vddd vssd sg13cmos5l_nor2_1
Xhold505 _7019_/D hold505/A vddd vssd sg13cmos5l_dlygate4sd3_1
Xhold516 _4562_/A _6995_/Q vddd vssd sg13cmos5l_dlygate4sd3_1
XFILLER_28_2405 vddd vssd sg13cmos5l_decap_8
X_4482_ _4483_/B _4482_/A _7019_/D vddd vssd sg13cmos5l_xnor2_1
Xhold527 _7003_/D _3475_/Y vddd vssd sg13cmos5l_dlygate4sd3_1
X_7270_ _7270_/Q _7273_/CLK _7270_/D fanout383/X vddd vssd sg13cmos5l_dfrbpq_1
XFILLER_7_571 vddd vssd sg13cmos5l_decap_8
X_3502_ _4757_/A _7336_/Q vddd vssd sg13cmos5l_inv_1
Xhold549 _7011_/D _3473_/Y vddd vssd sg13cmos5l_dlygate4sd3_1
Xhold538 _4655_/A _7011_/Q vddd vssd sg13cmos5l_dlygate4sd3_1
X_6221_ _6221_/Y _6219_/Y _6220_/Y _6232_/C vddd vssd sg13cmos5l_o21ai_1
X_6152_ _6152_/Y _5184_/A _6150_/Y _6151_/Y vddd vssd sg13cmos5l_a21oi_1
XFILLER_32_0 vddd vssd sg13cmos5l_decap_8
X_5103_ _5103_/X _6060_/B _5103_/B _5103_/C vddd vssd sg13cmos5l_or3_1
Xhold1216 _6758_/A1 _7070_/Q vddd vssd sg13cmos5l_dlygate4sd3_1
Xhold1205 _6713_/B1 _6712_/Y vddd vssd sg13cmos5l_dlygate4sd3_1
X_6083_ _6083_/Y _6146_/A _6082_/B _5131_/D _6082_/Y _5132_/C vddd vssd sg13cmos5l_a221oi_1
Xoutbuffers\[46\] bandgap_trim[7] _6282_/B vddd vssd sg13cmos5l_buf_16
Xhold1249 _7068_/D _6756_/X vddd vssd sg13cmos5l_dlygate4sd3_1
XFILLER_22_2048 vddd vssd sg13cmos5l_decap_8
Xhold1238 _6465_/A1 _5544_/B vddd vssd sg13cmos5l_dlygate4sd3_1
Xhold1227 _7229_/D _6553_/Y vddd vssd sg13cmos5l_dlygate4sd3_1
X_5034_ _5042_/A _7256_/Q _7257_/Q _5136_/A vddd vssd sg13cmos5l_nor3_1
XFILLER_6_1533 vddd vssd sg13cmos5l_decap_8
XFILLER_6_1555 vddd vssd sg13cmos5l_decap_8
XFILLER_26_637 vddd vssd sg13cmos5l_decap_8
XFILLER_25_114 vddd vssd sg13cmos5l_decap_8
XFILLER_20_1071 vddd vssd sg13cmos5l_decap_8
X_6985_ _6985_/Q _7336_/CLK _6985_/D _6932_/Y vddd vssd sg13cmos5l_dfrbpq_1
XFILLER_0_1143 vddd vssd sg13cmos5l_decap_8
X_5936_ _5936_/Y _5936_/A _5936_/B vddd vssd sg13cmos5l_nor2_1
Xclkbuf_3_0_0_SCK_regs clkbuf_3_0_0_SCK_regs/X clkbuf_0_SCK_regs/X vddd vssd sg13cmos5l_buf_8
XFILLER_22_876 vddd vssd sg13cmos5l_decap_8
X_5867_ _5867_/Y _5873_/C _5862_/Y _5866_/Y vddd vssd sg13cmos5l_o21ai_1
X_4818_ _4818_/Y _4818_/A _4818_/B _4822_/A vddd vssd sg13cmos5l_nor3_1
X_5798_ _5819_/A _7218_/Q _7219_/Q vddd vssd sg13cmos5l_nor2_1
XFILLER_31_58 vddd vssd sg13cmos5l_decap_8
X_4749_ _4749_/Y _4769_/A1 _4744_/Y _4748_/Y vddd vssd sg13cmos5l_o21ai_1
XFILLER_11_2442 vddd vssd sg13cmos5l_decap_8
X_6419_ _7158_/D _6419_/A1 _6423_/S _6418_/Y vddd vssd sg13cmos5l_a21oi_1
X_7399_ _7399_/Q _7401_/CLK _7399_/D _6912_/Y vddd vssd sg13cmos5l_dfrbpq_1
XFILLER_0_235 vddd vssd sg13cmos5l_decap_8
XFILLER_5_1032 vddd vssd sg13cmos5l_decap_8
XFILLER_17_659 vddd vssd sg13cmos5l_decap_8
XFILLER_32_607 vddd vssd sg13cmos5l_decap_8
XFILLER_31_128 vddd vssd sg13cmos5l_decap_8
XFILLER_25_692 vddd vssd sg13cmos5l_decap_8
XFILLER_13_832 vddd vssd sg13cmos5l_decap_8
XFILLER_16_2375 vddd vssd sg13cmos5l_decap_8
XFILLER_12_397 vddd vssd sg13cmos5l_decap_8
XFILLER_8_368 vddd vssd sg13cmos5l_decap_8
XFILLER_12_1516 vddd vssd sg13cmos5l_decap_4
XFILLER_21_91 vddd vssd sg13cmos5l_decap_8
XFILLER_10_1240 vddd vssd sg13cmos5l_decap_8
XFILLER_27_2471 vddd vssd sg13cmos5l_decap_8
XFILLER_4_596 vddd vssd sg13cmos5l_decap_8
XFILLER_7_2543 vddd vssd sg13cmos5l_decap_8
XFILLER_3_2418 vddd vssd sg13cmos5l_decap_4
X_6770_ _6770_/X _6770_/A0 _6770_/A1 wire49/X vddd vssd sg13cmos5l_mux2_1
X_3982_ _3982_/Y _7043_/Q _3836_/Y _4159_/B vddd vssd sg13cmos5l_a21oi_1
XFILLER_22_106 vddd vssd sg13cmos5l_decap_8
XFILLER_1_1474 vddd vssd sg13cmos5l_decap_4
X_5721_ _5732_/B _5721_/A _7207_/Q vddd vssd sg13cmos5l_nor2_1
XFILLER_17_1449 vddd vssd sg13cmos5l_decap_8
X_5652_ _5677_/C _7198_/Q _5661_/B vddd vssd sg13cmos5l_nand2_1
X_4603_ _4603_/Y _4577_/Y _4626_/B _4575_/A vddd vssd sg13cmos5l_o21ai_1
X_5583_ _5583_/Y _7188_/Q _5583_/B _5586_/B vddd vssd sg13cmos5l_nor3_1
X_4534_ _4536_/C _4534_/A _4534_/B vddd vssd sg13cmos5l_and2_1
X_7322_ _7322_/Q _7338_/CLK _7322_/D _7322_/RESET_B vddd vssd sg13cmos5l_dfrbpq_1
XFILLER_7_93 vddd vssd sg13cmos5l_decap_8
XFILLER_28_2235 vddd vssd sg13cmos5l_decap_4
XFILLER_28_1512 vddd vssd sg13cmos5l_decap_8
X_7253_ _7253_/Q _7258_/CLK _7253_/D fanout385/X vddd vssd sg13cmos5l_dfrbpq_1
X_4465_ _4712_/B _4757_/A _4465_/B vddd vssd sg13cmos5l_and2_1
X_7184_ _7184_/Q _7200_/CLK _7184_/D fanout361/X vddd vssd sg13cmos5l_dfrbpq_1
X_6204_ _6204_/Y _5233_/C _6202_/Y _6203_/Y vddd vssd sg13cmos5l_o21ai_1
X_4396_ _4396_/Y _4458_/A _4815_/A _4396_/C _4821_/A vddd vssd sg13cmos5l_nor4_1
X_6135_ _6137_/B _6135_/A _6135_/B vddd vssd sg13cmos5l_nor2_1
XFILLER_8_1628 vddd vssd sg13cmos5l_decap_8
Xhold1002 _6642_/B1 _6641_/Y vddd vssd sg13cmos5l_dlygate4sd3_1
Xhold1024 _6655_/B1 _6654_/Y vddd vssd sg13cmos5l_dlygate4sd3_1
Xhold1013 _5983_/A0 _4925_/A vddd vssd sg13cmos5l_dlygate4sd3_1
X_6066_ _6066_/Y _5100_/B _6065_/Y _5099_/B vddd vssd sg13cmos5l_o21ai_1
X_5017_ _5024_/A _7288_/Q _7289_/Q _6188_/B vddd vssd sg13cmos5l_nor3_1
Xhold1046 hold1046/X _7402_/Q vddd vssd sg13cmos5l_dlygate4sd3_1
Xhold1057 _4270_/C _4269_/Y vddd vssd sg13cmos5l_dlygate4sd3_1
Xhold1035 _6415_/A1 _5348_/C vddd vssd sg13cmos5l_dlygate4sd3_1
XFILLER_26_14 vddd vssd sg13cmos5l_decap_8
Xhold1068 _6600_/A0 _7255_/Q vddd vssd sg13cmos5l_dlygate4sd3_1
Xhold1079 _7404_/D _5280_/Y vddd vssd sg13cmos5l_dlygate4sd3_1
XFILLER_26_69 vddd vssd sg13cmos5l_decap_8
XFILLER_14_629 vddd vssd sg13cmos5l_decap_8
X_6968_ _6968_/Y _6969_/A _6968_/B_N vddd vssd sg13cmos5l_nor2b_1
X_5919_ _5919_/Y _5908_/Y _5917_/Y _5918_/Y vddd vssd sg13cmos5l_a21oi_1
X_6899_ _6899_/Y _6899_/A _6901_/B_N vddd vssd sg13cmos5l_nor2b_1
XFILLER_13_2548 vddd vssd sg13cmos5l_decap_8
XFILLER_10_846 vddd vssd sg13cmos5l_decap_8
XFILLER_13_1869 vddd vssd sg13cmos5l_decap_8
XFILLER_11_1582 vddd vssd sg13cmos5l_decap_8
XFILLER_27_1011 vddd vssd sg13cmos5l_decap_8
XFILLER_24_2600 vddd vssd sg13cmos5l_decap_8
Xhold891 hold891/X _3629_/Y vddd vssd sg13cmos5l_dlygate4sd3_1
Xhold880 _7108_/D _6322_/Y vddd vssd sg13cmos5l_dlygate4sd3_1
XFILLER_27_1066 vddd vssd sg13cmos5l_decap_4
XFILLER_27_1099 vddd vssd sg13cmos5l_decap_8
XFILLER_18_924 vddd vssd sg13cmos5l_decap_8
XFILLER_29_294 vddd vssd sg13cmos5l_decap_8
XFILLER_32_415 vddd vssd sg13cmos5l_decap_8
XFILLER_17_489 vddd vssd sg13cmos5l_decap_4
Xclkbuf_leaf_30_SCK_regs _7258_/CLK clkload8/A vddd vssd sg13cmos5l_buf_8
XFILLER_16_2150 vddd vssd sg13cmos5l_decap_8
XFILLER_16_1482 vddd vssd sg13cmos5l_decap_4
XFILLER_29_2555 vddd vssd sg13cmos5l_decap_8
XFILLER_25_2419 vddd vssd sg13cmos5l_decap_8
X_4250_ wire7/A _4183_/Y _4248_/Y _4249_/Y vddd vssd sg13cmos5l_o21ai_1
X_4181_ _4181_/Y _4179_/Y _4180_/Y hold567/X vddd vssd sg13cmos5l_o21ai_1
XFILLER_23_2176 vddd vssd sg13cmos5l_decap_8
XFILLER_24_916 vddd vssd sg13cmos5l_decap_8
X_6822_ _6822_/Y CSB _6914_/B_N vddd vssd sg13cmos5l_nor2b_1
XFILLER_24_949 vddd vssd sg13cmos5l_decap_8
X_6753_ _6761_/S _6753_/A _6753_/B vddd vssd sg13cmos5l_nand2_1
X_3965_ _3965_/Y _3554_/Y _6424_/A _3963_/Y _3958_/Y _4144_/B vddd vssd sg13cmos5l_a221oi_1
X_5704_ _5706_/B _5704_/A _5704_/B vddd vssd sg13cmos5l_nor2_1
X_6684_ _6684_/Y sram_odata[6] _6686_/S vddd vssd sg13cmos5l_nand2_1
X_3896_ _3898_/B _3896_/A _3925_/B vddd vssd sg13cmos5l_nand2_1
X_5635_ _5640_/A _5633_/Y _5634_/Y _3568_/Y vddd vssd sg13cmos5l_o21ai_1
XFILLER_12_49 vddd vssd sg13cmos5l_decap_8
XFILLER_12_2570 vddd vssd sg13cmos5l_decap_8
XFILLER_30_1479 vddd vssd sg13cmos5l_decap_8
X_5566_ _5566_/Y _5566_/A _5581_/A _5569_/B vddd vssd sg13cmos5l_nor3_1
X_4517_ _4517_/Y _4498_/Y _4513_/Y _4804_/B1 vddd vssd sg13cmos5l_o21ai_1
X_5497_ _5497_/X _5530_/A _5483_/Y _5496_/Y vddd vssd sg13cmos5l_a21o_1
X_7305_ _7305_/Q _7328_/CLK _7305_/D _6827_/Y vddd vssd sg13cmos5l_dfrbpq_1
XFILLER_28_2065 vddd vssd sg13cmos5l_decap_8
X_4448_ _4619_/A _5542_/A _4674_/A _4642_/B vddd vssd sg13cmos5l_nand3_1
X_7236_ _7236_/Q _7292_/CLK _7236_/D fanout373/X vddd vssd sg13cmos5l_dfrbpq_1
XFILLER_8_2104 vddd vssd sg13cmos5l_decap_8
XFILLER_28_2087 vddd vssd sg13cmos5l_decap_4
X_4379_ _4393_/B _4379_/A _4379_/B vddd vssd sg13cmos5l_nand2_1
X_7167_ _7167_/Q _7210_/CLK _7167_/D fanout359/X vddd vssd sg13cmos5l_dfrbpq_1
X_7098_ _7098_/Q _7111_/CLK _7098_/D fanout404/X vddd vssd sg13cmos5l_dfrbpq_1
X_6118_ _6118_/Y _6276_/A _5148_/A _6116_/Y _6117_/Y _7295_/Q vddd vssd sg13cmos5l_a221oi_1
XFILLER_6_1182 vddd vssd sg13cmos5l_decap_8
X_6049_ _6049_/Y _6049_/A _6049_/B _6049_/C vddd vssd sg13cmos5l_nand3_1
XFILLER_17_2492 vddd vssd sg13cmos5l_decap_8
XFILLER_13_1655 vddd vssd sg13cmos5l_decap_4
XFILLER_10_698 vddd vssd sg13cmos5l_decap_4
Xtiedowns\[45\] mask_rev_in[1] vddd vssd sg13cmos5l_antennanp
XFILLER_4_2513 vddd vssd sg13cmos5l_decap_8
XFILLER_24_2474 vddd vssd sg13cmos5l_decap_8
XFILLER_24_1751 vddd vssd sg13cmos5l_decap_8
XFILLER_2_2292 vddd vssd sg13cmos5l_decap_8
XFILLER_17_297 vddd vssd sg13cmos5l_decap_4
XFILLER_18_1500 vddd vssd sg13cmos5l_decap_8
XFILLER_32_289 vddd vssd sg13cmos5l_decap_8
XFILLER_31_2401 vddd vssd sg13cmos5l_decap_8
XFILLER_20_418 vddd vssd sg13cmos5l_decap_8
XFILLER_18_1555 vddd vssd sg13cmos5l_decap_8
X_3750_ wire16/A _3786_/A wire98/X _4262_/A2 mask_rev_in[23] _3747_/Y vddd vssd sg13cmos5l_a221oi_1
XFILLER_14_1408 vddd vssd sg13cmos5l_decap_8
XFILLER_31_2478 vddd vssd sg13cmos5l_decap_8
X_3681_ _3984_/A _3874_/B _3940_/A vddd vssd sg13cmos5l_nor2_1
XFILLER_9_485 vddd vssd sg13cmos5l_decap_8
X_5420_ _5445_/C _7166_/Q _5429_/B vddd vssd sg13cmos5l_nand2_1
XFILLER_12_1154 vddd vssd sg13cmos5l_decap_8
XFILLER_31_1799 vddd vssd sg13cmos5l_decap_4
X_5351_ _5351_/X _5464_/A _7157_/Q vddd vssd sg13cmos5l_or2_1
X_5282_ _5283_/D _7028_/Q _7025_/Q vddd vssd sg13cmos5l_or2_1
X_4302_ _4302_/Y _6713_/A1 _4301_/B _4301_/Y _4312_/B vddd vssd sg13cmos5l_a22oi_1
X_7021_ _7021_/Q _7346_/CLK _7021_/D _6968_/Y vddd vssd sg13cmos5l_dfrbpq_1
XFILLER_4_190 vddd vssd sg13cmos5l_decap_8
XFILLER_9_2457 vddd vssd sg13cmos5l_decap_8
X_4233_ _4233_/Y _7162_/Q _6424_/A _4144_/B vddd vssd sg13cmos5l_a21oi_1
XFILLER_9_1767 vddd vssd sg13cmos5l_decap_8
X_4164_ _4164_/Y _7129_/Q _3842_/B _4163_/Y vddd vssd sg13cmos5l_a21oi_1
XFILLER_3_2023 vddd vssd sg13cmos5l_decap_8
X_4095_ _4095_/Y _4092_/Y _4093_/X _4094_/Y vddd vssd sg13cmos5l_o21ai_1
XFILLER_3_2078 vddd vssd sg13cmos5l_decap_8
X_6805_ _6805_/Y _6805_/A _6805_/B vddd vssd sg13cmos5l_nor2_1
X_6736_ _6777_/B _6736_/A _6736_/B vddd vssd sg13cmos5l_nor2_1
XFILLER_23_289 vddd vssd sg13cmos5l_decap_4
X_4997_ _5080_/C _7252_/Q _7253_/Q vddd vssd sg13cmos5l_nor2_1
X_3948_ _3948_/Y _5583_/B _6468_/A _3945_/Y _3942_/Y _6461_/A vddd vssd sg13cmos5l_a221oi_1
XFILLER_17_1076 vddd vssd sg13cmos5l_decap_4
X_3879_ _3881_/C _7285_/Q _6640_/A wire91/X _7281_/Q wire88/A vddd vssd sg13cmos5l_a221oi_1
X_6667_ _7298_/D _6667_/A1 _6671_/S hold824/X vddd vssd sg13cmos5l_a21oi_1
Xclkbuf_0_SCK clkbuf_0_SCK/X SCK vddd vssd sg13cmos5l_buf_8
X_5618_ _5618_/Y _5795_/A1 _5614_/Y _5617_/Y vddd vssd sg13cmos5l_a21oi_1
XFILLER_14_1986 vddd vssd sg13cmos5l_decap_8
X_6598_ _6598_/Y _6598_/A _6602_/S vddd vssd sg13cmos5l_nor2_1
X_5549_ _5549_/X _5783_/A _5557_/B vddd vssd sg13cmos5l_or2_1
XFILLER_3_7 vddd vssd sg13cmos5l_decap_8
Xfanout420 _5464_/A _5783_/A vddd vssd sg13cmos5l_buf_1
Xfanout431 _5730_/A _5871_/A vddd vssd sg13cmos5l_buf_1
X_7219_ _7219_/Q _7231_/CLK _7219_/D fanout366/X vddd vssd sg13cmos5l_dfrbpq_1
Xfanout442 _6219_/A fanout443/X vddd vssd sg13cmos5l_buf_1
Xfanout453 _6901_/A _6899_/A vddd vssd sg13cmos5l_buf_1
XFILLER_8_1288 vddd vssd sg13cmos5l_decap_8
XFILLER_27_573 vddd vssd sg13cmos5l_decap_4
XFILLER_19_2576 vddd vssd sg13cmos5l_decap_8
XFILLER_19_1831 vddd vssd sg13cmos5l_decap_8
XFILLER_9_28 vddd vssd sg13cmos5l_decap_8
Xfanout71 _6753_/A _4241_/A2 vddd vssd sg13cmos5l_buf_1
Xfanout60 _4668_/A _4575_/A vddd vssd sg13cmos5l_buf_1
XFILLER_19_1897 vddd vssd sg13cmos5l_decap_8
Xfanout82 _4256_/B _3848_/A vddd vssd sg13cmos5l_buf_1
XFILLER_7_912 vddd vssd sg13cmos5l_decap_4
XFILLER_11_974 vddd vssd sg13cmos5l_decap_8
XFILLER_13_70 vddd vssd sg13cmos5l_decap_8
XFILLER_26_2514 vddd vssd sg13cmos5l_decap_8
XFILLER_24_2271 vddd vssd sg13cmos5l_decap_8
XFILLER_20_2102 vddd vssd sg13cmos5l_decap_8
XFILLER_4_2376 vddd vssd sg13cmos5l_decap_4
XFILLER_0_1506 vddd vssd sg13cmos5l_decap_4
XFILLER_4_1697 vddd vssd sg13cmos5l_decap_8
X_4920_ _4932_/A _4920_/A _4920_/B vddd vssd sg13cmos5l_nand2_1
XFILLER_21_705 vddd vssd sg13cmos5l_decap_8
X_4851_ _4851_/Y _4832_/B _4852_/A vddd vssd sg13cmos5l_nand2b_1
X_3802_ _3802_/Y _3802_/A _3802_/B _3802_/C vddd vssd sg13cmos5l_nand3_1
XFILLER_18_2097 vddd vssd sg13cmos5l_decap_8
XFILLER_18_1352 vddd vssd sg13cmos5l_decap_8
X_4782_ _4782_/Y _4782_/A _4782_/B vddd vssd sg13cmos5l_xnor2_1
X_3733_ _4253_/A _3734_/A wire95/X vddd vssd sg13cmos5l_and2_1
X_6521_ _6521_/Y _6521_/A1 _6520_/B _6520_/Y vddd vssd sg13cmos5l_a21oi_1
X_3664_ _3928_/A _4339_/B _4348_/A _3672_/S vddd vssd sg13cmos5l_mux2_1
X_6452_ _6452_/Y _6452_/A1 _6451_/B _6451_/Y vddd vssd sg13cmos5l_a21oi_1
X_5403_ _5403_/Y _7165_/Q _5403_/B vddd vssd sg13cmos5l_nor2_1
X_6383_ _7140_/D _6759_/A _6382_/B hold742/X vddd vssd sg13cmos5l_o21ai_1
X_3595_ _4786_/B _3595_/A vddd vssd sg13cmos5l_inv_1
XFILLER_25_2013 vddd vssd sg13cmos5l_decap_8
X_5334_ _5334_/Y _5331_/A _5333_/Y _5331_/B vddd vssd sg13cmos5l_o21ai_1
Xoutbuffers\[76\] io_oe[3] _5103_/X vddd vssd sg13cmos5l_buf_16
XFILLER_0_609 vddd vssd sg13cmos5l_decap_8
X_5265_ _5269_/B _5265_/A _5265_/B vddd vssd sg13cmos5l_or2_1
XFILLER_9_1531 vddd vssd sg13cmos5l_decap_8
XFILLER_9_2254 vddd vssd sg13cmos5l_decap_8
XFILLER_29_1492 vddd vssd sg13cmos5l_decap_8
X_7004_ _7004_/Q _7355_/CLK _7004_/D _6951_/Y vddd vssd sg13cmos5l_dfrbpq_1
X_4216_ _4216_/Y _7214_/Q _3922_/Y _3925_/Y vddd vssd sg13cmos5l_o21ai_1
X_5196_ _5258_/B _7248_/Q _7249_/Q vddd vssd sg13cmos5l_nand2b_1
XFILLER_28_315 vddd vssd sg13cmos5l_decap_8
XFILLER_21_1209 vddd vssd sg13cmos5l_decap_8
X_4147_ _4147_/Y _5318_/B _6402_/A _4145_/Y _4146_/Y _4238_/B vddd vssd sg13cmos5l_a221oi_1
X_4078_ _4078_/Y _7098_/Q _3848_/A _4172_/A2 vddd vssd sg13cmos5l_a21oi_1
XFILLER_32_2028 vddd vssd sg13cmos5l_decap_8
XFILLER_32_1338 vddd vssd sg13cmos5l_decap_8
X_6719_ _6719_/Y _6719_/A _6725_/S vddd vssd sg13cmos5l_nor2_1
Xclkload2 clkload2/Y clkload2/A vddd vssd sg13cmos5l_inv_1
XFILLER_20_793 vddd vssd sg13cmos5l_decap_8
XFILLER_14_2484 vddd vssd sg13cmos5l_decap_8
XFILLER_3_458 vddd vssd sg13cmos5l_decap_8
Xfanout250 _4762_/B fanout254/X vddd vssd sg13cmos5l_buf_1
XFILLER_25_2580 vddd vssd sg13cmos5l_decap_8
Xfanout272 _5245_/A _7250_/Q vddd vssd sg13cmos5l_buf_1
Xfanout283 _5794_/B hold1330/X vddd vssd sg13cmos5l_buf_1
Xfanout261 _4909_/B1 _7302_/Q vddd vssd sg13cmos5l_buf_1
Xfanout294 _5557_/B _7185_/Q vddd vssd sg13cmos5l_buf_1
XFILLER_21_2444 vddd vssd sg13cmos5l_decap_8
XFILLER_21_1732 vddd vssd sg13cmos5l_decap_8
XFILLER_19_2395 vddd vssd sg13cmos5l_decap_4
XFILLER_15_2237 vddd vssd sg13cmos5l_decap_4
XFILLER_32_2551 vddd vssd sg13cmos5l_decap_8
XFILLER_24_91 vddd vssd sg13cmos5l_decap_8
Xhold709 _7280_/D _6638_/X vddd vssd sg13cmos5l_dlygate4sd3_1
XFILLER_6_285 vddd vssd sg13cmos5l_decap_8
XFILLER_13_1293 vddd vssd sg13cmos5l_decap_8
XFILLER_26_2388 vddd vssd sg13cmos5l_decap_8
XFILLER_26_1632 vddd vssd sg13cmos5l_decap_8
X_5050_ _5241_/A _7258_/Q _7259_/Q vddd vssd sg13cmos5l_nor2b_1
Xhold1409 _7189_/D _6474_/X vddd vssd sg13cmos5l_dlygate4sd3_1
X_4001_ _4001_/Y _4179_/A1 sram_odata[3] _3758_/X wire5/X _4300_/B vddd vssd sg13cmos5l_a221oi_1
XFILLER_6_1737 vddd vssd sg13cmos5l_decap_8
XFILLER_26_819 vddd vssd sg13cmos5l_decap_8
XFILLER_1_73 vddd vssd sg13cmos5l_decap_8
XFILLER_25_329 vddd vssd sg13cmos5l_decap_8
XFILLER_4_1494 vddd vssd sg13cmos5l_decap_8
X_5952_ _5952_/Y _3539_/Y _5974_/B _5956_/A vddd vssd sg13cmos5l_a21oi_1
X_4903_ _4904_/B _4903_/A _4912_/C vddd vssd sg13cmos5l_nor2_1
X_5883_ _5899_/C _5901_/A _5901_/B vddd vssd sg13cmos5l_nand2_1
XFILLER_21_524 vddd vssd sg13cmos5l_decap_8
X_4834_ _4834_/Y _4853_/A sram_odata[7] _4833_/Y vddd vssd sg13cmos5l_o21ai_1
X_4765_ _4765_/Y _4765_/A _4765_/B vddd vssd sg13cmos5l_xnor2_1
X_6504_ _7204_/D _6504_/A1 _6505_/S _6503_/Y vddd vssd sg13cmos5l_a21oi_1
X_3716_ _6346_/A _3846_/A _3959_/A vddd vssd sg13cmos5l_nor2_1
X_4696_ _4697_/B _4689_/Y _4690_/Y _4695_/Y vddd vssd sg13cmos5l_a21oi_1
XFILLER_20_49 vddd vssd sg13cmos5l_decap_8
X_6435_ _7167_/D _6435_/A1 _6437_/S _6434_/Y vddd vssd sg13cmos5l_a21oi_1
X_3647_ _3648_/A _4836_/B _4841_/B _3647_/C vddd vssd sg13cmos5l_nor3_1
X_6366_ _6366_/X hold861/X _6788_/A1 _6372_/S vddd vssd sg13cmos5l_mux2_1
X_3578_ _5752_/B _3578_/A vddd vssd sg13cmos5l_inv_1
X_5317_ _5320_/A _5544_/A _5318_/B _5327_/A vddd vssd sg13cmos5l_nor3_1
XFILLER_0_406 vddd vssd sg13cmos5l_decap_8
X_6297_ _6297_/X _7078_/Q _6294_/Y _6296_/Y vddd vssd sg13cmos5l_a21o_1
XFILLER_29_14 vddd vssd sg13cmos5l_decap_8
X_5248_ _6239_/B _5248_/A _5256_/B vddd vssd sg13cmos5l_nor2_1
XFILLER_5_1247 vddd vssd sg13cmos5l_decap_4
X_5179_ _5186_/B _5258_/A _5179_/B vddd vssd sg13cmos5l_nand2b_1
XFILLER_28_134 vddd vssd sg13cmos5l_decap_8
XFILLER_17_808 vddd vssd sg13cmos5l_decap_8
XFILLER_32_1102 vddd vssd sg13cmos5l_decap_8
XFILLER_16_2568 vddd vssd sg13cmos5l_decap_8
XFILLER_16_1856 vddd vssd sg13cmos5l_decap_8
XFILLER_32_1179 vddd vssd sg13cmos5l_decap_8
XFILLER_20_590 vddd vssd sg13cmos5l_decap_8
XFILLER_4_767 vddd vssd sg13cmos5l_decap_8
XFILLER_27_1930 vddd vssd sg13cmos5l_decap_8
XFILLER_23_2517 vddd vssd sg13cmos5l_decap_8
XFILLER_0_973 vddd vssd sg13cmos5l_decap_8
XFILLER_23_1827 vddd vssd sg13cmos5l_decap_8
XFILLER_19_112 vddd vssd sg13cmos5l_decap_8
XFILLER_19_91 vddd vssd sg13cmos5l_decap_8
XFILLER_21_2296 vddd vssd sg13cmos5l_decap_4
XFILLER_5_1781 vddd vssd sg13cmos5l_decap_4
XFILLER_31_833 vddd vssd sg13cmos5l_decap_4
XFILLER_15_2001 vddd vssd sg13cmos5l_decap_4
XFILLER_15_1300 vddd vssd sg13cmos5l_decap_8
XFILLER_31_899 vddd vssd sg13cmos5l_decap_8
X_4550_ _4550_/Y _4524_/B _4549_/X _4736_/B1 vddd vssd sg13cmos5l_a21oi_1
Xhold506 _3469_/A _7019_/Q vddd vssd sg13cmos5l_dlygate4sd3_1
Xhold517 _6996_/D _3480_/Y vddd vssd sg13cmos5l_dlygate4sd3_1
X_4481_ _4486_/A _4736_/B1 _4480_/Y _4478_/Y vddd vssd sg13cmos5l_a21oi_1
X_3501_ _6012_/A _7337_/Q vddd vssd sg13cmos5l_inv_1
Xhold539 _7012_/D _3472_/Y vddd vssd sg13cmos5l_dlygate4sd3_1
X_6220_ _6220_/Y _5888_/A _6232_/B _6218_/Y vddd vssd sg13cmos5l_o21ai_1
Xhold528 _4733_/A _6987_/Q vddd vssd sg13cmos5l_dlygate4sd3_1
X_6151_ _6151_/Y _6267_/A1 _5184_/A _5183_/A vddd vssd sg13cmos5l_o21ai_1
X_5102_ _5103_/C _5102_/A _6074_/B _5102_/C _5102_/D vddd vssd sg13cmos5l_nand4_1
XFILLER_25_0 vddd vssd sg13cmos5l_decap_8
X_6082_ _6082_/Y _6239_/A _6082_/B vddd vssd sg13cmos5l_nor2_1
Xhold1206 _3581_/A _7316_/Q vddd vssd sg13cmos5l_dlygate4sd3_1
Xhold1217 _7070_/D _6758_/X vddd vssd sg13cmos5l_dlygate4sd3_1
XFILLER_26_1462 vddd vssd sg13cmos5l_decap_4
Xhold1228 _6579_/A1 _7243_/Q vddd vssd sg13cmos5l_dlygate4sd3_1
X_5033_ _5136_/A _7255_/Q _7254_/Q vddd vssd sg13cmos5l_nand2b_1
Xhold1239 _3592_/A _7232_/Q vddd vssd sg13cmos5l_dlygate4sd3_1
Xoutbuffers\[39\] bandgap_trim[0] _6285_/Y vddd vssd sg13cmos5l_buf_16
XFILLER_26_605 vddd vssd sg13cmos5l_decap_8
XFILLER_22_1348 vddd vssd sg13cmos5l_decap_8
XFILLER_0_1100 vddd vssd sg13cmos5l_decap_8
X_6984_ _6984_/Q _7355_/CLK _6984_/D _6931_/Y vddd vssd sg13cmos5l_dfrbpq_1
X_5935_ _5939_/B _5936_/A _5936_/B vddd vssd sg13cmos5l_and2_1
XFILLER_15_49 vddd vssd sg13cmos5l_decap_8
X_5866_ _5866_/Y _5868_/C _5857_/Y _5873_/C _5865_/Y _5863_/Y vddd vssd sg13cmos5l_a221oi_1
XFILLER_22_855 vddd vssd sg13cmos5l_decap_4
XFILLER_16_1119 vddd vssd sg13cmos5l_decap_8
X_4817_ _4822_/A _4821_/A _4817_/B vddd vssd sg13cmos5l_nor2_1
X_5797_ _5797_/Y _5797_/A1 _5768_/Y _5796_/Y vddd vssd sg13cmos5l_a21oi_1
XFILLER_31_37 vddd vssd sg13cmos5l_decap_8
X_4748_ _4748_/Y _4446_/C _4740_/B _4769_/A1 vddd vssd sg13cmos5l_o21ai_1
X_4679_ _4680_/B _4668_/Y _4676_/Y _4746_/B1 vddd vssd sg13cmos5l_o21ai_1
X_6418_ _6418_/Y _6754_/A _6423_/S vddd vssd sg13cmos5l_nor2_1
X_7398_ _7398_/Q _7398_/CLK _7398_/D _6911_/Y vddd vssd sg13cmos5l_dfrbpq_1
XFILLER_0_214 vddd vssd sg13cmos5l_decap_8
X_6349_ _6349_/Y _6349_/A _6361_/B vddd vssd sg13cmos5l_nand2_1
XFILLER_27_1248 vddd vssd sg13cmos5l_decap_8
XFILLER_22_2583 vddd vssd sg13cmos5l_decap_8
XFILLER_5_1099 vddd vssd sg13cmos5l_decap_8
XFILLER_31_107 vddd vssd sg13cmos5l_decap_8
XFILLER_25_671 vddd vssd sg13cmos5l_decap_8
XFILLER_9_815 vddd vssd sg13cmos5l_decap_8
XFILLER_16_1664 vddd vssd sg13cmos5l_decap_8
XFILLER_16_1631 vddd vssd sg13cmos5l_decap_4
XFILLER_12_2218 vddd vssd sg13cmos5l_decap_8
Xtiedowns\[75\] mask_rev_in[31] vddd vssd sg13cmos5l_antennanp
XFILLER_12_1539 vddd vssd sg13cmos5l_decap_8
XFILLER_21_70 vddd vssd sg13cmos5l_decap_8
XFILLER_27_2450 vddd vssd sg13cmos5l_decap_8
XFILLER_7_2522 vddd vssd sg13cmos5l_decap_8
XFILLER_27_1782 vddd vssd sg13cmos5l_decap_8
XFILLER_23_1602 vddd vssd sg13cmos5l_decap_8
XFILLER_7_1865 vddd vssd sg13cmos5l_decap_4
XFILLER_7_2599 vddd vssd sg13cmos5l_decap_8
XFILLER_7_1898 vddd vssd sg13cmos5l_decap_8
XFILLER_23_1668 vddd vssd sg13cmos5l_decap_8
XFILLER_21_2071 vddd vssd sg13cmos5l_decap_4
XFILLER_21_1381 vddd vssd sg13cmos5l_decap_8
X_3981_ _6739_/A _3981_/A _3984_/B vddd vssd sg13cmos5l_nand2_1
XFILLER_17_2107 vddd vssd sg13cmos5l_decap_4
X_5720_ _5720_/Y _5627_/A _7208_/Q _5733_/C vddd vssd sg13cmos5l_o21ai_1
X_5651_ _5651_/Y _7198_/Q _7199_/Q _5673_/A _7201_/Q vddd vssd sg13cmos5l_nor4_1
XFILLER_30_184 vddd vssd sg13cmos5l_decap_8
X_5582_ _5582_/Y _5757_/A _5579_/Y _5581_/Y vddd vssd sg13cmos5l_a21oi_1
X_4602_ _4626_/B _6121_/A _4628_/A vddd vssd sg13cmos5l_nor2_1
XFILLER_15_1163 vddd vssd sg13cmos5l_decap_8
XFILLER_30_1639 vddd vssd sg13cmos5l_decap_8
X_4533_ _4536_/B _4533_/A _4533_/B vddd vssd sg13cmos5l_nor2_1
X_7321_ _7321_/Q _7338_/CLK _7321_/D _7321_/RESET_B vddd vssd sg13cmos5l_dfrbpq_1
XFILLER_7_72 vddd vssd sg13cmos5l_decap_8
XFILLER_8_892 vddd vssd sg13cmos5l_decap_8
XFILLER_11_1016 vddd vssd sg13cmos5l_decap_8
X_7252_ _7252_/Q _7258_/CLK _7252_/D fanout382/X vddd vssd sg13cmos5l_dfrbpq_1
X_6203_ _6203_/Y _6136_/A _5233_/C _5233_/B vddd vssd sg13cmos5l_a21oi_1
X_4464_ _4465_/B _4778_/A _4754_/A vddd vssd sg13cmos5l_nor2b_1
X_7183_ _7183_/Q _7189_/CLK _7183_/D fanout360/X vddd vssd sg13cmos5l_dfrbpq_1
Xclkbuf_leaf_0_SCK_regs _7404_/CLK clkbuf_3_0_0_SCK_regs/X vddd vssd sg13cmos5l_buf_8
X_4395_ _4395_/Y _4821_/A vddd vssd sg13cmos5l_inv_1
X_6134_ _6135_/B _6144_/A _5157_/Y _6136_/B vddd vssd sg13cmos5l_o21ai_1
X_6065_ _6065_/Y _6267_/A1 _5101_/C _6064_/Y vddd vssd sg13cmos5l_a21oi_1
Xhold1014 _3561_/A _7180_/Q vddd vssd sg13cmos5l_dlygate4sd3_1
Xhold1003 _3513_/A _7242_/Q vddd vssd sg13cmos5l_dlygate4sd3_1
X_5016_ _6188_/B _5212_/B _5212_/A vddd vssd sg13cmos5l_nand2b_1
Xhold1058 _6719_/A _7045_/Q vddd vssd sg13cmos5l_dlygate4sd3_1
Xhold1047 _5280_/A1 _4342_/A vddd vssd sg13cmos5l_dlygate4sd3_1
Xhold1036 _7156_/D _6415_/Y vddd vssd sg13cmos5l_dlygate4sd3_1
Xhold1025 hold494/A hold1512/X vddd vssd sg13cmos5l_dlygate4sd3_1
XFILLER_27_914 vddd vssd sg13cmos5l_decap_8
Xhold1069 _7255_/D _6600_/X vddd vssd sg13cmos5l_dlygate4sd3_1
XFILLER_26_48 vddd vssd sg13cmos5l_decap_8
X_6967_ _6967_/Y _6969_/A _6968_/B_N vddd vssd sg13cmos5l_nor2b_1
X_5918_ _5918_/Y _7101_/Q _5939_/A vddd vssd sg13cmos5l_nor2b_1
X_6898_ _6898_/Y _6898_/A _6901_/B_N vddd vssd sg13cmos5l_nor2b_1
XFILLER_22_674 vddd vssd sg13cmos5l_decap_8
XFILLER_13_2527 vddd vssd sg13cmos5l_decap_8
X_5849_ _5849_/Y _5873_/A _5847_/A _5847_/Y _5844_/Y _5848_/X vddd vssd sg13cmos5l_a221oi_1
XFILLER_10_825 vddd vssd sg13cmos5l_decap_8
XFILLER_13_1848 vddd vssd sg13cmos5l_decap_8
Xhold881 hold881/X _7184_/Q vddd vssd sg13cmos5l_dlygate4sd3_1
Xhold870 _3553_/A _7164_/Q vddd vssd sg13cmos5l_dlygate4sd3_1
Xhold892 hold892/X hold892/A vddd vssd sg13cmos5l_dlygate4sd3_1
XFILLER_29_273 vddd vssd sg13cmos5l_decap_8
XFILLER_20_1819 vddd vssd sg13cmos5l_decap_8
XFILLER_22_1690 vddd vssd sg13cmos5l_decap_8
XFILLER_2_2485 vddd vssd sg13cmos5l_decap_8
XFILLER_16_70 vddd vssd sg13cmos5l_decap_8
XFILLER_13_652 vddd vssd sg13cmos5l_decap_8
XFILLER_16_2195 vddd vssd sg13cmos5l_decap_4
XFILLER_16_1461 vddd vssd sg13cmos5l_decap_8
XFILLER_32_91 vddd vssd sg13cmos5l_decap_8
XFILLER_29_2534 vddd vssd sg13cmos5l_decap_8
XFILLER_29_1844 vddd vssd sg13cmos5l_decap_8
XFILLER_29_1866 vddd vssd sg13cmos5l_decap_8
X_4180_ _4180_/Y _4182_/A _4267_/B _4267_/A vddd vssd sg13cmos5l_o21ai_1
XFILLER_3_2227 vddd vssd sg13cmos5l_decap_4
XFILLER_7_1662 vddd vssd sg13cmos5l_decap_8
X_6821_ _6821_/Y CSB _6914_/B_N vddd vssd sg13cmos5l_nor2b_1
XFILLER_17_991 vddd vssd sg13cmos5l_decap_8
X_6752_ _6752_/X _6759_/A _6752_/A1 _6752_/S vddd vssd sg13cmos5l_mux2_1
X_3964_ _6417_/A _6597_/B _6395_/B vddd vssd sg13cmos5l_nor2_1
XFILLER_32_983 vddd vssd sg13cmos5l_decap_8
Xoutbuffers\[2\] analog_bus_ena[0] _7036_/Q vddd vssd sg13cmos5l_buf_16
X_5703_ _5704_/B _5705_/C _5700_/Y _5705_/B vddd vssd sg13cmos5l_a21oi_1
X_3895_ _6576_/A _6597_/A _6395_/A vddd vssd sg13cmos5l_nor2_1
X_6683_ _6683_/X _6683_/A0 sram_odata[5] _6683_/S vddd vssd sg13cmos5l_mux2_1
X_5634_ _5634_/Y _6212_/A1 _5632_/A _5647_/B vddd vssd sg13cmos5l_o21ai_1
XFILLER_12_28 vddd vssd sg13cmos5l_decap_8
X_5565_ _5579_/A _5569_/B _5581_/A vddd vssd sg13cmos5l_nand2b_1
X_7304_ _7304_/Q _7400_/CLK _7304_/D _6826_/Y vddd vssd sg13cmos5l_dfrbpq_1
X_4516_ _4516_/Y _4806_/A _4485_/B vddd vssd sg13cmos5l_nor2b_1
XFILLER_2_309 vddd vssd sg13cmos5l_decap_4
X_5496_ _5496_/Y _5586_/A _7175_/Q _5498_/A vddd vssd sg13cmos5l_a21oi_1
X_4447_ _4642_/B _6057_/A _4664_/B vddd vssd sg13cmos5l_nor2_1
X_7235_ _7235_/Q _7292_/CLK _7235_/D fanout373/X vddd vssd sg13cmos5l_dfrbpq_1
X_7166_ _7166_/Q _7214_/CLK _7166_/D fanout359/X vddd vssd sg13cmos5l_dfrbpq_1
XFILLER_8_1415 vddd vssd sg13cmos5l_decap_8
X_4378_ _4379_/B _5315_/A _7121_/Q vddd vssd sg13cmos5l_xor2_1
X_6117_ _6117_/Y _6136_/A _5148_/B _5148_/A vddd vssd sg13cmos5l_a21oi_1
X_7097_ _7097_/Q _7135_/CLK _7097_/D _6969_/B_N vddd vssd sg13cmos5l_dfrbpq_1
X_6048_ _6048_/Y _6144_/A _5068_/B _6047_/Y vddd vssd sg13cmos5l_o21ai_1
XFILLER_14_449 vddd vssd sg13cmos5l_decap_8
XFILLER_23_972 vddd vssd sg13cmos5l_decap_4
XFILLER_17_2471 vddd vssd sg13cmos5l_decap_8
XFILLER_17_1770 vddd vssd sg13cmos5l_decap_4
XFILLER_13_1612 vddd vssd sg13cmos5l_decap_4
XFILLER_13_1634 vddd vssd sg13cmos5l_decap_8
XFILLER_10_677 vddd vssd sg13cmos5l_decap_8
XFILLER_13_1678 vddd vssd sg13cmos5l_decap_8
Xtiedowns\[38\] dbus_in_right[6] vddd vssd sg13cmos5l_antennanp
XFILLER_24_2453 vddd vssd sg13cmos5l_decap_8
XFILLER_20_2317 vddd vssd sg13cmos5l_decap_8
X_6906__471 _7393_/CLK _7164_/CLK vddd vssd sg13cmos5l_inv_1
XFILLER_20_1605 vddd vssd sg13cmos5l_decap_8
XFILLER_17_276 vddd vssd sg13cmos5l_decap_8
XFILLER_32_224 vddd vssd sg13cmos5l_decap_4
XFILLER_32_268 vddd vssd sg13cmos5l_decap_8
XFILLER_31_2457 vddd vssd sg13cmos5l_decap_8
X_3680_ _3902_/B _3753_/C _3753_/D vddd vssd sg13cmos5l_nand2_1
X_5350_ _5350_/Y _5348_/Y _5349_/Y _5345_/Y vddd vssd sg13cmos5l_a21oi_1
X_4301_ _4301_/Y _4301_/A _4301_/B vddd vssd sg13cmos5l_nor2_1
X_5281_ _5281_/X _5279_/A _4315_/B _4272_/A vddd vssd sg13cmos5l_a21o_1
X_7020_ _7020_/Q _7020_/CLK _7020_/D _6967_/Y vddd vssd sg13cmos5l_dfrbpq_1
XFILLER_29_1641 vddd vssd sg13cmos5l_decap_4
X_4232_ _4232_/X _4229_/Y _4230_/Y _4231_/Y vddd vssd sg13cmos5l_a21o_1
XFILLER_4_95 vddd vssd sg13cmos5l_decap_4
XFILLER_9_1746 vddd vssd sg13cmos5l_decap_8
X_4163_ _4163_/Y _7121_/Q _3717_/Y _6329_/A vddd vssd sg13cmos5l_o21ai_1
X_4094_ _4094_/Y _7299_/Q wire92/X _4189_/B1 vddd vssd sg13cmos5l_a21oi_1
XFILLER_3_1334 vddd vssd sg13cmos5l_decap_8
Xoutbuffers\[21\] voltgen_source[2] _7075_/Q vddd vssd sg13cmos5l_buf_16
X_4996_ _5010_/A _7270_/Q _7271_/Q _7272_/Q _7273_/Q vddd vssd sg13cmos5l_nor4_1
X_6804_ _6804_/Y hold739/X _6803_/B _6803_/Y vddd vssd sg13cmos5l_o21ai_1
X_6735_ _6735_/X _6342_/A _6735_/A1 _6735_/S vddd vssd sg13cmos5l_mux2_1
X_3947_ _3947_/Y _3947_/A _3966_/B vddd vssd sg13cmos5l_nand2_1
XFILLER_17_1033 vddd vssd sg13cmos5l_decap_8
XFILLER_11_408 vddd vssd sg13cmos5l_decap_8
XFILLER_32_1509 vddd vssd sg13cmos5l_decap_8
XFILLER_32_780 vddd vssd sg13cmos5l_decap_8
XFILLER_23_49 vddd vssd sg13cmos5l_decap_8
X_3878_ wire88/A _3878_/A _3878_/B _3878_/C _4010_/C vddd vssd sg13cmos5l_nor4_1
X_6666_ _6666_/Y _6666_/A _6671_/S vddd vssd sg13cmos5l_nor2_1
XFILLER_20_986 vddd vssd sg13cmos5l_decap_8
XFILLER_14_1921 vddd vssd sg13cmos5l_decap_8
XFILLER_10_2519 vddd vssd sg13cmos5l_decap_8
X_5617_ _5617_/Y _7192_/Q _7193_/Q _5617_/C vddd vssd sg13cmos5l_nor3_1
X_6597_ _6602_/S _6597_/A _6597_/B _6736_/B vddd vssd sg13cmos5l_nor3_1
X_5548_ _5552_/B _5560_/C _5553_/C vddd vssd sg13cmos5l_nor2_1
XFILLER_10_1829 vddd vssd sg13cmos5l_decap_8
X_7218_ _7218_/Q _7228_/CLK _7218_/D fanout366/X vddd vssd sg13cmos5l_dfrbpq_1
X_5479_ _5479_/Y _5498_/C _7177_/Q vddd vssd sg13cmos5l_nor2_1
Xfanout410 fanout410/X fanout411/X vddd vssd sg13cmos5l_buf_1
XFILLER_28_1140 vddd vssd sg13cmos5l_decap_8
Xfanout421 _5783_/A _6224_/A vddd vssd sg13cmos5l_buf_1
Xfanout432 _5871_/A io_in[3] vddd vssd sg13cmos5l_buf_1
Xfanout443 fanout443/X io_in[11] vddd vssd sg13cmos5l_buf_1
X_7149_ _7149_/Q _7190_/CLK _7149_/D fanout358/X vddd vssd sg13cmos5l_dfrbpq_1
Xfanout454 _6899_/A _6879_/A vddd vssd sg13cmos5l_buf_1
XFILLER_21_1936 vddd vssd sg13cmos5l_decap_8
XFILLER_3_2591 vddd vssd sg13cmos5l_decap_8
XFILLER_19_2555 vddd vssd sg13cmos5l_decap_8
XFILLER_19_1810 vddd vssd sg13cmos5l_decap_8
XFILLER_30_728 vddd vssd sg13cmos5l_decap_8
Xfanout50 _6709_/S _6710_/S vddd vssd sg13cmos5l_buf_1
Xfanout72 _4241_/A2 _3795_/Y vddd vssd sg13cmos5l_buf_1
Xfanout61 _4575_/A _4528_/A vddd vssd sg13cmos5l_buf_1
XFILLER_15_1729 vddd vssd sg13cmos5l_decap_8
Xfanout83 _3848_/A _3686_/Y vddd vssd sg13cmos5l_buf_1
XFILLER_11_953 vddd vssd sg13cmos5l_decap_8
XFILLER_6_434 vddd vssd sg13cmos5l_decap_8
XFILLER_7_957 vddd vssd sg13cmos5l_decap_8
XFILLER_30_2490 vddd vssd sg13cmos5l_decap_8
XFILLER_2_640 vddd vssd sg13cmos5l_decap_4
XFILLER_29_7 vddd vssd sg13cmos5l_decap_8
XFILLER_8_2480 vddd vssd sg13cmos5l_decap_8
XFILLER_4_1610 vddd vssd sg13cmos5l_decap_4
XFILLER_4_1676 vddd vssd sg13cmos5l_decap_8
XFILLER_20_1479 vddd vssd sg13cmos5l_decap_8
X_4850_ _4850_/Y _4832_/Y _4849_/Y hold603/X vddd vssd sg13cmos5l_o21ai_1
Xoutbuffers\[111\] dbus_out[14] _5707_/X vddd vssd sg13cmos5l_buf_16
X_3801_ _3802_/C _7055_/Q _6726_/A wire70/A _7082_/Q vddd vssd sg13cmos5l_a22oi_1
XFILLER_18_1364 vddd vssd sg13cmos5l_decap_8
X_6520_ _6520_/Y _6520_/A _6520_/B vddd vssd sg13cmos5l_nor2_1
X_4781_ _4782_/B _4781_/A _4798_/B vddd vssd sg13cmos5l_nor2_1
XFILLER_13_290 vddd vssd sg13cmos5l_decap_4
X_3732_ wire95/A _3874_/C _4009_/B vddd vssd sg13cmos5l_nor2_1
X_3663_ _3693_/B _4325_/A _4339_/B _3672_/S vddd vssd sg13cmos5l_mux2_1
X_6451_ _6451_/Y _6459_/A _6451_/B vddd vssd sg13cmos5l_nor2_1
X_6382_ _6382_/Y _6382_/A _6382_/B vddd vssd sg13cmos5l_nand2_1
X_5402_ _5403_/B _5727_/A _5398_/B _5416_/C _5326_/A vddd vssd sg13cmos5l_a22oi_1
X_5333_ _5333_/Y _5586_/A _5314_/Y _5332_/Y vddd vssd sg13cmos5l_o21ai_1
X_3594_ _3594_/Y _3594_/A vddd vssd sg13cmos5l_inv_1
Xoutbuffers\[69\] idac1_value[1] _7041_/Q vddd vssd sg13cmos5l_buf_16
X_5264_ _6266_/A _5173_/A _5264_/B vddd vssd sg13cmos5l_nand2b_1
X_7003_ _7003_/Q clkload1/A _7003_/D _6950_/Y vddd vssd sg13cmos5l_dfrbpq_1
X_5195_ _5195_/Y _5245_/A _7251_/Q _5267_/B vddd vssd sg13cmos5l_nor3_1
X_4215_ _4215_/Y _7222_/Q _6538_/A _6529_/A _7218_/Q _6522_/A vddd vssd sg13cmos5l_a221oi_1
XFILLER_25_1357 vddd vssd sg13cmos5l_decap_8
XFILLER_9_1598 vddd vssd sg13cmos5l_decap_8
X_4146_ _4146_/Y _5348_/B _6410_/A _6402_/A vddd vssd sg13cmos5l_a21oi_1
XFILLER_18_49 vddd vssd sg13cmos5l_decap_8
X_4077_ _4077_/Y _4074_/Y _4075_/Y _4076_/Y vddd vssd sg13cmos5l_o21ai_1
XFILLER_24_511 vddd vssd sg13cmos5l_decap_8
XFILLER_3_1197 vddd vssd sg13cmos5l_decap_4
X_4979_ sram_idata[7] _6344_/A _4979_/B vddd vssd sg13cmos5l_and2_1
XFILLER_32_1328 vddd vssd sg13cmos5l_decap_4
X_6718_ _6725_/S _6718_/A _6762_/C vddd vssd sg13cmos5l_nor2_1
XFILLER_14_2463 vddd vssd sg13cmos5l_decap_8
Xclkload3 clkload3/X clkload3/A vddd vssd sg13cmos5l_buf_8
X_6649_ _7287_/D _6649_/A0 _6636_/A _6652_/S vddd vssd sg13cmos5l_mux2_1
XFILLER_14_1773 vddd vssd sg13cmos5l_decap_8
Xfanout240 _5542_/A _7341_/Q vddd vssd sg13cmos5l_buf_1
Xfanout251 _4620_/B fanout254/X vddd vssd sg13cmos5l_buf_1
Xfanout273 _5130_/A hold1377/X vddd vssd sg13cmos5l_buf_1
Xfanout262 _6057_/B _7300_/Q vddd vssd sg13cmos5l_buf_1
Xfanout295 _5557_/A _7184_/Q vddd vssd sg13cmos5l_buf_1
Xfanout284 _5794_/A _7216_/Q vddd vssd sg13cmos5l_buf_1
XFILLER_5_1996 vddd vssd sg13cmos5l_decap_8
XFILLER_28_894 vddd vssd sg13cmos5l_decap_8
XFILLER_19_1651 vddd vssd sg13cmos5l_decap_8
XFILLER_15_1504 vddd vssd sg13cmos5l_decap_8
XFILLER_32_2530 vddd vssd sg13cmos5l_decap_8
XFILLER_24_70 vddd vssd sg13cmos5l_decap_8
XFILLER_11_783 vddd vssd sg13cmos5l_decap_8
XFILLER_32_1873 vddd vssd sg13cmos5l_decap_8
XFILLER_13_1261 vddd vssd sg13cmos5l_decap_8
XFILLER_32_1895 vddd vssd sg13cmos5l_decap_8
XFILLER_7_787 vddd vssd sg13cmos5l_decap_8
XFILLER_3_982 vddd vssd sg13cmos5l_decap_8
XFILLER_26_2367 vddd vssd sg13cmos5l_decap_8
X_4000_ wire5/A _3998_/Y _4000_/B vddd vssd sg13cmos5l_nand2b_1
XFILLER_6_1716 vddd vssd sg13cmos5l_decap_8
XFILLER_24_1390 vddd vssd sg13cmos5l_decap_8
XFILLER_25_308 vddd vssd sg13cmos5l_decap_8
XFILLER_20_1265 vddd vssd sg13cmos5l_decap_8
X_5951_ _5951_/X _6211_/A _7238_/Q _7239_/Q vddd vssd sg13cmos5l_or3_1
X_4902_ _4912_/C hold636/X _4902_/B vddd vssd sg13cmos5l_nand2b_1
XFILLER_21_503 vddd vssd sg13cmos5l_decap_8
X_5882_ _5896_/A _5880_/Y _5881_/Y _5886_/C vddd vssd sg13cmos5l_o21ai_1
XFILLER_21_536 vddd vssd sg13cmos5l_decap_8
X_4833_ _4833_/Y _3504_/Y _3648_/A _4826_/Y vddd vssd sg13cmos5l_o21ai_1
X_4764_ _4767_/B _4769_/A1 _4763_/Y _4761_/X vddd vssd sg13cmos5l_o21ai_1
X_6503_ _6503_/Y _6558_/A _6505_/S vddd vssd sg13cmos5l_nor2_1
X_3715_ _3959_/A _3874_/B _3938_/B vddd vssd sg13cmos5l_or2_1
X_6434_ _6434_/Y _6464_/A _6437_/S vddd vssd sg13cmos5l_nor2_1
X_4695_ _4695_/Y _4745_/A1 _4694_/Y _4650_/A vddd vssd sg13cmos5l_a21oi_1
XFILLER_20_28 vddd vssd sg13cmos5l_decap_8
X_3646_ _3647_/C _4847_/A _4853_/B vddd vssd sg13cmos5l_or2_1
X_6365_ _7128_/D _6738_/A1 _6372_/S hold707/X vddd vssd sg13cmos5l_a21oi_1
X_3577_ _5748_/B _3577_/A vddd vssd sg13cmos5l_inv_1
XFILLER_11_1979 vddd vssd sg13cmos5l_decap_8
X_6296_ _6296_/Y _6285_/B _3628_/Y _6294_/A vddd vssd sg13cmos5l_a21oi_1
X_5316_ _5321_/A _5314_/Y _5315_/Y _5327_/A vddd vssd sg13cmos5l_o21ai_1
X_5247_ _5251_/D _7246_/Q _5247_/B _5258_/B vddd vssd sg13cmos5l_nor3_1
XFILLER_28_113 vddd vssd sg13cmos5l_decap_8
XFILLER_21_1018 vddd vssd sg13cmos5l_decap_4
X_5178_ _6158_/B _5263_/A _5178_/B vddd vssd sg13cmos5l_nand2b_1
XFILLER_29_669 vddd vssd sg13cmos5l_decap_4
X_4129_ _4129_/Y _7207_/Q _3929_/Y _4127_/Y _4128_/Y _6498_/A vddd vssd sg13cmos5l_a221oi_1
XFILLER_28_179 vddd vssd sg13cmos5l_decap_8
XFILLER_25_820 vddd vssd sg13cmos5l_decap_8
XFILLER_16_2547 vddd vssd sg13cmos5l_decap_8
XFILLER_32_1158 vddd vssd sg13cmos5l_decap_8
XFILLER_10_72 vddd vssd sg13cmos5l_decap_8
Xclkbuf_leaf_24_SCK_regs _7297_/CLK clkload6/A vddd vssd sg13cmos5l_buf_8
Xtiedowns\[20\] dbus_in_left[0] vddd vssd sg13cmos5l_antennanp
XFILLER_19_70 vddd vssd sg13cmos5l_decap_8
XFILLER_1_1602 vddd vssd sg13cmos5l_decap_8
XFILLER_21_1585 vddd vssd sg13cmos5l_decap_8
XFILLER_30_311 vddd vssd sg13cmos5l_decap_4
XFILLER_15_1389 vddd vssd sg13cmos5l_decap_8
X_3500_ _6057_/A _7339_/Q vddd vssd sg13cmos5l_inv_1
Xhold507 _7020_/D _3469_/Y vddd vssd sg13cmos5l_dlygate4sd3_1
X_4480_ _4480_/Y _4508_/C _4551_/B _4479_/Y vddd vssd sg13cmos5l_o21ai_1
Xhold518 _6808_/A _7004_/Q vddd vssd sg13cmos5l_dlygate4sd3_1
Xhold529 _6988_/D _3485_/Y vddd vssd sg13cmos5l_dlygate4sd3_1
X_6150_ _6150_/Y _4207_/Y _5186_/A _6149_/Y vddd vssd sg13cmos5l_o21ai_1
X_5101_ _5102_/D _5101_/A _6072_/B _5101_/C _6075_/A vddd vssd sg13cmos5l_nor4_1
Xhold1207 _6677_/A1 _3581_/Y vddd vssd sg13cmos5l_dlygate4sd3_1
X_6081_ _6100_/A _7340_/Q _6122_/A2 _6080_/Y vddd vssd sg13cmos5l_o21ai_1
Xhold1218 _3534_/A _7025_/Q vddd vssd sg13cmos5l_dlygate4sd3_1
XFILLER_22_1316 vddd vssd sg13cmos5l_decap_4
Xhold1229 _7243_/D _6579_/X vddd vssd sg13cmos5l_dlygate4sd3_1
X_5032_ _5043_/B _5032_/A _5032_/B _5032_/C vddd vssd sg13cmos5l_nor3_1
XFILLER_22_1327 vddd vssd sg13cmos5l_decap_8
XFILLER_18_0 vddd vssd sg13cmos5l_decap_8
X_6983_ _6983_/Q clkload1/A _6983_/D _6930_/Y vddd vssd sg13cmos5l_dfrbpq_1
XFILLER_25_149 vddd vssd sg13cmos5l_decap_8
X_5934_ _5934_/Y _5945_/A _5934_/B _5936_/B vddd vssd sg13cmos5l_nor3_1
XFILLER_20_1084 vddd vssd sg13cmos5l_decap_8
XFILLER_15_28 vddd vssd sg13cmos5l_decap_8
XFILLER_22_834 vddd vssd sg13cmos5l_decap_8
X_5865_ _5865_/Y _6225_/A _7228_/Q _5864_/X vddd vssd sg13cmos5l_o21ai_1
X_4816_ _4817_/B _3503_/Y _4815_/A _4815_/Y vddd vssd sg13cmos5l_o21ai_1
XFILLER_31_16 vddd vssd sg13cmos5l_decap_8
Xtiedowns\[4\] sram_odata[4] vddd vssd sg13cmos5l_antennanp
X_5796_ _5796_/Y _5502_/A _5794_/Y _5795_/Y _5793_/Y _5768_/Y vddd vssd sg13cmos5l_a221oi_1
XFILLER_15_2591 vddd vssd sg13cmos5l_decap_8
X_4747_ _4747_/Y _4746_/Y _4747_/B vddd vssd sg13cmos5l_nand2b_1
X_4678_ _4680_/A _4803_/A _4678_/B vddd vssd sg13cmos5l_nor2_1
XFILLER_11_2477 vddd vssd sg13cmos5l_decap_4
X_6417_ _6423_/S _6417_/A _6753_/B vddd vssd sg13cmos5l_nand2_1
X_7397_ _7397_/Q _7398_/CLK _7397_/D _6910_/Y vddd vssd sg13cmos5l_dfrbpq_1
X_3629_ _3629_/Y _3629_/A vddd vssd sg13cmos5l_inv_1
X_6348_ _7120_/D _6727_/A _6361_/B hold672/X vddd vssd sg13cmos5l_o21ai_1
XFILLER_11_1787 vddd vssd sg13cmos5l_decap_4
X_6279_ _6291_/A _7081_/Q _7082_/Q vddd vssd sg13cmos5l_nor2_1
XFILLER_22_2562 vddd vssd sg13cmos5l_decap_8
XFILLER_24_182 vddd vssd sg13cmos5l_decap_8
XFILLER_13_867 vddd vssd sg13cmos5l_decap_4
XFILLER_16_1643 vddd vssd sg13cmos5l_decap_8
XFILLER_13_889 vddd vssd sg13cmos5l_decap_8
XFILLER_14_2090 vddd vssd sg13cmos5l_decap_8
Xtiedowns\[68\] mask_rev_in[24] vddd vssd sg13cmos5l_antennanp
XFILLER_7_2501 vddd vssd sg13cmos5l_decap_8
XFILLER_23_2315 vddd vssd sg13cmos5l_decap_4
XFILLER_7_2578 vddd vssd sg13cmos5l_decap_8
XFILLER_23_1647 vddd vssd sg13cmos5l_decap_8
XFILLER_21_2050 vddd vssd sg13cmos5l_decap_8
XFILLER_11_7 vddd vssd sg13cmos5l_decap_8
XFILLER_1_1443 vddd vssd sg13cmos5l_decap_4
XFILLER_5_1590 vddd vssd sg13cmos5l_decap_8
X_3980_ _4159_/B _3980_/A _6762_/B vddd vssd sg13cmos5l_nor2_1
Xmax_cap80 _4183_/B1 _3724_/Y vddd vssd sg13cmos5l_buf_4
X_5650_ _5650_/Y _5797_/A1 _5649_/A _5649_/Y vddd vssd sg13cmos5l_a21oi_1
Xclkbuf_0_clk clkbuf_0_clk/X clk vddd vssd sg13cmos5l_buf_8
XFILLER_30_163 vddd vssd sg13cmos5l_decap_8
X_4601_ _4601_/Y _4597_/Y _4600_/Y _4647_/B vddd vssd sg13cmos5l_o21ai_1
X_5581_ _5581_/Y _5581_/A _7187_/Q _5581_/C vddd vssd sg13cmos5l_nor3_1
X_4532_ _4539_/A _4553_/A _4531_/Y _4650_/A vddd vssd sg13cmos5l_a21oi_1
XFILLER_7_51 vddd vssd sg13cmos5l_decap_8
X_7320_ _7320_/Q _7328_/CLK _7320_/D _7320_/RESET_B vddd vssd sg13cmos5l_dfrbpq_1
X_7251_ _7251_/Q _7291_/CLK _7251_/D fanout385/X vddd vssd sg13cmos5l_dfrbpq_1
X_4463_ _4754_/A _4781_/A _5315_/A _6009_/A vddd vssd sg13cmos5l_nor3_1
XFILLER_11_1039 vddd vssd sg13cmos5l_decap_8
XFILLER_28_2226 vddd vssd sg13cmos5l_decap_4
X_6202_ _6202_/Y _6072_/A _5227_/A _6201_/Y vddd vssd sg13cmos5l_a21oi_1
X_7182_ _7182_/Q _7200_/CLK _7182_/D fanout360/X vddd vssd sg13cmos5l_dfrbpq_1
X_4394_ _4394_/Y _4394_/A _4394_/B _4394_/C _4394_/D vddd vssd sg13cmos5l_nand4_1
X_6133_ _6135_/A _5157_/A _5180_/B _5168_/A _3901_/X _6132_/Y vddd vssd sg13cmos5l_a221oi_1
XFILLER_6_2022 vddd vssd sg13cmos5l_decap_8
Xoutbuffers\[51\] bandgap_trim[12] _6297_/X vddd vssd sg13cmos5l_buf_16
X_6064_ _6064_/Y _6037_/A _5100_/A _6062_/Y _6063_/Y _5101_/C vddd vssd sg13cmos5l_a221oi_1
Xsram_clk_mux sram_clk sram_clk_mux/A0 clkload0/A _5988_/A vddd vssd sg13cmos5l_mux2_1
Xhold1015 _6458_/A1 _5517_/A vddd vssd sg13cmos5l_dlygate4sd3_1
Xhold1004 _6578_/A1 _5065_/A vddd vssd sg13cmos5l_dlygate4sd3_1
Xhold1037 _3622_/A _7075_/Q vddd vssd sg13cmos5l_dlygate4sd3_1
X_5015_ _5025_/C _7248_/Q _7249_/Q _5225_/A vddd vssd sg13cmos5l_nor3_1
XFILLER_6_1354 vddd vssd sg13cmos5l_decap_4
Xhold1048 _7402_/D _3638_/Y vddd vssd sg13cmos5l_dlygate4sd3_1
Xhold1026 _5986_/A0 _4940_/A vddd vssd sg13cmos5l_dlygate4sd3_1
Xhold1059 _6720_/B1 _6719_/Y vddd vssd sg13cmos5l_dlygate4sd3_1
XFILLER_6_1398 vddd vssd sg13cmos5l_decap_4
X_6966_ _6966_/Y _6966_/A _6966_/B_N vddd vssd sg13cmos5l_nor2b_1
X_5917_ _5917_/Y _3526_/Y _7100_/Q _5916_/Y vddd vssd sg13cmos5l_o21ai_1
X_6897_ _6897_/Y _6901_/A _6901_/B_N vddd vssd sg13cmos5l_nor2b_1
XFILLER_13_2506 vddd vssd sg13cmos5l_decap_8
X_5848_ _5848_/X _5848_/A _5848_/B vddd vssd sg13cmos5l_and2_1
XFILLER_17_1985 vddd vssd sg13cmos5l_decap_8
X_5779_ _5779_/Y _5779_/A1 _5791_/B _5777_/Y vddd vssd sg13cmos5l_o21ai_1
XFILLER_5_329 vddd vssd sg13cmos5l_decap_8
Xhold882 _7184_/D _6466_/X vddd vssd sg13cmos5l_dlygate4sd3_1
Xhold871 hold871/X _5413_/A vddd vssd sg13cmos5l_dlygate4sd3_1
Xhold860 _7373_/D _4305_/Y vddd vssd sg13cmos5l_dlygate4sd3_1
Xhold893 hold893/X _4955_/A vddd vssd sg13cmos5l_dlygate4sd3_1
XFILLER_29_252 vddd vssd sg13cmos5l_decap_8
XFILLER_17_469 vddd vssd sg13cmos5l_decap_4
XFILLER_18_1716 vddd vssd sg13cmos5l_decap_8
XFILLER_31_1916 vddd vssd sg13cmos5l_decap_8
XFILLER_8_145 vddd vssd sg13cmos5l_decap_4
XFILLER_12_2027 vddd vssd sg13cmos5l_decap_8
XFILLER_32_70 vddd vssd sg13cmos5l_decap_8
XFILLER_31_1949 vddd vssd sg13cmos5l_decap_4
XFILLER_8_178 vddd vssd sg13cmos5l_decap_8
XFILLER_29_2513 vddd vssd sg13cmos5l_decap_8
XFILLER_29_1823 vddd vssd sg13cmos5l_decap_8
XFILLER_4_362 vddd vssd sg13cmos5l_decap_8
XFILLER_4_384 vddd vssd sg13cmos5l_decap_8
XFILLER_7_2353 vddd vssd sg13cmos5l_decap_8
XFILLER_7_2397 vddd vssd sg13cmos5l_decap_4
XFILLER_23_1455 vddd vssd sg13cmos5l_decap_4
XFILLER_23_1499 vddd vssd sg13cmos5l_decap_8
X_6820_ _6820_/Y _6879_/A _6914_/B_N vddd vssd sg13cmos5l_nor2b_1
X_6751_ _6751_/X _6769_/A1 _6751_/A1 _6752_/S vddd vssd sg13cmos5l_mux2_1
X_3963_ _3963_/Y _5441_/B _6431_/A _6424_/A vddd vssd sg13cmos5l_a21oi_1
XFILLER_32_962 vddd vssd sg13cmos5l_decap_8
X_5702_ _5704_/A _6230_/A _5699_/Y _5701_/Y vddd vssd sg13cmos5l_a21oi_1
X_3894_ _3894_/Y _7253_/Q _3894_/B vddd vssd sg13cmos5l_nand2b_1
X_6682_ _6682_/X _6682_/A0 sram_odata[4] _6683_/S vddd vssd sg13cmos5l_mux2_1
X_5633_ _5633_/Y _6211_/A _5633_/B _7195_/Q vddd vssd sg13cmos5l_nor3_1
X_5564_ _5564_/Y _5569_/B _5581_/A vddd vssd sg13cmos5l_nor2b_1
Xoutbuffers\[99\] dbus_out[2] _5362_/X vddd vssd sg13cmos5l_buf_16
X_4515_ _4515_/Y _4803_/A _4515_/B vddd vssd sg13cmos5l_nor2_1
X_7303_ _7303_/Q _7375_/CLK _7303_/D _6825_/Y vddd vssd sg13cmos5l_dfrbpq_1
X_5495_ _5501_/B _5757_/A _5498_/C _5498_/D _5495_/D vddd vssd sg13cmos5l_nand4_1
X_7234_ _7234_/Q _7292_/CLK _7234_/D fanout371/X vddd vssd sg13cmos5l_dfrbpq_1
X_4446_ _4664_/B _4698_/A _7337_/Q _4446_/C vddd vssd sg13cmos5l_nand3_1
X_4377_ _4379_/A _4508_/C _7135_/Q vddd vssd sg13cmos5l_xnor2_1
X_7165_ _7165_/Q _7210_/CLK _7165_/D fanout359/X vddd vssd sg13cmos5l_dfrbpq_1
X_6116_ _6116_/Y _6116_/A _6116_/B vddd vssd sg13cmos5l_nand2_1
X_7096_ _7096_/Q _7111_/CLK _7096_/D fanout404/X vddd vssd sg13cmos5l_dfrbpq_1
X_6047_ _6047_/Y _6049_/B _6049_/C _6046_/Y vddd vssd sg13cmos5l_a21oi_1
XFILLER_27_734 vddd vssd sg13cmos5l_decap_8
X_6949_ _6949_/Y _6969_/A _6968_/B_N vddd vssd sg13cmos5l_nor2b_1
XFILLER_17_2450 vddd vssd sg13cmos5l_decap_8
Xclkbuf_3_5_0_clk_regs clkbuf_3_5_0_clk_regs/X clkbuf_0_clk_regs/X vddd vssd sg13cmos5l_buf_8
XFILLER_6_649 vddd vssd sg13cmos5l_decap_4
XFILLER_30_1960 vddd vssd sg13cmos5l_decap_4
Xhold690 hold690/X _6792_/Y vddd vssd sg13cmos5l_dlygate4sd3_1
XFILLER_24_2432 vddd vssd sg13cmos5l_decap_8
XFILLER_2_888 vddd vssd sg13cmos5l_decap_8
XFILLER_4_2559 vddd vssd sg13cmos5l_decap_8
XFILLER_18_745 vddd vssd sg13cmos5l_decap_8
XFILLER_4_1869 vddd vssd sg13cmos5l_decap_8
XFILLER_27_70 vddd vssd sg13cmos5l_decap_8
XFILLER_17_255 vddd vssd sg13cmos5l_decap_8
Xhold1390 hold1390/X _7381_/Q vddd vssd sg13cmos5l_dlygate4sd3_1
XFILLER_32_203 vddd vssd sg13cmos5l_decap_8
XFILLER_31_2436 vddd vssd sg13cmos5l_decap_8
XFILLER_12_1134 vddd vssd sg13cmos5l_decap_8
X_4300_ _4301_/B _4315_/A _4300_/B vddd vssd sg13cmos5l_nor2_1
XFILLER_5_693 vddd vssd sg13cmos5l_decap_8
X_5280_ _5280_/Y _5280_/A1 _5280_/A2 _5279_/Y vddd vssd sg13cmos5l_o21ai_1
XFILLER_29_2387 vddd vssd sg13cmos5l_decap_8
XFILLER_25_2207 vddd vssd sg13cmos5l_decap_4
XFILLER_4_30 vddd vssd sg13cmos5l_decap_8
XFILLER_9_2437 vddd vssd sg13cmos5l_decap_4
X_4231_ _4231_/Y _7166_/Q _3962_/Y _3960_/Y vddd vssd sg13cmos5l_o21ai_1
XFILLER_4_74 vddd vssd sg13cmos5l_decap_8
X_4162_ _4162_/X _7137_/Q wire81/X _3842_/B vddd vssd sg13cmos5l_a21o_1
X_4093_ _4093_/X _3534_/Y _6687_/A wire92/A vddd vssd sg13cmos5l_a21o_1
XFILLER_3_1313 vddd vssd sg13cmos5l_decap_8
XFILLER_23_1263 vddd vssd sg13cmos5l_decap_4
XFILLER_23_1274 vddd vssd sg13cmos5l_decap_8
XFILLER_24_737 vddd vssd sg13cmos5l_decap_8
XFILLER_23_203 vddd vssd sg13cmos5l_decap_8
Xoutbuffers\[14\] proj_sel[1] _7025_/Q vddd vssd sg13cmos5l_buf_16
X_4995_ _5008_/B _6181_/B _5062_/A vddd vssd sg13cmos5l_and2_1
X_6803_ _6803_/Y _6803_/A _6803_/B vddd vssd sg13cmos5l_nand2_1
X_6734_ _6734_/X _6661_/A _6734_/A1 _6735_/S vddd vssd sg13cmos5l_mux2_1
XFILLER_23_28 vddd vssd sg13cmos5l_decap_8
X_3946_ _6461_/A _3946_/A _6395_/B vddd vssd sg13cmos5l_nor2_1
XFILLER_14_1900 vddd vssd sg13cmos5l_decap_8
X_6665_ _6671_/S wire92/X _6726_/B vddd vssd sg13cmos5l_and2_1
XFILLER_20_965 vddd vssd sg13cmos5l_decap_8
X_3877_ _6621_/A _3877_/A _3889_/A vddd vssd sg13cmos5l_nand2_1
X_5616_ _5616_/Y _5611_/Y _5612_/X _5615_/Y vddd vssd sg13cmos5l_o21ai_1
X_6596_ _6596_/X _6596_/A0 _6645_/A1 _6596_/S vddd vssd sg13cmos5l_mux2_1
X_5547_ _5553_/C _5557_/B _5557_/A vddd vssd sg13cmos5l_nand2b_1
X_5478_ _5478_/Y _5590_/A1 _5449_/Y _5477_/Y vddd vssd sg13cmos5l_a21oi_1
XFILLER_2_129 vddd vssd sg13cmos5l_decap_8
X_7217_ _7217_/Q _7229_/CLK _7217_/D fanout365/X vddd vssd sg13cmos5l_dfrbpq_1
X_4429_ _4507_/A _4533_/A _4536_/A vddd vssd sg13cmos5l_nor2_1
Xfanout400 _6966_/B_N _6964_/B_N vddd vssd sg13cmos5l_buf_1
Xfanout411 fanout411/X porb vddd vssd sg13cmos5l_buf_1
Xfanout422 _6224_/A io_in[6] vddd vssd sg13cmos5l_buf_1
XFILLER_8_1224 vddd vssd sg13cmos5l_decap_8
X_7148_ _7148_/Q _7190_/CLK _7148_/D fanout357/X vddd vssd sg13cmos5l_dfrbpq_1
XFILLER_24_1016 vddd vssd sg13cmos5l_decap_8
Xfanout433 _5530_/A _5733_/A vddd vssd sg13cmos5l_buf_1
Xfanout444 _5484_/A _5627_/A vddd vssd sg13cmos5l_buf_1
Xfanout455 _6917_/A _6893_/A vddd vssd sg13cmos5l_buf_1
X_7079_ _7079_/Q _7276_/CLK _7079_/D fanout390/X vddd vssd sg13cmos5l_dfrbpq_1
XFILLER_27_531 vddd vssd sg13cmos5l_decap_4
XFILLER_19_2534 vddd vssd sg13cmos5l_decap_8
Xfanout40 _6344_/B _6329_/Y vddd vssd sg13cmos5l_buf_1
Xfanout73 _4244_/A2 wire75/X vddd vssd sg13cmos5l_buf_1
Xfanout62 _4553_/A _4528_/A vddd vssd sg13cmos5l_buf_1
XFILLER_15_1708 vddd vssd sg13cmos5l_decap_8
XFILLER_13_2122 vddd vssd sg13cmos5l_decap_8
Xfanout51 _6683_/S _6674_/Y vddd vssd sg13cmos5l_buf_1
XFILLER_11_932 vddd vssd sg13cmos5l_decap_8
Xfanout84 _4172_/B1 _3682_/X vddd vssd sg13cmos5l_buf_1
XFILLER_17_1590 vddd vssd sg13cmos5l_decap_8
XFILLER_13_2166 vddd vssd sg13cmos5l_decap_8
XFILLER_2_630 vddd vssd sg13cmos5l_decap_4
Xtiedowns\[50\] mask_rev_in[6] vddd vssd sg13cmos5l_antennanp
XFILLER_26_2549 vddd vssd sg13cmos5l_decap_8
XFILLER_26_1837 vddd vssd sg13cmos5l_decap_4
XFILLER_24_1561 vddd vssd sg13cmos5l_decap_8
X_3800_ _6736_/A _3867_/B _3878_/B _3846_/A vddd vssd sg13cmos5l_or3_1
X_4780_ _4780_/Y _4754_/A _4780_/B vddd vssd sg13cmos5l_nand2b_1
Xoutbuffers\[104\] dbus_out[7] _5505_/Y vddd vssd sg13cmos5l_buf_16
X_3731_ _3731_/Y _3711_/Y _3725_/Y _3730_/Y vddd vssd sg13cmos5l_o21ai_1
XFILLER_14_792 vddd vssd sg13cmos5l_decap_8
X_3662_ _3713_/A _3705_/B _3662_/B vddd vssd sg13cmos5l_or2_1
X_6450_ _7176_/D _6472_/A _6450_/A1 _6451_/B vddd vssd sg13cmos5l_mux2_1
Xclkload10 clkload10/Y _7375_/CLK vddd vssd sg13cmos5l_inv_4
XFILLER_9_284 vddd vssd sg13cmos5l_decap_8
X_3593_ _3593_/Y _3593_/A vddd vssd sg13cmos5l_inv_1
X_6381_ _6381_/Y _6408_/A _6382_/B hold746/X vddd vssd sg13cmos5l_o21ai_1
X_5401_ _5410_/B _7162_/Q _7163_/Q vddd vssd sg13cmos5l_nand2_1
X_5332_ _5332_/Y _5416_/A _5326_/D _5320_/B _5530_/A vddd vssd sg13cmos5l_a22oi_1
X_5263_ _6272_/B _5263_/A _6181_/C vddd vssd sg13cmos5l_nor2b_1
X_7002_ _7002_/Q clkload1/A _7002_/D _6949_/Y vddd vssd sg13cmos5l_dfrbpq_1
XFILLER_25_2059 vddd vssd sg13cmos5l_decap_8
X_5194_ _5267_/B _7252_/Q _7253_/Q vddd vssd sg13cmos5l_nand2b_1
X_4214_ _4214_/Y _4211_/Y _4212_/X _4213_/Y vddd vssd sg13cmos5l_o21ai_1
X_4145_ _4145_/Y _4142_/Y _4143_/X _4144_/Y vddd vssd sg13cmos5l_o21ai_1
XFILLER_18_28 vddd vssd sg13cmos5l_decap_8
X_4076_ _4076_/Y _4458_/A _6779_/A _3848_/A vddd vssd sg13cmos5l_a21oi_1
X_4978_ sram_idata[6] _6801_/A _4980_/B vddd vssd sg13cmos5l_and2_1
X_6717_ _6717_/X _6717_/A0 _6759_/A _6717_/S vddd vssd sg13cmos5l_mux2_1
XFILLER_20_751 vddd vssd sg13cmos5l_decap_8
X_3929_ _3929_/Y _6762_/A _3961_/B vddd vssd sg13cmos5l_nor2_1
Xclkload4 clkload4/X clkload4/A vddd vssd sg13cmos5l_buf_8
XFILLER_14_2442 vddd vssd sg13cmos5l_decap_8
X_6648_ _7286_/D _6704_/A1 _6652_/S _6647_/Y vddd vssd sg13cmos5l_a21oi_1
XFILLER_14_1730 vddd vssd sg13cmos5l_decap_8
XFILLER_30_1053 vddd vssd sg13cmos5l_decap_4
XFILLER_30_1031 vddd vssd sg13cmos5l_decap_8
XFILLER_4_917 vddd vssd sg13cmos5l_decap_4
X_6579_ _6579_/X _6668_/A _6579_/A1 _6581_/B vddd vssd sg13cmos5l_mux2_1
XFILLER_4_939 vddd vssd sg13cmos5l_decap_8
Xfanout241 _4674_/A _4662_/A vddd vssd sg13cmos5l_buf_1
Xfanout230 _4179_/A1 hold1369/X vddd vssd sg13cmos5l_buf_1
Xfanout274 _5204_/A hold1400/X vddd vssd sg13cmos5l_buf_1
Xfanout252 _4815_/A fanout254/X vddd vssd sg13cmos5l_buf_1
Xfanout263 _6122_/A2 _7300_/Q vddd vssd sg13cmos5l_buf_1
Xfanout296 _5498_/C hold1398/X vddd vssd sg13cmos5l_buf_1
Xfanout285 _5762_/A hold1414/X vddd vssd sg13cmos5l_buf_1
XFILLER_21_2479 vddd vssd sg13cmos5l_decap_8
XFILLER_21_1756 vddd vssd sg13cmos5l_decap_8
XFILLER_28_873 vddd vssd sg13cmos5l_decap_4
XFILLER_21_1778 vddd vssd sg13cmos5l_decap_8
XFILLER_1_1839 vddd vssd sg13cmos5l_decap_8
XFILLER_27_372 vddd vssd sg13cmos5l_decap_8
XFILLER_32_2586 vddd vssd sg13cmos5l_decap_8
XFILLER_15_1549 vddd vssd sg13cmos5l_decap_8
XFILLER_32_1852 vddd vssd sg13cmos5l_decap_8
XFILLER_7_766 vddd vssd sg13cmos5l_decap_8
XFILLER_13_1240 vddd vssd sg13cmos5l_decap_8
XFILLER_20_1200 vddd vssd sg13cmos5l_decap_8
XFILLER_0_2028 vddd vssd sg13cmos5l_decap_8
XFILLER_1_42 vddd vssd sg13cmos5l_decap_8
XFILLER_4_2186 vddd vssd sg13cmos5l_decap_4
X_5950_ _5974_/B _7239_/Q _7238_/Q vddd vssd sg13cmos5l_nor2b_1
X_4901_ _4905_/B _4916_/A _4901_/B vddd vssd sg13cmos5l_nand2_1
X_5881_ _5881_/Y _6212_/A1 _5895_/A _5901_/D vddd vssd sg13cmos5l_o21ai_1
X_4832_ _4832_/Y _5988_/A _4832_/B vddd vssd sg13cmos5l_nand2_1
XFILLER_21_559 vddd vssd sg13cmos5l_decap_8
XFILLER_18_1173 vddd vssd sg13cmos5l_decap_8
X_4763_ _4763_/Y _4762_/B _3596_/Y _4762_/Y vddd vssd sg13cmos5l_a21oi_1
X_6502_ _7203_/D _6502_/A1 _6505_/S _6501_/Y vddd vssd sg13cmos5l_a21oi_1
X_4694_ _4694_/Y _4674_/C _4694_/B vddd vssd sg13cmos5l_nand2b_1
X_3714_ wire98/A _3874_/B _3938_/B vddd vssd sg13cmos5l_nor2_1
X_6433_ _7166_/D _6492_/A1 _6437_/S hold963/X vddd vssd sg13cmos5l_o21ai_1
Xoutbuffers\[81\] io_oe[8] _5217_/Y vddd vssd sg13cmos5l_buf_16
X_3645_ _4853_/B _4852_/A _3645_/B vddd vssd sg13cmos5l_nand2b_1
X_6364_ _6364_/Y _6364_/A _6372_/S vddd vssd sg13cmos5l_nor2_1
X_3576_ _5713_/B _3576_/A vddd vssd sg13cmos5l_inv_1
X_6295_ _6295_/Y _6291_/A _6287_/B _6294_/A vddd vssd sg13cmos5l_o21ai_1
X_5315_ _5315_/Y _5315_/A _5327_/B vddd vssd sg13cmos5l_nor2_1
X_5246_ _5250_/A _5246_/A _5261_/B vddd vssd sg13cmos5l_nor2_1
XFILLER_29_49 vddd vssd sg13cmos5l_decap_8
XFILLER_25_1122 vddd vssd sg13cmos5l_decap_4
XFILLER_21_1008 vddd vssd sg13cmos5l_decap_4
X_5177_ _5186_/A _5265_/A _5177_/B vddd vssd sg13cmos5l_or2_1
XFILLER_29_659 vddd vssd sg13cmos5l_decap_8
X_4128_ _4128_/Y _5748_/B _6514_/A _3929_/Y vddd vssd sg13cmos5l_a21oi_1
XFILLER_28_158 vddd vssd sg13cmos5l_decap_8
X_4059_ _4059_/Y _4056_/Y _4057_/Y _4058_/Y vddd vssd sg13cmos5l_o21ai_1
XFILLER_0_2573 vddd vssd sg13cmos5l_decap_8
XFILLER_25_854 vddd vssd sg13cmos5l_decap_8
XFILLER_0_1883 vddd vssd sg13cmos5l_decap_4
XFILLER_16_2526 vddd vssd sg13cmos5l_decap_8
XFILLER_32_1137 vddd vssd sg13cmos5l_decap_8
XFILLER_10_1402 vddd vssd sg13cmos5l_decap_8
XFILLER_10_2125 vddd vssd sg13cmos5l_decap_8
XFILLER_14_1582 vddd vssd sg13cmos5l_decap_8
XFILLER_10_2169 vddd vssd sg13cmos5l_decap_8
XFILLER_10_1446 vddd vssd sg13cmos5l_decap_8
XFILLER_10_1468 vddd vssd sg13cmos5l_decap_4
XFILLER_10_51 vddd vssd sg13cmos5l_decap_8
Xclkbuf_regs_0_clk clkbuf_regs_0_clk/X clk vddd vssd sg13cmos5l_buf_8
XFILLER_0_931 vddd vssd sg13cmos5l_decap_8
XFILLER_21_1520 vddd vssd sg13cmos5l_decap_8
XFILLER_5_2484 vddd vssd sg13cmos5l_decap_8
XFILLER_21_1564 vddd vssd sg13cmos5l_decap_8
Xtiedowns\[13\] _5967_/A vddd vssd sg13cmos5l_antennanp
XFILLER_27_180 vddd vssd sg13cmos5l_decap_8
XFILLER_31_802 vddd vssd sg13cmos5l_decap_4
XFILLER_19_2183 vddd vssd sg13cmos5l_decap_8
XFILLER_15_386 vddd vssd sg13cmos5l_decap_8
XFILLER_19_1471 vddd vssd sg13cmos5l_decap_8
XFILLER_15_1335 vddd vssd sg13cmos5l_decap_8
XFILLER_32_2383 vddd vssd sg13cmos5l_decap_8
XFILLER_32_1660 vddd vssd sg13cmos5l_decap_8
Xhold508 _3476_/A _7000_/Q vddd vssd sg13cmos5l_dlygate4sd3_1
XFILLER_7_585 vddd vssd sg13cmos5l_decap_8
XFILLER_28_2419 vddd vssd sg13cmos5l_decap_8
Xhold519 _7005_/D _6808_/X vddd vssd sg13cmos5l_dlygate4sd3_1
XFILLER_26_2143 vddd vssd sg13cmos5l_decap_8
X_5100_ _5102_/C _5100_/A _5100_/B _5100_/C vddd vssd sg13cmos5l_nor3_1
X_6080_ _6080_/Y _4757_/A _6122_/A2 _6167_/B1 vddd vssd sg13cmos5l_a21oi_1
XFILLER_22_2007 vddd vssd sg13cmos5l_decap_8
X_5031_ _5032_/C _5208_/A _5209_/B _5141_/A vddd vssd sg13cmos5l_nor3_1
Xhold1219 _6691_/A1 _3534_/Y vddd vssd sg13cmos5l_dlygate4sd3_1
Xhold1208 _6612_/A0 _7263_/Q vddd vssd sg13cmos5l_dlygate4sd3_1
XFILLER_6_1569 vddd vssd sg13cmos5l_decap_8
X_6982_ _6982_/Q clkload1/A _6982_/D _6929_/Y vddd vssd sg13cmos5l_dfrbpq_1
XFILLER_25_128 vddd vssd sg13cmos5l_decap_8
X_5933_ _5936_/B _5933_/A _5933_/B vddd vssd sg13cmos5l_and2_1
XFILLER_22_813 vddd vssd sg13cmos5l_decap_8
X_5864_ _5864_/X _6224_/A _7229_/Q vddd vssd sg13cmos5l_or2_1
X_4815_ _4815_/Y _4815_/A _7104_/Q vddd vssd sg13cmos5l_nand2_1
XFILLER_21_367 vddd vssd sg13cmos5l_decap_8
XFILLER_15_2570 vddd vssd sg13cmos5l_decap_8
X_5795_ _5795_/Y _5795_/A1 _5791_/Y _5794_/Y vddd vssd sg13cmos5l_a21oi_1
X_4746_ _4746_/Y _4656_/A _4733_/Y _4746_/B1 vddd vssd sg13cmos5l_o21ai_1
X_4677_ _4678_/B _4677_/A _4677_/B vddd vssd sg13cmos5l_xor2_1
XFILLER_11_2456 vddd vssd sg13cmos5l_decap_8
X_3628_ _3628_/Y _3628_/A vddd vssd sg13cmos5l_inv_1
X_7396_ SDO _7396_/CLK _7396_/D _6815_/Y vddd vssd sg13cmos5l_dfrbpq_1
X_6416_ _6416_/X _6769_/A1 hold958/X _6416_/S vddd vssd sg13cmos5l_mux2_1
XFILLER_11_1744 vddd vssd sg13cmos5l_decap_8
X_6347_ _6347_/Y _6347_/A _6361_/B vddd vssd sg13cmos5l_nand2_1
X_3559_ _5498_/D _3559_/A vddd vssd sg13cmos5l_inv_1
X_6278_ _6278_/X _6278_/A1 _6277_/Y _6260_/Y vddd vssd sg13cmos5l_a21o_1
XFILLER_0_249 vddd vssd sg13cmos5l_decap_8
X_5229_ _5229_/Y _5233_/D vddd vssd sg13cmos5l_inv_1
XFILLER_22_2541 vddd vssd sg13cmos5l_decap_8
XFILLER_5_1046 vddd vssd sg13cmos5l_decap_8
XFILLER_0_2370 vddd vssd sg13cmos5l_decap_8
XFILLER_24_161 vddd vssd sg13cmos5l_decap_8
XFILLER_13_846 vddd vssd sg13cmos5l_decap_8
XFILLER_8_327 vddd vssd sg13cmos5l_decap_8
XFILLER_10_1254 vddd vssd sg13cmos5l_decap_8
XFILLER_27_2485 vddd vssd sg13cmos5l_decap_8
XFILLER_7_2557 vddd vssd sg13cmos5l_decap_8
XFILLER_0_772 vddd vssd sg13cmos5l_decap_8
XFILLER_21_2095 vddd vssd sg13cmos5l_decap_8
XFILLER_21_1361 vddd vssd sg13cmos5l_decap_8
XFILLER_1_1433 vddd vssd sg13cmos5l_decap_4
XFILLER_16_673 vddd vssd sg13cmos5l_decap_8
XFILLER_1_1488 vddd vssd sg13cmos5l_decap_4
XFILLER_30_142 vddd vssd sg13cmos5l_decap_8
X_4600_ _4600_/Y _4668_/A _4600_/B vddd vssd sg13cmos5l_nor2_1
XFILLER_15_1121 vddd vssd sg13cmos5l_decap_8
X_5580_ _5580_/Y _5580_/A _5580_/B vddd vssd sg13cmos5l_nand2_1
XFILLER_7_30 vddd vssd sg13cmos5l_decap_8
XFILLER_12_890 vddd vssd sg13cmos5l_decap_8
X_4531_ _4531_/Y _4531_/A _4534_/A _4534_/B vddd vssd sg13cmos5l_nand3_1
X_7250_ _7250_/Q _7258_/CLK _7250_/D fanout385/X vddd vssd sg13cmos5l_dfrbpq_1
X_4462_ _4798_/C _5315_/A _6009_/A vddd vssd sg13cmos5l_nor2_1
X_6201_ _6201_/Y _6201_/A _6201_/B vddd vssd sg13cmos5l_nor2_1
XFILLER_28_1526 vddd vssd sg13cmos5l_decap_8
X_4393_ _4394_/D _4393_/A _4393_/B _4393_/C _4393_/D vddd vssd sg13cmos5l_nor4_1
X_7181_ _7181_/Q _7210_/CLK _7181_/D fanout362/X vddd vssd sg13cmos5l_dfrbpq_1
XFILLER_30_0 vddd vssd sg13cmos5l_decap_8
X_6132_ _6132_/Y _3822_/Y _5159_/B _6130_/Y _6131_/Y _5168_/A vddd vssd sg13cmos5l_a221oi_1
XFILLER_6_2001 vddd vssd sg13cmos5l_decap_8
Xhold1005 _3602_/A _7113_/Q vddd vssd sg13cmos5l_dlygate4sd3_1
X_6063_ _6063_/Y _6263_/A1 _5100_/C _5100_/A vddd vssd sg13cmos5l_a21oi_1
Xhold1038 _6768_/A1 _3622_/Y vddd vssd sg13cmos5l_dlygate4sd3_1
Xoutbuffers\[44\] bandgap_trim[5] _6288_/Y vddd vssd sg13cmos5l_buf_16
XFILLER_26_1294 vddd vssd sg13cmos5l_decap_4
XFILLER_26_1272 vddd vssd sg13cmos5l_decap_8
Xhold1049 _3527_/A _6978_/Q vddd vssd sg13cmos5l_dlygate4sd3_1
XFILLER_22_1103 vddd vssd sg13cmos5l_decap_8
Xhold1016 _6664_/A0 _7297_/Q vddd vssd sg13cmos5l_dlygate4sd3_1
X_5014_ _5225_/A _5130_/A _5247_/B vddd vssd sg13cmos5l_nand2_1
XFILLER_6_1333 vddd vssd sg13cmos5l_decap_8
Xhold1027 _7311_/D _4941_/Y vddd vssd sg13cmos5l_dlygate4sd3_1
XFILLER_26_28 vddd vssd sg13cmos5l_decap_8
X_6965_ _6965_/Y _6965_/A _6966_/B_N vddd vssd sg13cmos5l_nor2b_1
X_5916_ _5916_/Y _5916_/A _5916_/B vddd vssd sg13cmos5l_nand2_1
X_6896_ _6896_/Y _6898_/A _6901_/B_N vddd vssd sg13cmos5l_nor2b_1
XFILLER_21_142 vddd vssd sg13cmos5l_decap_8
X_5847_ _5847_/Y _5847_/A _5846_/Y vddd vssd sg13cmos5l_nor2b_1
XFILLER_10_805 vddd vssd sg13cmos5l_decap_8
XFILLER_21_186 vddd vssd sg13cmos5l_decap_8
X_5778_ _5778_/Y _5861_/A _5778_/B _7216_/Q vddd vssd sg13cmos5l_nor3_1
X_4729_ _4729_/Y _4590_/A _4711_/Y _4725_/Y _4728_/Y vddd vssd sg13cmos5l_a22oi_1
XFILLER_11_1552 vddd vssd sg13cmos5l_decap_8
Xhold861 hold861/X _7129_/Q vddd vssd sg13cmos5l_dlygate4sd3_1
Xhold872 hold872/X _7216_/Q vddd vssd sg13cmos5l_dlygate4sd3_1
X_7379_ _7379_/Q _7380_/CLK _7379_/D _6893_/Y vddd vssd sg13cmos5l_dfrbpq_1
XFILLER_11_1596 vddd vssd sg13cmos5l_decap_4
Xhold850 _4357_/A _7358_/Q vddd vssd sg13cmos5l_dlygate4sd3_1
Xhold894 _7306_/D _4956_/Y vddd vssd sg13cmos5l_dlygate4sd3_1
Xhold883 hold883/X _7101_/Q vddd vssd sg13cmos5l_dlygate4sd3_1
XFILLER_24_1924 vddd vssd sg13cmos5l_decap_8
XFILLER_29_231 vddd vssd sg13cmos5l_decap_8
XFILLER_24_1979 vddd vssd sg13cmos5l_decap_8
XFILLER_17_404 vddd vssd sg13cmos5l_decap_8
XFILLER_18_938 vddd vssd sg13cmos5l_decap_8
Xclkbuf_4_15__f_clk_regs clkload1/A clkbuf_3_7_0_clk_regs/X vddd vssd sg13cmos5l_buf_8
XFILLER_16_2164 vddd vssd sg13cmos5l_decap_8
XFILLER_16_1452 vddd vssd sg13cmos5l_decap_4
XFILLER_9_658 vddd vssd sg13cmos5l_decap_8
Xtiedowns\[80\] _6968_/B_N vddd vssd sg13cmos5l_antennanp
XFILLER_5_831 vddd vssd sg13cmos5l_decap_8
XFILLER_29_1802 vddd vssd sg13cmos5l_decap_8
XFILLER_29_2569 vddd vssd sg13cmos5l_decap_8
XFILLER_5_886 vddd vssd sg13cmos5l_decap_8
XFILLER_29_1857 vddd vssd sg13cmos5l_decap_4
XFILLER_27_2260 vddd vssd sg13cmos5l_decap_8
XFILLER_23_2135 vddd vssd sg13cmos5l_decap_8
XFILLER_27_1570 vddd vssd sg13cmos5l_decap_8
XFILLER_1_1241 vddd vssd sg13cmos5l_decap_8
X_6750_ _6750_/X _6767_/A _6750_/A1 _6752_/S vddd vssd sg13cmos5l_mux2_1
XFILLER_32_941 vddd vssd sg13cmos5l_decap_8
X_5701_ _5701_/Y _5841_/A _5686_/Y _5689_/Y _5698_/Y _5699_/Y vddd vssd sg13cmos5l_a221oi_1
XFILLER_16_492 vddd vssd sg13cmos5l_decap_8
X_3962_ _3962_/Y _3962_/A _3966_/B vddd vssd sg13cmos5l_nand2_1
XFILLER_17_1238 vddd vssd sg13cmos5l_decap_8
X_3893_ _6583_/A _3922_/B _3896_/A vddd vssd sg13cmos5l_nand2_1
X_6681_ _7318_/D _6681_/A1 _6683_/S _6680_/Y vddd vssd sg13cmos5l_o21ai_1
X_5632_ _5641_/A _5632_/A _5642_/C vddd vssd sg13cmos5l_nor2_1
XFILLER_30_1405 vddd vssd sg13cmos5l_decap_8
X_5563_ _5563_/Y _5590_/A1 _5534_/Y _5562_/Y vddd vssd sg13cmos5l_a21oi_1
X_4514_ _4515_/B _4514_/A _4514_/B vddd vssd sg13cmos5l_xnor2_1
X_7302_ _7302_/Q _7404_/CLK _7302_/D _6672_/Y vddd vssd sg13cmos5l_dfrbpq_1
XFILLER_12_2584 vddd vssd sg13cmos5l_decap_8
X_5494_ _5501_/A _5498_/C _5488_/Y _5493_/Y vddd vssd sg13cmos5l_o21ai_1
X_7233_ _7233_/Q _7301_/CLK _7233_/D fanout370/X vddd vssd sg13cmos5l_dfrbpq_1
X_4445_ _4691_/B _4730_/A _4446_/C vddd vssd sg13cmos5l_nand2_1
X_4376_ _4391_/A _4782_/A _7123_/Q vddd vssd sg13cmos5l_xnor2_1
X_7164_ _7164_/Q _7164_/CLK _7164_/D fanout356/X vddd vssd sg13cmos5l_dfrbpq_1
XFILLER_28_1367 vddd vssd sg13cmos5l_decap_4
X_6115_ _6116_/B _6144_/A _5149_/C _5148_/B vddd vssd sg13cmos5l_a21oi_1
X_7095_ _7095_/Q _7111_/CLK _7095_/D _6870_/B_N vddd vssd sg13cmos5l_dfrbpq_1
XFILLER_6_1141 vddd vssd sg13cmos5l_decap_8
X_6046_ _6046_/Y _5068_/C _6044_/Y _6045_/Y vddd vssd sg13cmos5l_a21oi_1
XFILLER_15_919 vddd vssd sg13cmos5l_decap_4
X_6948_ _6948_/Y _6948_/A _6968_/B_N vddd vssd sg13cmos5l_nor2b_1
X_6879_ _6879_/Y _6879_/A _6917_/B_N vddd vssd sg13cmos5l_nor2b_1
XFILLER_5_105 vddd vssd sg13cmos5l_decap_8
XFILLER_11_2050 vddd vssd sg13cmos5l_decap_8
Xhold680 _5273_/A _5272_/Y vddd vssd sg13cmos5l_dlygate4sd3_1
XFILLER_28_2580 vddd vssd sg13cmos5l_decap_8
XFILLER_24_2411 vddd vssd sg13cmos5l_decap_8
Xhold691 _7089_/D _6793_/Y vddd vssd sg13cmos5l_dlygate4sd3_1
XFILLER_4_2527 vddd vssd sg13cmos5l_decap_8
XFILLER_8_1962 vddd vssd sg13cmos5l_decap_8
XFILLER_24_2488 vddd vssd sg13cmos5l_decap_8
XFILLER_4_1837 vddd vssd sg13cmos5l_decap_4
Xhold1391 _4431_/A _6981_/Q vddd vssd sg13cmos5l_dlygate4sd3_1
Xhold1380 _7320_/D _6683_/X vddd vssd sg13cmos5l_dlygate4sd3_1
XFILLER_2_1583 vddd vssd sg13cmos5l_decap_4
XFILLER_18_1514 vddd vssd sg13cmos5l_decap_8
XFILLER_13_451 vddd vssd sg13cmos5l_decap_8
XFILLER_31_2415 vddd vssd sg13cmos5l_decap_8
XFILLER_18_1569 vddd vssd sg13cmos5l_decap_8
XFILLER_9_499 vddd vssd sg13cmos5l_decap_4
XFILLER_12_1113 vddd vssd sg13cmos5l_decap_8
XFILLER_29_2366 vddd vssd sg13cmos5l_decap_8
XFILLER_9_1704 vddd vssd sg13cmos5l_decap_8
X_4230_ _4230_/Y _7170_/Q _6438_/A _6431_/A vddd vssd sg13cmos5l_a21oi_1
XFILLER_29_1676 vddd vssd sg13cmos5l_decap_8
X_4161_ wire6/A _4158_/Y _4159_/Y _4160_/Y vddd vssd sg13cmos5l_a21oi_1
XFILLER_4_53 vddd vssd sg13cmos5l_decap_8
X_4092_ _4092_/Y _7031_/Q _6696_/A _6702_/A _7034_/Q _6687_/A vddd vssd sg13cmos5l_a221oi_1
XFILLER_7_1483 vddd vssd sg13cmos5l_decap_8
X_6802_ _6802_/Y hold888/X _6801_/B _6801_/Y vddd vssd sg13cmos5l_o21ai_1
X_4994_ _5062_/A _7256_/Q _7257_/Q vddd vssd sg13cmos5l_nor2_1
X_6733_ _6733_/Y _6733_/A1 _6726_/Y _6732_/Y vddd vssd sg13cmos5l_a21oi_1
X_3945_ _3945_/Y _5606_/B _6475_/A _6468_/A vddd vssd sg13cmos5l_a21oi_1
XFILLER_20_944 vddd vssd sg13cmos5l_decap_8
X_6664_ _6664_/X _6664_/A0 _6803_/A _6664_/S vddd vssd sg13cmos5l_mux2_1
X_5615_ _5615_/Y _5730_/A _5613_/Y _5614_/Y vddd vssd sg13cmos5l_a21oi_1
X_3876_ wire89/A _3876_/A _3902_/A _3940_/A _3876_/D vddd vssd sg13cmos5l_nor4_1
XFILLER_30_1224 vddd vssd sg13cmos5l_decap_4
X_6595_ _6595_/X _6595_/A0 _6650_/A _6596_/S vddd vssd sg13cmos5l_mux2_1
X_5546_ _5546_/Y _5544_/Y _5545_/Y _5557_/C vddd vssd sg13cmos5l_o21ai_1
X_5477_ _5477_/Y _5416_/A _5475_/Y _5476_/Y _5474_/Y _5449_/Y vddd vssd sg13cmos5l_a221oi_1
X_4428_ _4428_/Y _4812_/B _4458_/B vddd vssd sg13cmos5l_nand2_1
X_7216_ _7216_/Q _7229_/CLK _7216_/D fanout365/X vddd vssd sg13cmos5l_dfrbpq_1
Xfanout401 _6964_/B_N fanout408/X vddd vssd sg13cmos5l_buf_1
Xfanout412 _3539_/A _6212_/A1 vddd vssd sg13cmos5l_buf_1
Xfanout423 _5326_/A _5898_/A1 vddd vssd sg13cmos5l_buf_1
XFILLER_8_1203 vddd vssd sg13cmos5l_decap_8
X_7147_ _7147_/Q _7190_/CLK _7147_/D fanout357/X vddd vssd sg13cmos5l_dfrbpq_1
Xfanout445 _5627_/A _5784_/A vddd vssd sg13cmos5l_buf_1
Xfanout434 _5733_/A io_in[2] vddd vssd sg13cmos5l_buf_1
Xfanout456 _6893_/A _6879_/A vddd vssd sg13cmos5l_buf_1
X_4359_ _4359_/Y _7093_/Q _4410_/A vddd vssd sg13cmos5l_nand2b_1
X_7078_ _7078_/Q _7276_/CLK _7078_/D fanout390/X vddd vssd sg13cmos5l_dfrbpq_1
X_6029_ _6029_/Y _7291_/Q _3581_/Y _5193_/B vddd vssd sg13cmos5l_a21oi_1
XFILLER_19_2513 vddd vssd sg13cmos5l_decap_8
Xfanout30 _6801_/B _6789_/Y vddd vssd sg13cmos5l_buf_1
Xfanout74 _6726_/A wire75/A vddd vssd sg13cmos5l_buf_1
XFILLER_19_1867 vddd vssd sg13cmos5l_decap_8
Xfanout41 _6321_/B _6312_/Y vddd vssd sg13cmos5l_buf_1
Xfanout52 _6686_/S _6674_/Y vddd vssd sg13cmos5l_buf_1
Xfanout63 _4821_/A _4528_/A vddd vssd sg13cmos5l_buf_1
Xclkbuf_leaf_18_SCK_regs _7286_/CLK clkload9/A vddd vssd sg13cmos5l_buf_8
XFILLER_11_988 vddd vssd sg13cmos5l_decap_8
XFILLER_13_84 vddd vssd sg13cmos5l_decap_4
XFILLER_13_1444 vddd vssd sg13cmos5l_decap_8
XFILLER_26_2528 vddd vssd sg13cmos5l_decap_8
XFILLER_8_0 vddd vssd sg13cmos5l_decap_8
Xtiedowns\[43\] dbus_in_right[11] vddd vssd sg13cmos5l_antennanp
XFILLER_2_697 vddd vssd sg13cmos5l_decap_8
XFILLER_24_2285 vddd vssd sg13cmos5l_decap_4
XFILLER_4_2357 vddd vssd sg13cmos5l_decap_8
XFILLER_8_1781 vddd vssd sg13cmos5l_decap_8
XFILLER_24_1584 vddd vssd sg13cmos5l_decap_8
XFILLER_18_554 vddd vssd sg13cmos5l_decap_8
XFILLER_2_2081 vddd vssd sg13cmos5l_decap_4
X_3730_ _3730_/Y _7127_/Q _6346_/A _3863_/B vddd vssd sg13cmos5l_a21oi_1
X_3661_ _3693_/A _3705_/B _3662_/B vddd vssd sg13cmos5l_nor2_1
XFILLER_9_263 vddd vssd sg13cmos5l_decap_8
XFILLER_31_1555 vddd vssd sg13cmos5l_decap_4
Xclkload11 clkload11/Y _7119_/CLK vddd vssd sg13cmos5l_inv_2
X_6380_ _6380_/Y _6380_/A _6382_/B vddd vssd sg13cmos5l_nand2_1
X_5400_ _5408_/B _7162_/Q _7163_/Q vddd vssd sg13cmos5l_nor2b_1
X_3592_ _5886_/C _3592_/A vddd vssd sg13cmos5l_inv_1
XFILLER_31_1599 vddd vssd sg13cmos5l_decap_8
X_5331_ _5331_/X _5331_/A _5331_/B vddd vssd sg13cmos5l_and2_1
XFILLER_6_981 vddd vssd sg13cmos5l_decap_8
X_7001_ _7001_/Q _7346_/CLK _7001_/D _6948_/Y vddd vssd sg13cmos5l_dfrbpq_1
XFILLER_25_2027 vddd vssd sg13cmos5l_decap_8
X_5262_ _5270_/B _5262_/A _5262_/B vddd vssd sg13cmos5l_nor2_1
X_5193_ _5215_/A _7298_/Q _5193_/B _5193_/C vddd vssd sg13cmos5l_nor3_1
X_4213_ _4213_/Y _5863_/A _6545_/A _3916_/Y vddd vssd sg13cmos5l_a21oi_1
XFILLER_9_1545 vddd vssd sg13cmos5l_decap_8
XFILLER_29_808 vddd vssd sg13cmos5l_decap_8
X_4144_ _4144_/Y _5380_/B _4144_/B vddd vssd sg13cmos5l_nand2_1
XFILLER_28_329 vddd vssd sg13cmos5l_decap_8
X_4075_ _4075_/Y _7106_/Q _6312_/A _3847_/Y vddd vssd sg13cmos5l_o21ai_1
XFILLER_24_579 vddd vssd sg13cmos5l_decap_8
X_4977_ sram_idata[5] _6777_/A _4980_/B vddd vssd sg13cmos5l_and2_1
X_6716_ _6716_/X _6716_/A0 _6408_/A _6717_/S vddd vssd sg13cmos5l_mux2_1
XFILLER_14_2421 vddd vssd sg13cmos5l_decap_8
XFILLER_11_207 vddd vssd sg13cmos5l_decap_8
XFILLER_32_1308 vddd vssd sg13cmos5l_decap_8
X_3928_ _3928_/X _3928_/A _3928_/B vddd vssd sg13cmos5l_or2_1
Xclkload5 clkload5/X clkload5/A vddd vssd sg13cmos5l_buf_8
X_6647_ _6647_/Y _6647_/A _6652_/S vddd vssd sg13cmos5l_nor2_1
X_3859_ _3859_/Y _3862_/A _4267_/B _7023_/D vddd vssd sg13cmos5l_o21ai_1
XFILLER_14_2498 vddd vssd sg13cmos5l_decap_8
X_6578_ _7242_/D _6578_/A1 _6581_/B _6577_/Y vddd vssd sg13cmos5l_a21oi_1
XFILLER_10_1639 vddd vssd sg13cmos5l_decap_8
X_5529_ _5531_/A _5529_/A _5529_/B vddd vssd sg13cmos5l_and2_1
XFILLER_1_7 vddd vssd sg13cmos5l_decap_8
Xfanout220 _6966_/A _6951_/A vddd vssd sg13cmos5l_buf_1
Xfanout231 _4508_/C _5713_/A vddd vssd sg13cmos5l_buf_1
Xfanout242 _4662_/A hold1513/X vddd vssd sg13cmos5l_buf_1
Xfanout253 _4551_/B fanout254/X vddd vssd sg13cmos5l_buf_1
Xfanout264 _6121_/B _6207_/S vddd vssd sg13cmos5l_buf_1
XFILLER_8_1066 vddd vssd sg13cmos5l_decap_8
Xfanout286 _5673_/A _7200_/Q vddd vssd sg13cmos5l_buf_1
XFILLER_25_2594 vddd vssd sg13cmos5l_decap_8
XFILLER_21_2458 vddd vssd sg13cmos5l_decap_8
Xfanout297 _5472_/B _5475_/B vddd vssd sg13cmos5l_buf_1
Xfanout275 _5972_/A _7240_/Q vddd vssd sg13cmos5l_buf_1
XFILLER_19_1620 vddd vssd sg13cmos5l_decap_8
XFILLER_30_549 vddd vssd sg13cmos5l_decap_8
XFILLER_11_752 vddd vssd sg13cmos5l_decap_4
XFILLER_32_2565 vddd vssd sg13cmos5l_decap_8
XFILLER_32_1831 vddd vssd sg13cmos5l_decap_8
XFILLER_13_1285 vddd vssd sg13cmos5l_decap_4
XFILLER_26_2336 vddd vssd sg13cmos5l_decap_8
XFILLER_26_1613 vddd vssd sg13cmos5l_decap_4
XFILLER_26_1646 vddd vssd sg13cmos5l_decap_8
XFILLER_24_2093 vddd vssd sg13cmos5l_decap_8
XFILLER_1_21 vddd vssd sg13cmos5l_decap_8
XFILLER_4_2132 vddd vssd sg13cmos5l_decap_8
XFILLER_19_852 vddd vssd sg13cmos5l_decap_8
XFILLER_4_1464 vddd vssd sg13cmos5l_decap_8
X_4900_ _4912_/B _5985_/S _4900_/B vddd vssd sg13cmos5l_nor2_1
X_5880_ _5880_/Y _6211_/A _5901_/A _5901_/B vddd vssd sg13cmos5l_nor3_1
X_4831_ _4831_/Y _4832_/B _4831_/B vddd vssd sg13cmos5l_nand2b_1
X_4762_ _4762_/Y _4778_/A _4762_/B vddd vssd sg13cmos5l_nor2_1
X_6501_ _6501_/Y _6532_/A _6505_/S vddd vssd sg13cmos5l_nor2_1
X_3713_ _6786_/B _3713_/A _4010_/B vddd vssd sg13cmos5l_or2_1
XFILLER_18_1196 vddd vssd sg13cmos5l_decap_8
X_4693_ _4697_/A _4670_/B _4691_/Y _4692_/Y vddd vssd sg13cmos5l_o21ai_1
X_6432_ _6432_/Y _6432_/A _6437_/S vddd vssd sg13cmos5l_nand2_1
X_3644_ _4852_/B _3645_/B vddd vssd sg13cmos5l_inv_1
X_6363_ _6371_/S _6363_/A _6789_/B vddd vssd sg13cmos5l_nor2_1
X_3575_ _5716_/B _3575_/A vddd vssd sg13cmos5l_inv_1
X_6294_ _6294_/Y _6294_/A vddd vssd sg13cmos5l_inv_1
X_5314_ _5314_/Y _7150_/Q _7151_/Q vddd vssd sg13cmos5l_nand2_1
Xoutbuffers\[74\] io_oe[1] _5043_/Y vddd vssd sg13cmos5l_buf_16
XFILLER_9_2021 vddd vssd sg13cmos5l_decap_4
XFILLER_25_1101 vddd vssd sg13cmos5l_decap_8
X_5245_ _6251_/A _5245_/A _5245_/B _5267_/B vddd vssd sg13cmos5l_nor3_1
XFILLER_29_28 vddd vssd sg13cmos5l_decap_8
X_5176_ _5184_/C _5266_/A _5176_/B vddd vssd sg13cmos5l_or2_1
X_4127_ _4127_/Y _4124_/Y _4125_/X _4126_/Y vddd vssd sg13cmos5l_o21ai_1
X_4058_ _4058_/Y _7148_/Q _4238_/B _3821_/Y vddd vssd sg13cmos5l_a21oi_1
XFILLER_0_2552 vddd vssd sg13cmos5l_decap_8
XFILLER_16_2505 vddd vssd sg13cmos5l_decap_8
XFILLER_32_1116 vddd vssd sg13cmos5l_decap_8
XFILLER_10_30 vddd vssd sg13cmos5l_decap_8
XFILLER_0_910 vddd vssd sg13cmos5l_decap_8
XFILLER_27_1944 vddd vssd sg13cmos5l_decap_4
XFILLER_25_2391 vddd vssd sg13cmos5l_decap_8
XFILLER_0_987 vddd vssd sg13cmos5l_decap_8
XFILLER_5_2463 vddd vssd sg13cmos5l_decap_8
XFILLER_28_682 vddd vssd sg13cmos5l_decap_8
XFILLER_16_877 vddd vssd sg13cmos5l_decap_8
XFILLER_19_2162 vddd vssd sg13cmos5l_decap_8
Xclkbuf_leaf_33_SCK_regs _7296_/CLK clkload8/A vddd vssd sg13cmos5l_buf_8
XFILLER_15_2059 vddd vssd sg13cmos5l_decap_8
Xhold509 _7001_/D _3476_/Y vddd vssd sg13cmos5l_dlygate4sd3_1
X_5030_ _5141_/A _7267_/Q _7266_/Q vddd vssd sg13cmos5l_nand2b_1
Xhold1209 _7263_/D _6612_/X vddd vssd sg13cmos5l_dlygate4sd3_1
XFILLER_26_619 vddd vssd sg13cmos5l_decap_4
X_6981_ _6981_/Q _6981_/CLK _6981_/D _6928_/Y vddd vssd sg13cmos5l_dfrbpq_1
XFILLER_20_1031 vddd vssd sg13cmos5l_decap_8
XFILLER_25_107 vddd vssd sg13cmos5l_decap_8
X_5932_ _5932_/Y _5933_/A _5933_/B vddd vssd sg13cmos5l_nor2_1
XFILLER_0_1136 vddd vssd sg13cmos5l_decap_8
X_5863_ _5863_/Y _5863_/A _7227_/Q _5868_/C _7229_/Q vddd vssd sg13cmos5l_nor4_1
XFILLER_22_869 vddd vssd sg13cmos5l_decap_8
X_5794_ _5794_/Y _5794_/A _5794_/B _5794_/C vddd vssd sg13cmos5l_nor3_1
X_4814_ _4814_/Y _4488_/Y _4813_/X _4812_/Y vddd vssd sg13cmos5l_o21ai_1
X_4745_ _4747_/B _4745_/A1 _4744_/Y _4742_/Y vddd vssd sg13cmos5l_o21ai_1
X_4676_ _4676_/Y _4671_/Y _4672_/Y _4673_/Y _4460_/B _4675_/Y vddd vssd sg13cmos5l_a221oi_1
X_3627_ _3627_/Y mask_rev_in[13] vddd vssd sg13cmos5l_inv_1
X_7395_ _7395_/Q _7395_/CLK _7395_/D _6816_/Y vddd vssd sg13cmos5l_dfrbpq_1
X_6415_ _6415_/Y _6415_/A1 _6416_/S _6414_/Y vddd vssd sg13cmos5l_a21oi_1
X_3558_ _5498_/B _3558_/A vddd vssd sg13cmos5l_inv_1
X_6346_ _6346_/Y _6346_/A _6726_/B vddd vssd sg13cmos5l_nand2_1
XFILLER_0_228 vddd vssd sg13cmos5l_decap_8
X_6277_ _6277_/Y _6276_/B _6275_/X _6276_/Y vddd vssd sg13cmos5l_a21oi_1
X_3489_ _4853_/A _4867_/A vddd vssd sg13cmos5l_inv_1
XFILLER_22_2520 vddd vssd sg13cmos5l_decap_8
X_5228_ _5233_/D _5228_/A _5261_/B vddd vssd sg13cmos5l_nor2_1
X_5159_ _5169_/A _5159_/A _5159_/B _5159_/C _5159_/D vddd vssd sg13cmos5l_nor4_1
XFILLER_22_2597 vddd vssd sg13cmos5l_decap_8
XFILLER_25_685 vddd vssd sg13cmos5l_decap_8
XFILLER_24_140 vddd vssd sg13cmos5l_decap_8
Xclkbuf_4_14__f_clk_regs _6981_/CLK clkbuf_3_7_0_clk_regs/X vddd vssd sg13cmos5l_buf_8
XFILLER_16_2368 vddd vssd sg13cmos5l_decap_8
XFILLER_12_1509 vddd vssd sg13cmos5l_decap_8
XFILLER_21_84 vddd vssd sg13cmos5l_decap_8
XFILLER_27_2464 vddd vssd sg13cmos5l_decap_8
XFILLER_7_2536 vddd vssd sg13cmos5l_decap_8
Xmax_cap93 _6640_/A _3865_/Y vddd vssd sg13cmos5l_buf_2
XFILLER_30_121 vddd vssd sg13cmos5l_decap_8
XFILLER_19_1280 vddd vssd sg13cmos5l_decap_8
XFILLER_8_840 vddd vssd sg13cmos5l_decap_8
XFILLER_30_198 vddd vssd sg13cmos5l_decap_8
X_4530_ _4534_/B _4556_/A _5659_/A vddd vssd sg13cmos5l_nand2b_1
X_4461_ _4461_/Y _4461_/A _4461_/B _4818_/B vddd vssd sg13cmos5l_nor3_1
XFILLER_7_86 vddd vssd sg13cmos5l_decap_8
XFILLER_7_372 vddd vssd sg13cmos5l_decap_4
X_6200_ _6201_/B _6272_/A _5221_/A _5237_/A vddd vssd sg13cmos5l_o21ai_1
X_7180_ _7180_/Q _7228_/CLK _7180_/D fanout362/X vddd vssd sg13cmos5l_dfrbpq_1
X_4392_ _4393_/D _4392_/A _4392_/B _4392_/C _4392_/D vddd vssd sg13cmos5l_nand4_1
X_6131_ _6131_/Y _3797_/X _5168_/C _5159_/B vddd vssd sg13cmos5l_a21oi_1
Xhold1006 _6333_/A1 _3602_/Y vddd vssd sg13cmos5l_dlygate4sd3_1
XFILLER_23_0 vddd vssd sg13cmos5l_decap_8
X_6062_ _6062_/Y _6060_/Y _6062_/B vddd vssd sg13cmos5l_nand2b_1
Xhold1039 _7075_/D _6768_/Y vddd vssd sg13cmos5l_dlygate4sd3_1
Xhold1017 _7297_/D _6664_/X vddd vssd sg13cmos5l_dlygate4sd3_1
Xhold1028 _3585_/A _7317_/Q vddd vssd sg13cmos5l_dlygate4sd3_1
X_5013_ _5013_/Y _5013_/A _5013_/B _5013_/C vddd vssd sg13cmos5l_nand3_1
XFILLER_27_928 vddd vssd sg13cmos5l_decap_4
Xoutbuffers\[37\] biasgen_coarse _7059_/Q vddd vssd sg13cmos5l_buf_16
X_7318__462 _7318_/RESET_B vddd vssd sg13cmos5l_tiehi
X_6964_ _6964_/Y _6966_/A _6964_/B_N vddd vssd sg13cmos5l_nor2b_1
X_5915_ _5916_/B _3526_/Y _7100_/Q _7099_/Q _3525_/Y vddd vssd sg13cmos5l_a22oi_1
X_6895_ _6895_/Y _6901_/A _6901_/B_N vddd vssd sg13cmos5l_nor2b_1
XFILLER_22_622 vddd vssd sg13cmos5l_decap_8
X_5846_ _5846_/Y _5871_/A _7222_/Q _7223_/Q _5848_/A vddd vssd sg13cmos5l_nand4_1
X_5777_ _5777_/Y _5790_/C _5776_/Y _5794_/A vddd vssd sg13cmos5l_o21ai_1
XFILLER_10_839 vddd vssd sg13cmos5l_decap_8
XFILLER_11_2210 vddd vssd sg13cmos5l_decap_8
X_4728_ _4728_/Y _4647_/B _4727_/Y _4590_/A vddd vssd sg13cmos5l_a21oi_1
X_4659_ _4659_/Y _4659_/A1 _3601_/Y _4488_/A _4656_/B vddd vssd sg13cmos5l_a22oi_1
XFILLER_11_1575 vddd vssd sg13cmos5l_decap_8
Xhold840 _7200_/D _6495_/X vddd vssd sg13cmos5l_dlygate4sd3_1
Xhold862 _7129_/D _6366_/X vddd vssd sg13cmos5l_dlygate4sd3_1
Xhold873 _7216_/D _6527_/X vddd vssd sg13cmos5l_dlygate4sd3_1
X_7378_ _7378_/Q _7380_/CLK _7378_/D _6892_/Y vddd vssd sg13cmos5l_dfrbpq_1
Xhold851 _4355_/C _4350_/Y vddd vssd sg13cmos5l_dlygate4sd3_1
XFILLER_27_1004 vddd vssd sg13cmos5l_decap_8
X_6329_ _6329_/Y _6329_/A _6789_/B vddd vssd sg13cmos5l_nor2_1
Xhold884 _7101_/D _6308_/X vddd vssd sg13cmos5l_dlygate4sd3_1
Xhold895 _3595_/A _7106_/Q vddd vssd sg13cmos5l_dlygate4sd3_1
XFILLER_29_210 vddd vssd sg13cmos5l_decap_8
XFILLER_22_2372 vddd vssd sg13cmos5l_decap_4
XFILLER_18_917 vddd vssd sg13cmos5l_decap_8
XFILLER_29_287 vddd vssd sg13cmos5l_decap_8
XFILLER_2_2455 vddd vssd sg13cmos5l_decap_4
XFILLER_32_408 vddd vssd sg13cmos5l_decap_8
XFILLER_16_84 vddd vssd sg13cmos5l_decap_8
XFILLER_16_2143 vddd vssd sg13cmos5l_decap_8
XFILLER_13_666 vddd vssd sg13cmos5l_decap_4
XFILLER_13_699 vddd vssd sg13cmos5l_decap_8
XFILLER_16_1475 vddd vssd sg13cmos5l_decap_8
Xtiedowns\[73\] mask_rev_in[29] vddd vssd sg13cmos5l_antennanp
XFILLER_10_1052 vddd vssd sg13cmos5l_decap_8
XFILLER_29_2548 vddd vssd sg13cmos5l_decap_8
XFILLER_23_2169 vddd vssd sg13cmos5l_decap_8
XFILLER_7_1632 vddd vssd sg13cmos5l_decap_8
XFILLER_7_1676 vddd vssd sg13cmos5l_decap_8
X_3961_ _6431_/A _3961_/A _3961_/B vddd vssd sg13cmos5l_nor2_1
XFILLER_32_920 vddd vssd sg13cmos5l_decap_8
X_5700_ _5700_/Y _5733_/A _5690_/Y _5691_/X _5871_/A vddd vssd sg13cmos5l_a22oi_1
X_6680_ _6680_/Y sram_odata[3] _6683_/S vddd vssd sg13cmos5l_nand2_1
X_3892_ _3892_/Y _6786_/A _6597_/A vddd vssd sg13cmos5l_nor2_1
XFILLER_32_997 vddd vssd sg13cmos5l_decap_8
X_5631_ _5642_/C _5647_/B _7196_/Q vddd vssd sg13cmos5l_nand2b_1
X_5562_ _5562_/Y _5502_/A _5560_/Y _5561_/Y _5559_/Y _5534_/Y vddd vssd sg13cmos5l_a221oi_1
X_7301_ _7301_/Q _7301_/CLK _7301_/D fanout377/X vddd vssd sg13cmos5l_dfrbpq_1
X_4513_ _4513_/Y _4501_/Y _4504_/Y _4510_/Y _4512_/Y _4509_/Y vddd vssd sg13cmos5l_a221oi_1
XFILLER_8_692 vddd vssd sg13cmos5l_decap_8
XFILLER_12_2563 vddd vssd sg13cmos5l_decap_8
X_5493_ _5493_/Y _5498_/C _5493_/B _5493_/C vddd vssd sg13cmos5l_nand3_1
X_7232_ _7232_/Q _7296_/CLK _7232_/D fanout371/X vddd vssd sg13cmos5l_dfrbpq_1
XFILLER_12_1873 vddd vssd sg13cmos5l_decap_8
X_4444_ _4446_/C _4757_/A _4444_/B vddd vssd sg13cmos5l_nor2_1
XFILLER_28_2058 vddd vssd sg13cmos5l_decap_8
X_4375_ _4392_/A _4698_/A _7126_/Q vddd vssd sg13cmos5l_xor2_1
X_7163_ _7163_/Q _7210_/CLK _7163_/D fanout356/X vddd vssd sg13cmos5l_dfrbpq_1
X_6114_ _6116_/A _5151_/C _6112_/Y _6113_/Y vddd vssd sg13cmos5l_o21ai_1
X_7094_ _7094_/Q _7263_/CLK _7094_/D _6865_/B_N vddd vssd sg13cmos5l_dfrbpq_1
X_6045_ _6045_/Y _6272_/A _5068_/C _5068_/B vddd vssd sg13cmos5l_o21ai_1
XFILLER_26_202 vddd vssd sg13cmos5l_decap_8
X_6947_ _6947_/Y _6948_/A _6968_/B_N vddd vssd sg13cmos5l_nor2b_1
XFILLER_23_920 vddd vssd sg13cmos5l_decap_8
X_6878_ _6878_/Y _6901_/A _6917_/B_N vddd vssd sg13cmos5l_nor2b_1
XFILLER_13_2305 vddd vssd sg13cmos5l_decap_8
XFILLER_17_2485 vddd vssd sg13cmos5l_decap_8
X_5829_ _5845_/C _7222_/Q _7223_/Q vddd vssd sg13cmos5l_nand2b_1
XFILLER_13_1648 vddd vssd sg13cmos5l_decap_8
XFILLER_11_1383 vddd vssd sg13cmos5l_decap_8
Xhold681 hold681/X _7149_/Q vddd vssd sg13cmos5l_dlygate4sd3_1
Xhold670 hold670/X _6353_/Y vddd vssd sg13cmos5l_dlygate4sd3_1
Xhold692 _6304_/A _7098_/Q vddd vssd sg13cmos5l_dlygate4sd3_1
XFILLER_24_2467 vddd vssd sg13cmos5l_decap_8
XFILLER_20_1619 vddd vssd sg13cmos5l_decap_4
XFILLER_17_202 vddd vssd sg13cmos5l_decap_8
Xhold1370 _7369_/D _4313_/X vddd vssd sg13cmos5l_dlygate4sd3_1
Xhold1392 _4432_/B _4396_/C vddd vssd sg13cmos5l_dlygate4sd3_1
XFILLER_2_2285 vddd vssd sg13cmos5l_decap_8
Xhold1381 _6675_/A0 _7315_/Q vddd vssd sg13cmos5l_dlygate4sd3_1
XFILLER_14_920 vddd vssd sg13cmos5l_decap_4
XFILLER_13_430 vddd vssd sg13cmos5l_decap_8
XFILLER_9_434 vddd vssd sg13cmos5l_decap_4
XFILLER_29_1611 vddd vssd sg13cmos5l_decap_8
X_4160_ _4160_/Y _7145_/Q _6390_/A _4183_/B1 vddd vssd sg13cmos5l_o21ai_1
XFILLER_3_2016 vddd vssd sg13cmos5l_decap_8
X_4091_ _4091_/Y _4091_/A _4182_/B vddd vssd sg13cmos5l_nand2_1
XFILLER_7_1440 vddd vssd sg13cmos5l_decap_4
XFILLER_3_1348 vddd vssd sg13cmos5l_decap_8
XFILLER_24_706 vddd vssd sg13cmos5l_decap_8
X_6801_ _6801_/Y _6801_/A _6801_/B vddd vssd sg13cmos5l_nand2_1
X_4993_ _6181_/B _7254_/Q _7255_/Q vddd vssd sg13cmos5l_nor2_1
X_7315__465 _7315_/RESET_B vddd vssd sg13cmos5l_tiehi
X_6732_ _6732_/Y _6732_/A _6735_/S vddd vssd sg13cmos5l_nor2_1
X_3944_ _3944_/Y _3944_/A _3966_/B vddd vssd sg13cmos5l_nand2_1
XFILLER_20_901 vddd vssd sg13cmos5l_decap_8
XFILLER_14_2603 vddd vssd sg13cmos5l_decap_4
XFILLER_32_794 vddd vssd sg13cmos5l_decap_8
Xoutbuffers\[0\] project_zero _5283_/Y vddd vssd sg13cmos5l_buf_16
X_3875_ _6615_/A _3875_/A _3889_/A vddd vssd sg13cmos5l_nand2_1
X_6663_ _6663_/X _6663_/A0 _6342_/A _6663_/S vddd vssd sg13cmos5l_mux2_1
X_5614_ _5614_/Y _7192_/Q _7193_/Q _5614_/C vddd vssd sg13cmos5l_nor3_1
XFILLER_17_1069 vddd vssd sg13cmos5l_decap_8
XFILLER_14_1946 vddd vssd sg13cmos5l_decap_4
X_6594_ _6594_/Y _6594_/A1 _6596_/S _6593_/Y vddd vssd sg13cmos5l_o21ai_1
X_5545_ _5545_/Y _5319_/A _5557_/B _5543_/Y vddd vssd sg13cmos5l_o21ai_1
XFILLER_14_1979 vddd vssd sg13cmos5l_decap_8
X_5476_ _5476_/Y _5795_/A1 _5472_/Y _5475_/Y vddd vssd sg13cmos5l_a21oi_1
X_4427_ _4461_/B _4458_/A _7083_/Q vddd vssd sg13cmos5l_nor2_1
X_7215_ _7215_/Q _7228_/CLK _7215_/D fanout365/X vddd vssd sg13cmos5l_dfrbpq_1
X_7322__458 _7322_/RESET_B vddd vssd sg13cmos5l_tiehi
X_7146_ _7146_/Q _7146_/CLK _7146_/D fanout357/X vddd vssd sg13cmos5l_dfrbpq_1
Xfanout402 _6865_/B_N fanout404/X vddd vssd sg13cmos5l_buf_1
Xfanout413 _6212_/A1 io_in[9] vddd vssd sg13cmos5l_buf_1
Xfanout446 _6225_/A _5784_/A vddd vssd sg13cmos5l_buf_1
Xfanout457 _6879_/A CSB vddd vssd sg13cmos5l_buf_1
Xfanout435 _5416_/A _5502_/A vddd vssd sg13cmos5l_buf_1
Xfanout424 _5757_/A _5898_/A1 vddd vssd sg13cmos5l_buf_1
X_4358_ _4358_/Y _3673_/Y _4352_/B _4357_/Y vddd vssd sg13cmos5l_a21oi_1
X_7077_ _7077_/Q _7077_/CLK _7077_/D fanout357/X vddd vssd sg13cmos5l_dfrbpq_1
X_4289_ _4289_/Y _6713_/A1 _4288_/B hold600/X vddd vssd sg13cmos5l_o21ai_1
X_6028_ _6028_/Y _6185_/C _5042_/C _6026_/Y _6027_/Y vddd vssd sg13cmos5l_a22oi_1
XFILLER_3_2572 vddd vssd sg13cmos5l_decap_4
XFILLER_27_588 vddd vssd sg13cmos5l_decap_4
XFILLER_19_2569 vddd vssd sg13cmos5l_decap_8
XFILLER_19_1824 vddd vssd sg13cmos5l_decap_8
Xfanout20 _4547_/A _4492_/X vddd vssd sg13cmos5l_buf_1
Xfanout31 _6803_/B _6789_/Y vddd vssd sg13cmos5l_buf_1
XFILLER_23_783 vddd vssd sg13cmos5l_decap_8
XFILLER_17_2271 vddd vssd sg13cmos5l_decap_4
Xfanout53 _6663_/S _6664_/S vddd vssd sg13cmos5l_buf_1
Xfanout64 _4528_/A _4394_/Y vddd vssd sg13cmos5l_buf_1
Xfanout42 _6327_/B _6312_/Y vddd vssd sg13cmos5l_buf_1
XFILLER_17_2293 vddd vssd sg13cmos5l_decap_8
Xfanout97 _3962_/A _3718_/Y vddd vssd sg13cmos5l_buf_1
Xfanout86 _4647_/B _4461_/Y vddd vssd sg13cmos5l_buf_1
XFILLER_11_967 vddd vssd sg13cmos5l_decap_8
XFILLER_13_63 vddd vssd sg13cmos5l_decap_8
XFILLER_26_2507 vddd vssd sg13cmos5l_decap_8
Xtiedowns\[36\] dbus_in_right[4] vddd vssd sg13cmos5l_antennanp
XFILLER_24_2264 vddd vssd sg13cmos5l_decap_8
XFILLER_8_2494 vddd vssd sg13cmos5l_decap_8
XFILLER_4_2369 vddd vssd sg13cmos5l_decap_8
XFILLER_18_1345 vddd vssd sg13cmos5l_decap_8
X_3660_ _3662_/B _4333_/A _3660_/A1 _3672_/S vddd vssd sg13cmos5l_mux2_1
XFILLER_16_1091 vddd vssd sg13cmos5l_decap_8
X_3591_ _3591_/Y _3591_/A vddd vssd sg13cmos5l_inv_1
X_5330_ _5330_/Y _5727_/A _5328_/C _5328_/Y vddd vssd sg13cmos5l_o21ai_1
X_5261_ _6268_/A _5261_/A _5261_/B vddd vssd sg13cmos5l_nor2_1
X_7000_ _7000_/Q _7346_/CLK _7000_/D _6947_/Y vddd vssd sg13cmos5l_dfrbpq_1
XFILLER_25_2006 vddd vssd sg13cmos5l_decap_8
X_4212_ _4212_/X _5901_/A _6554_/A _6545_/A vddd vssd sg13cmos5l_a21o_1
XFILLER_9_1502 vddd vssd sg13cmos5l_decap_8
XFILLER_29_1485 vddd vssd sg13cmos5l_decap_8
X_5192_ _5193_/C _7274_/Q _7275_/Q _5265_/B vddd vssd sg13cmos5l_nor3_1
X_4143_ _4143_/X _7163_/Q _6424_/A _4144_/B vddd vssd sg13cmos5l_a21o_1
XFILLER_28_308 vddd vssd sg13cmos5l_decap_8
X_4074_ _4074_/Y _7114_/Q _3863_/B _4072_/Y _4073_/Y _4253_/A vddd vssd sg13cmos5l_a221oi_1
XFILLER_3_1156 vddd vssd sg13cmos5l_decap_8
X_4976_ sram_idata[4] _6759_/A _4980_/B vddd vssd sg13cmos5l_and2_1
X_6715_ _6715_/X _6715_/A0 _6722_/A _6717_/S vddd vssd sg13cmos5l_mux2_1
XFILLER_20_720 vddd vssd sg13cmos5l_decap_4
XFILLER_18_2591 vddd vssd sg13cmos5l_decap_8
X_3927_ _3934_/B _3928_/A _3928_/B vddd vssd sg13cmos5l_nor2_1
X_6646_ _6652_/S _6646_/A _6726_/B vddd vssd sg13cmos5l_and2_1
Xclkload6 clkload6/X clkload6/A vddd vssd sg13cmos5l_buf_8
XFILLER_14_2477 vddd vssd sg13cmos5l_decap_8
X_3858_ _3858_/Y _6299_/A sram_odata[4] _3758_/X wire10/X _4300_/B vddd vssd sg13cmos5l_a221oi_1
X_3789_ _3789_/Y _4179_/A1 sram_odata[6] _3756_/X wire14/X _4300_/B vddd vssd sg13cmos5l_a221oi_1
X_6577_ _6577_/Y _6727_/A _6581_/B vddd vssd sg13cmos5l_nor2_1
XFILLER_14_1787 vddd vssd sg13cmos5l_decap_8
X_5528_ _5528_/Y _5528_/A _5528_/B _5530_/B vddd vssd sg13cmos5l_nand3_1
X_5459_ _5459_/Y _5544_/A _5459_/B _5465_/B vddd vssd sg13cmos5l_nor3_1
Xfanout221 _6948_/A _6923_/A vddd vssd sg13cmos5l_buf_1
Xfanout232 _5713_/A hold1460/X vddd vssd sg13cmos5l_buf_1
Xfanout210 _6840_/A _6835_/A vddd vssd sg13cmos5l_buf_1
XFILLER_25_2573 vddd vssd sg13cmos5l_decap_8
X_7129_ _7129_/Q _7273_/CLK _7129_/D fanout390/X vddd vssd sg13cmos5l_dfrbpq_1
Xfanout265 _6207_/S hold1417/X vddd vssd sg13cmos5l_buf_1
Xfanout243 _4698_/A _5457_/A vddd vssd sg13cmos5l_buf_1
Xfanout254 fanout254/X _4698_/B vddd vssd sg13cmos5l_buf_1
Xfanout287 _5647_/B hold1405/X vddd vssd sg13cmos5l_buf_1
XFILLER_21_2437 vddd vssd sg13cmos5l_decap_8
Xfanout298 _5475_/B hold1277/X vddd vssd sg13cmos5l_buf_1
Xfanout276 _6232_/B hold1436/X vddd vssd sg13cmos5l_buf_1
XFILLER_21_1725 vddd vssd sg13cmos5l_decap_8
XFILLER_19_2388 vddd vssd sg13cmos5l_decap_8
XFILLER_32_2544 vddd vssd sg13cmos5l_decap_8
XFILLER_24_84 vddd vssd sg13cmos5l_decap_8
XFILLER_17_2090 vddd vssd sg13cmos5l_decap_4
XFILLER_15_1518 vddd vssd sg13cmos5l_decap_8
XFILLER_11_731 vddd vssd sg13cmos5l_decap_8
XFILLER_32_1810 vddd vssd sg13cmos5l_decap_8
XFILLER_7_713 vddd vssd sg13cmos5l_decap_4
XFILLER_27_7 vddd vssd sg13cmos5l_decap_8
XFILLER_1_66 vddd vssd sg13cmos5l_decap_8
XFILLER_4_2199 vddd vssd sg13cmos5l_decap_8
XFILLER_20_1279 vddd vssd sg13cmos5l_decap_8
X_4830_ _4830_/Y _4916_/A _4827_/Y _4903_/A _4829_/Y _3641_/Y vddd vssd sg13cmos5l_a221oi_1
XFILLER_21_517 vddd vssd sg13cmos5l_decap_8
X_4761_ _4761_/X _4507_/X _4755_/Y _4760_/Y vddd vssd sg13cmos5l_a21o_1
XFILLER_14_580 vddd vssd sg13cmos5l_decap_8
X_6500_ _7202_/D _6540_/A1 _6505_/S hold979/X vddd vssd sg13cmos5l_o21ai_1
X_3712_ _3712_/Y _3713_/A _4010_/B vddd vssd sg13cmos5l_nor2_1
X_4692_ _4692_/Y _4670_/B _4691_/Y _4512_/A vddd vssd sg13cmos5l_a21oi_1
X_3643_ _3645_/B _4856_/B _4862_/A _4867_/B vddd vssd sg13cmos5l_nor3_1
X_6431_ _6437_/S _6431_/A _6753_/B vddd vssd sg13cmos5l_nand2_1
X_6362_ _6362_/Y _6344_/A _6361_/B hold646/X vddd vssd sg13cmos5l_o21ai_1
X_5313_ _5313_/Y _5828_/B2 _5326_/D _5331_/A _5294_/C _5327_/B vddd vssd sg13cmos5l_a221oi_1
XFILLER_9_2000 vddd vssd sg13cmos5l_decap_8
X_3574_ _5721_/A _7206_/Q vddd vssd sg13cmos5l_inv_1
X_6293_ _6294_/A _7080_/Q _7081_/Q _7082_/Q vddd vssd sg13cmos5l_a21oi_1
Xoutbuffers\[67\] idac2_value[4] _7049_/Q vddd vssd sg13cmos5l_buf_16
X_5244_ _5252_/B _5167_/A _5244_/B vddd vssd sg13cmos5l_nand2b_1
XFILLER_29_1293 vddd vssd sg13cmos5l_decap_8
X_5175_ _6156_/B _5259_/A _5175_/B vddd vssd sg13cmos5l_nand2b_1
Xclkbuf_leaf_3_SCK_regs _7171_/CLK clkbuf_3_0_0_SCK_regs/X vddd vssd sg13cmos5l_buf_8
X_4126_ _4126_/Y _7215_/Q _6522_/A _6514_/A vddd vssd sg13cmos5l_a21oi_1
XFILLER_28_127 vddd vssd sg13cmos5l_decap_8
X_4057_ _4057_/Y _5327_/A _4057_/B _6395_/B vddd vssd sg13cmos5l_nor3_1
XFILLER_0_2531 vddd vssd sg13cmos5l_decap_8
Xclkbuf_4_13__f_clk_regs _7346_/CLK clkbuf_3_6_0_clk_regs/X vddd vssd sg13cmos5l_buf_8
X_4959_ _7305_/D _4943_/B _4958_/Y hold939/X vddd vssd sg13cmos5l_o21ai_1
X_6629_ _7274_/D _6635_/A1 _6632_/S hold973/X vddd vssd sg13cmos5l_a21oi_1
XFILLER_0_966 vddd vssd sg13cmos5l_decap_8
XFILLER_25_2370 vddd vssd sg13cmos5l_decap_8
XFILLER_19_105 vddd vssd sg13cmos5l_decap_8
XFILLER_5_2431 vddd vssd sg13cmos5l_decap_8
XFILLER_21_2256 vddd vssd sg13cmos5l_decap_4
XFILLER_28_661 vddd vssd sg13cmos5l_decap_8
XFILLER_21_2289 vddd vssd sg13cmos5l_decap_8
XFILLER_19_84 vddd vssd sg13cmos5l_decap_8
XFILLER_15_322 vddd vssd sg13cmos5l_decap_4
XFILLER_30_347 vddd vssd sg13cmos5l_decap_8
XFILLER_10_1982 vddd vssd sg13cmos5l_decap_4
XFILLER_26_2178 vddd vssd sg13cmos5l_decap_4
X_6980_ _6980_/Q _6981_/CLK _6980_/D _6927_/Y vddd vssd sg13cmos5l_dfrbpq_1
XFILLER_4_1240 vddd vssd sg13cmos5l_decap_8
XFILLER_19_672 vddd vssd sg13cmos5l_decap_8
X_5931_ _5931_/Y _5945_/A _5933_/B _5931_/C vddd vssd sg13cmos5l_nor3_1
X_5862_ _5862_/Y _3541_/Y _3591_/Y _5860_/Y _7228_/Q _5861_/Y vddd vssd sg13cmos5l_a221oi_1
XFILLER_22_848 vddd vssd sg13cmos5l_decap_8
X_4813_ _4813_/X _6809_/A _4813_/B vddd vssd sg13cmos5l_xor2_1
X_5793_ _5793_/Y _5788_/Y _5789_/X _5792_/Y vddd vssd sg13cmos5l_o21ai_1
X_4744_ _4744_/Y _4762_/B _3597_/Y _4743_/Y vddd vssd sg13cmos5l_a21oi_1
X_4675_ _4675_/Y _4745_/A1 _4674_/Y _4650_/A vddd vssd sg13cmos5l_a21oi_1
X_7394_ _7394_/Q _7394_/CLK _7394_/D _6817_/Y vddd vssd sg13cmos5l_dfrbpq_1
X_3626_ _3626_/Y mask_rev_in[4] vddd vssd sg13cmos5l_inv_1
X_6414_ _6414_/Y _6767_/A _6416_/S vddd vssd sg13cmos5l_nor2_1
X_6345_ _6345_/Y hold810/X _6329_/Y _6344_/Y vddd vssd sg13cmos5l_o21ai_1
X_3557_ _5498_/A _3557_/A vddd vssd sg13cmos5l_inv_1
X_6276_ _6276_/Y _6276_/A _6276_/B vddd vssd sg13cmos5l_nor2_1
X_5227_ _5237_/A _5227_/A vddd vssd sg13cmos5l_inv_1
X_3488_ _3488_/Y _4813_/B vddd vssd sg13cmos5l_inv_1
XFILLER_29_1090 vddd vssd sg13cmos5l_decap_8
X_5158_ _5159_/D _6123_/B _6145_/C _5157_/Y vddd vssd sg13cmos5l_o21ai_1
XFILLER_22_2576 vddd vssd sg13cmos5l_decap_8
X_4109_ _4109_/Y _4104_/Y _4106_/Y _4108_/Y vddd vssd sg13cmos5l_a21oi_1
X_5089_ _5266_/A _7242_/Q _7243_/Q vddd vssd sg13cmos5l_nand2_1
XFILLER_0_2350 vddd vssd sg13cmos5l_decap_8
XFILLER_0_2394 vddd vssd sg13cmos5l_decap_8
XFILLER_25_664 vddd vssd sg13cmos5l_decap_8
XFILLER_0_1660 vddd vssd sg13cmos5l_decap_4
XFILLER_24_196 vddd vssd sg13cmos5l_decap_8
XFILLER_9_808 vddd vssd sg13cmos5l_decap_8
XFILLER_16_1624 vddd vssd sg13cmos5l_decap_8
XFILLER_8_307 vddd vssd sg13cmos5l_decap_4
XFILLER_16_1657 vddd vssd sg13cmos5l_decap_8
XFILLER_21_63 vddd vssd sg13cmos5l_decap_8
XFILLER_27_2443 vddd vssd sg13cmos5l_decap_8
XFILLER_7_2515 vddd vssd sg13cmos5l_decap_8
XFILLER_27_1731 vddd vssd sg13cmos5l_decap_8
XFILLER_21_2064 vddd vssd sg13cmos5l_decap_8
XFILLER_1_2136 vddd vssd sg13cmos5l_decap_8
XFILLER_21_1374 vddd vssd sg13cmos5l_decap_8
Xmax_cap94 _3740_/B _3934_/A vddd vssd sg13cmos5l_buf_4
XFILLER_30_100 vddd vssd sg13cmos5l_decap_8
XFILLER_15_163 vddd vssd sg13cmos5l_decap_4
XFILLER_30_177 vddd vssd sg13cmos5l_decap_8
XFILLER_32_2171 vddd vssd sg13cmos5l_decap_8
XFILLER_15_1156 vddd vssd sg13cmos5l_decap_8
XFILLER_7_65 vddd vssd sg13cmos5l_decap_8
XFILLER_8_885 vddd vssd sg13cmos5l_decap_8
X_4460_ _4505_/B _4460_/A _4460_/B vddd vssd sg13cmos5l_nor2_1
X_4391_ _4394_/C _4391_/A _4391_/B _4391_/C vddd vssd sg13cmos5l_nor3_1
XFILLER_10_2491 vddd vssd sg13cmos5l_decap_8
X_6130_ _6130_/Y _5159_/C _6128_/Y _6129_/Y vddd vssd sg13cmos5l_o21ai_1
X_6061_ _6062_/B _6146_/A _6060_/B _5100_/C vddd vssd sg13cmos5l_a21oi_1
XFILLER_6_2036 vddd vssd sg13cmos5l_decap_4
Xhold1007 _7113_/D _6333_/Y vddd vssd sg13cmos5l_dlygate4sd3_1
Xhold1029 _6679_/A1 _3585_/Y vddd vssd sg13cmos5l_dlygate4sd3_1
X_5012_ _5013_/C _7290_/Q _5233_/A _5012_/C _5012_/D vddd vssd sg13cmos5l_nor4_1
Xhold1018 _3582_/A _7219_/Q vddd vssd sg13cmos5l_dlygate4sd3_1
XFILLER_16_0 vddd vssd sg13cmos5l_decap_8
X_6963_ _6963_/Y _6966_/A _6964_/B_N vddd vssd sg13cmos5l_nor2b_1
XFILLER_4_1081 vddd vssd sg13cmos5l_decap_8
X_5914_ _5916_/A _3525_/Y _7099_/Q _5913_/Y vddd vssd sg13cmos5l_o21ai_1
X_6894_ _6894_/Y _6917_/A _6915_/B_N vddd vssd sg13cmos5l_nor2b_1
X_5845_ _5847_/A _7224_/Q _7225_/Q _5845_/C vddd vssd sg13cmos5l_nor3_1
XFILLER_22_667 vddd vssd sg13cmos5l_decap_8
X_5776_ _5776_/Y _7316_/Q _5791_/B vddd vssd sg13cmos5l_nor2b_1
Xtiedowns\[2\] sram_odata[2] vddd vssd sg13cmos5l_antennanp
X_4727_ _4727_/Y _4745_/A1 _4722_/Y _4726_/X vddd vssd sg13cmos5l_o21ai_1
XFILLER_11_2244 vddd vssd sg13cmos5l_decap_8
X_4658_ _4658_/Y _4656_/Y _4657_/Y _4647_/Y vddd vssd sg13cmos5l_o21ai_1
X_3609_ _3609_/Y _7033_/Q vddd vssd sg13cmos5l_inv_1
Xhold830 _3596_/A _7107_/Q vddd vssd sg13cmos5l_dlygate4sd3_1
X_4589_ _4590_/B _4647_/B _4576_/X _4588_/Y vddd vssd sg13cmos5l_a21oi_1
Xhold841 _5930_/A _6973_/Q vddd vssd sg13cmos5l_dlygate4sd3_1
Xhold863 hold863/X _7099_/Q vddd vssd sg13cmos5l_dlygate4sd3_1
X_7377_ _7377_/Q _7380_/CLK _7377_/D _6891_/Y vddd vssd sg13cmos5l_dfrbpq_1
Xhold852 _7359_/D _4356_/Y vddd vssd sg13cmos5l_dlygate4sd3_1
Xhold874 hold874/X _7161_/Q vddd vssd sg13cmos5l_dlygate4sd3_1
Xhold885 hold885/X _7102_/Q vddd vssd sg13cmos5l_dlygate4sd3_1
X_6328_ _6328_/Y hold947/X _6327_/B _6327_/Y vddd vssd sg13cmos5l_o21ai_1
Xhold896 hold896/X _4786_/B vddd vssd sg13cmos5l_dlygate4sd3_1
X_6259_ _6259_/Y _5713_/A _7301_/Q _6121_/B vddd vssd sg13cmos5l_a21oi_1
XFILLER_6_2592 vddd vssd sg13cmos5l_decap_8
XFILLER_29_266 vddd vssd sg13cmos5l_decap_8
XFILLER_22_1683 vddd vssd sg13cmos5l_decap_8
XFILLER_26_962 vddd vssd sg13cmos5l_decap_4
XFILLER_2_1799 vddd vssd sg13cmos5l_decap_8
XFILLER_25_483 vddd vssd sg13cmos5l_decap_4
XFILLER_16_63 vddd vssd sg13cmos5l_decap_8
XFILLER_16_2188 vddd vssd sg13cmos5l_decap_8
XFILLER_12_199 vddd vssd sg13cmos5l_decap_8
XFILLER_32_84 vddd vssd sg13cmos5l_decap_8
XFILLER_29_2527 vddd vssd sg13cmos5l_decap_8
Xtiedowns\[66\] mask_rev_in[22] vddd vssd sg13cmos5l_antennanp
XFILLER_4_332 vddd vssd sg13cmos5l_decap_8
XFILLER_10_1031 vddd vssd sg13cmos5l_decap_8
XFILLER_10_1075 vddd vssd sg13cmos5l_decap_4
XFILLER_29_1837 vddd vssd sg13cmos5l_decap_8
XFILLER_4_398 vddd vssd sg13cmos5l_decap_8
XFILLER_23_2104 vddd vssd sg13cmos5l_decap_8
XFILLER_7_1611 vddd vssd sg13cmos5l_decap_8
XFILLER_17_984 vddd vssd sg13cmos5l_decap_8
XFILLER_17_951 vddd vssd sg13cmos5l_decap_4
X_3960_ _3960_/Y wire98/A _3966_/B vddd vssd sg13cmos5l_nand2_1
XFILLER_32_976 vddd vssd sg13cmos5l_decap_8
X_3891_ _3891_/Y _3885_/Y _3886_/Y _3890_/Y vddd vssd sg13cmos5l_o21ai_1
X_5630_ _5632_/A _5629_/A _5633_/B vddd vssd sg13cmos5l_nand2b_1
X_5561_ _5561_/Y _5795_/A1 _5557_/Y _5560_/Y vddd vssd sg13cmos5l_a21oi_1
XFILLER_12_2542 vddd vssd sg13cmos5l_decap_8
X_7300_ _7300_/Q _7300_/CLK _7300_/D fanout377/X vddd vssd sg13cmos5l_dfrbpq_1
X_4512_ _4512_/Y _4512_/A _4512_/B vddd vssd sg13cmos5l_nor2_1
X_5492_ _5493_/C _5464_/A _7177_/Q _5483_/Y vddd vssd sg13cmos5l_o21ai_1
X_7231_ _7231_/Q _7231_/CLK _7231_/D fanout368/X vddd vssd sg13cmos5l_dfrbpq_1
X_4443_ _4444_/B _4778_/A _4756_/B vddd vssd sg13cmos5l_nand2_1
X_7162_ _7162_/Q _7164_/CLK _7162_/D fanout356/X vddd vssd sg13cmos5l_dfrbpq_1
X_4374_ _4390_/A _7337_/Q _7125_/Q vddd vssd sg13cmos5l_xnor2_1
X_6113_ _6113_/Y _6272_/A _5151_/C _5149_/C vddd vssd sg13cmos5l_a21oi_1
XFILLER_8_1408 vddd vssd sg13cmos5l_decap_8
X_7093_ _7093_/Q _7263_/CLK _7093_/D _6870_/B_N vddd vssd sg13cmos5l_dfrbpq_1
XFILLER_6_1110 vddd vssd sg13cmos5l_decap_8
X_6044_ _6044_/Y _3822_/Y _5069_/B _6043_/Y vddd vssd sg13cmos5l_o21ai_1
X_6946_ _6946_/Y _6948_/A _6968_/B_N vddd vssd sg13cmos5l_nor2b_1
XFILLER_17_2464 vddd vssd sg13cmos5l_decap_8
X_6877_ _6877_/Y _6901_/A _6901_/B_N vddd vssd sg13cmos5l_nor2b_1
XFILLER_22_486 vddd vssd sg13cmos5l_decap_4
X_5828_ _5828_/Y _5294_/C _5842_/A _5848_/B _5828_/B2 _3920_/A vddd vssd sg13cmos5l_a221oi_1
XFILLER_17_1763 vddd vssd sg13cmos5l_decap_8
X_5759_ _5759_/Y _5759_/A _5759_/B _5759_/C vddd vssd sg13cmos5l_nand3_1
XFILLER_11_2085 vddd vssd sg13cmos5l_decap_8
XFILLER_11_1362 vddd vssd sg13cmos5l_decap_8
Xhold671 _6347_/A _7120_/Q vddd vssd sg13cmos5l_dlygate4sd3_1
XFILLER_11_1395 vddd vssd sg13cmos5l_decap_8
Xhold660 _4399_/A _4398_/Y vddd vssd sg13cmos5l_dlygate4sd3_1
Xhold682 _7149_/D _6401_/X vddd vssd sg13cmos5l_dlygate4sd3_1
Xhold693 hold693/X _6304_/Y vddd vssd sg13cmos5l_dlygate4sd3_1
XFILLER_28_1870 vddd vssd sg13cmos5l_decap_8
XFILLER_24_2446 vddd vssd sg13cmos5l_decap_8
Xhold1360 hold1360/X _7194_/Q vddd vssd sg13cmos5l_dlygate4sd3_1
Xhold1371 _3628_/A _7082_/Q vddd vssd sg13cmos5l_dlygate4sd3_1
Xhold1393 hold1393/X _4432_/Y vddd vssd sg13cmos5l_dlygate4sd3_1
Xhold1382 _7315_/D _6675_/X vddd vssd sg13cmos5l_dlygate4sd3_1
XFILLER_27_84 vddd vssd sg13cmos5l_decap_8
XFILLER_17_269 vddd vssd sg13cmos5l_decap_8
XFILLER_32_217 vddd vssd sg13cmos5l_decap_8
XFILLER_25_280 vddd vssd sg13cmos5l_decap_8
XFILLER_31_1705 vddd vssd sg13cmos5l_decap_4
XFILLER_29_1634 vddd vssd sg13cmos5l_decap_8
XFILLER_27_2070 vddd vssd sg13cmos5l_decap_4
XFILLER_4_88 vddd vssd sg13cmos5l_decap_8
X_4090_ _4090_/Y _4087_/Y _4088_/Y hold583/X vddd vssd sg13cmos5l_o21ai_1
XFILLER_3_1327 vddd vssd sg13cmos5l_decap_8
X_6800_ _6800_/X hold821/X _6777_/A _6803_/B vddd vssd sg13cmos5l_mux2_1
X_4992_ _5182_/A _7301_/Q _6121_/B vddd vssd sg13cmos5l_or2_1
X_6731_ _6731_/X _6581_/A _6731_/A1 _6735_/S vddd vssd sg13cmos5l_mux2_1
X_3943_ _6468_/A _3944_/A _3966_/B vddd vssd sg13cmos5l_and2_1
XFILLER_32_773 vddd vssd sg13cmos5l_decap_8
X_3874_ wire90/A _3876_/A _3874_/B _3874_/C _3876_/D vddd vssd sg13cmos5l_nor4_1
X_6662_ _7295_/D _6662_/A1 _6664_/S _6661_/Y vddd vssd sg13cmos5l_o21ai_1
X_5613_ _5613_/Y _5613_/A _7193_/Q _5613_/C vddd vssd sg13cmos5l_nor3_1
XFILLER_14_1914 vddd vssd sg13cmos5l_decap_8
XFILLER_20_979 vddd vssd sg13cmos5l_decap_8
X_6593_ _6593_/Y _6636_/A _6596_/S vddd vssd sg13cmos5l_nand2_1
XFILLER_30_1259 vddd vssd sg13cmos5l_decap_8
Xoutbuffers\[97\] dbus_out[0] _5310_/Y vddd vssd sg13cmos5l_buf_16
X_5544_ _5544_/Y _5544_/A _5544_/B _5557_/A vddd vssd sg13cmos5l_nor3_1
X_5475_ _5475_/Y _7172_/Q _5475_/B _5475_/C vddd vssd sg13cmos5l_nor3_1
X_7214_ _7214_/Q _7214_/CLK _7214_/D fanout365/X vddd vssd sg13cmos5l_dfrbpq_1
X_4426_ _4459_/B _4458_/A _4533_/A vddd vssd sg13cmos5l_nor2_1
X_7145_ _7145_/Q _7189_/CLK _7145_/D fanout350/X vddd vssd sg13cmos5l_dfrbpq_1
Xfanout414 _5566_/A _5593_/A vddd vssd sg13cmos5l_buf_1
Xfanout403 _6870_/B_N fanout404/X vddd vssd sg13cmos5l_buf_1
Xfanout447 _5784_/A io_in[10] vddd vssd sg13cmos5l_buf_1
Xfanout425 _5841_/A _5898_/A1 vddd vssd sg13cmos5l_buf_1
Xfanout436 _5502_/A _5976_/A vddd vssd sg13cmos5l_buf_1
X_4357_ _4357_/Y _4357_/A _4357_/B vddd vssd sg13cmos5l_nor2_1
X_7076_ _7076_/Q _7077_/CLK _7076_/D fanout353/X vddd vssd sg13cmos5l_dfrbpq_1
X_4288_ _4288_/Y _4309_/B _4288_/B vddd vssd sg13cmos5l_nand2_1
XFILLER_21_1907 vddd vssd sg13cmos5l_decap_4
X_6027_ _6027_/Y _6049_/A _5025_/C _5042_/C vddd vssd sg13cmos5l_a21oi_1
XFILLER_27_512 vddd vssd sg13cmos5l_decap_8
XFILLER_3_2584 vddd vssd sg13cmos5l_decap_8
XFILLER_19_2548 vddd vssd sg13cmos5l_decap_8
XFILLER_19_1803 vddd vssd sg13cmos5l_decap_8
X_6929_ _6929_/Y _6965_/A _6945_/B_N vddd vssd sg13cmos5l_nor2b_1
Xfanout32 _6776_/S _6777_/B vddd vssd sg13cmos5l_buf_1
Xfanout65 _6395_/B _3961_/B vddd vssd sg13cmos5l_buf_1
Xfanout54 _6805_/B _6301_/Y vddd vssd sg13cmos5l_buf_1
Xfanout43 _4954_/B _4960_/B vddd vssd sg13cmos5l_buf_1
XFILLER_17_1560 vddd vssd sg13cmos5l_decap_8
Xfanout87 _4806_/A _4461_/Y vddd vssd sg13cmos5l_buf_1
XFILLER_11_946 vddd vssd sg13cmos5l_decap_8
XFILLER_13_42 vddd vssd sg13cmos5l_decap_8
XFILLER_30_2483 vddd vssd sg13cmos5l_decap_8
XFILLER_13_1479 vddd vssd sg13cmos5l_decap_8
Xhold490 _4958_/A hold937/X vddd vssd sg13cmos5l_dlygate4sd3_1
XFILLER_8_2473 vddd vssd sg13cmos5l_decap_8
XFILLER_4_1603 vddd vssd sg13cmos5l_decap_8
XFILLER_4_2315 vddd vssd sg13cmos5l_decap_8
Xclkbuf_leaf_27_SCK_regs _7263_/CLK clkload7/A vddd vssd sg13cmos5l_buf_8
Xtiedowns\[29\] dbus_in_left[9] vddd vssd sg13cmos5l_antennanp
XFILLER_4_1669 vddd vssd sg13cmos5l_decap_8
Xhold1190 _3514_/A _7245_/Q vddd vssd sg13cmos5l_dlygate4sd3_1
XFILLER_2_1393 vddd vssd sg13cmos5l_decap_4
XFILLER_13_283 vddd vssd sg13cmos5l_decap_8
XFILLER_16_1081 vddd vssd sg13cmos5l_decap_4
X_3590_ _5868_/C _3590_/A vddd vssd sg13cmos5l_inv_1
XFILLER_6_950 vddd vssd sg13cmos5l_decap_8
XFILLER_29_2143 vddd vssd sg13cmos5l_decap_8
X_5260_ _5271_/C _6261_/B _5260_/B _5260_/C _5260_/D vddd vssd sg13cmos5l_nor4_1
XFILLER_29_2165 vddd vssd sg13cmos5l_decap_8
XFILLER_5_493 vddd vssd sg13cmos5l_decap_8
X_4211_ _4211_/Y _6215_/A _6561_/A _4209_/Y _4210_/Y _6554_/A vddd vssd sg13cmos5l_a221oi_1
X_5191_ _5265_/B _7276_/Q _7277_/Q vddd vssd sg13cmos5l_nand2b_1
X_4142_ _4142_/Y _5429_/B _6431_/A _4140_/Y _4141_/Y _6424_/A vddd vssd sg13cmos5l_a221oi_1
X_4073_ _4073_/Y _7122_/Q _6346_/A _3863_/B vddd vssd sg13cmos5l_a21oi_1
Xclkbuf_3_4_0_clk_regs clkbuf_3_4_0_clk_regs/X clkbuf_0_clk_regs/X vddd vssd sg13cmos5l_buf_8
XFILLER_7_1293 vddd vssd sg13cmos5l_decap_8
Xclkbuf_4_12__f_clk_regs _7020_/CLK clkbuf_3_6_0_clk_regs/X vddd vssd sg13cmos5l_buf_8
XFILLER_24_504 vddd vssd sg13cmos5l_decap_8
Xoutbuffers\[12\] proj_ena _7029_/Q vddd vssd sg13cmos5l_buf_16
X_4975_ sram_idata[3] _6408_/A _4980_/B vddd vssd sg13cmos5l_and2_1
X_6714_ _6714_/X _6714_/A0 _6765_/A _6717_/S vddd vssd sg13cmos5l_mux2_1
XFILLER_18_2570 vddd vssd sg13cmos5l_decap_8
X_3926_ _3926_/Y _5794_/B _3922_/Y _3925_/Y vddd vssd sg13cmos5l_o21ai_1
X_6645_ _6645_/X _6645_/A0 _6645_/A1 _6645_/S vddd vssd sg13cmos5l_mux2_1
XFILLER_20_765 vddd vssd sg13cmos5l_decap_8
Xclkload7 clkload7/X clkload7/A vddd vssd sg13cmos5l_buf_8
XFILLER_14_2456 vddd vssd sg13cmos5l_decap_8
X_3857_ wire11/A _3854_/Y _3855_/Y _3856_/Y vddd vssd sg13cmos5l_o21ai_1
X_3788_ wire14/A _3785_/Y _3787_/Y _3751_/Y vddd vssd sg13cmos5l_o21ai_1
X_6576_ _6581_/B _6576_/A _6726_/B vddd vssd sg13cmos5l_nand2_1
XFILLER_30_1067 vddd vssd sg13cmos5l_decap_4
X_5527_ _5530_/B _5529_/A _5527_/B vddd vssd sg13cmos5l_nand2_1
X_5458_ _5458_/Y _5471_/C _5457_/Y _5465_/B vddd vssd sg13cmos5l_o21ai_1
Xfanout222 _6969_/A _6923_/A vddd vssd sg13cmos5l_buf_1
X_5389_ _5389_/Y _5389_/A _7161_/Q _5389_/C vddd vssd sg13cmos5l_nor3_1
Xfanout211 _6913_/A _6835_/A vddd vssd sg13cmos5l_buf_1
X_4409_ _4409_/X _4409_/A _4409_/B vddd vssd sg13cmos5l_and2_1
Xfanout200 _6765_/A fanout208/X vddd vssd sg13cmos5l_buf_1
XFILLER_25_2552 vddd vssd sg13cmos5l_decap_8
Xfanout233 _4531_/A _4496_/A vddd vssd sg13cmos5l_buf_1
X_7128_ _7128_/Q _7273_/CLK _7128_/D fanout390/X vddd vssd sg13cmos5l_dfrbpq_1
Xfanout244 _5457_/A hold1374/X vddd vssd sg13cmos5l_buf_1
Xfanout255 _4698_/B _4920_/A vddd vssd sg13cmos5l_buf_1
Xfanout266 _5212_/B hold1446/X vddd vssd sg13cmos5l_buf_1
Xfanout288 _5629_/A hold1410/X vddd vssd sg13cmos5l_buf_1
X_7059_ _7059_/Q _7146_/CLK _7059_/D fanout350/X vddd vssd sg13cmos5l_dfrbpq_1
Xfanout299 _5465_/B hold1431/X vddd vssd sg13cmos5l_buf_1
Xfanout277 _6235_/A hold1422/X vddd vssd sg13cmos5l_buf_1
XFILLER_5_1989 vddd vssd sg13cmos5l_decap_8
XFILLER_28_887 vddd vssd sg13cmos5l_decap_8
XFILLER_19_1644 vddd vssd sg13cmos5l_decap_8
XFILLER_32_2523 vddd vssd sg13cmos5l_decap_8
XFILLER_24_63 vddd vssd sg13cmos5l_decap_8
XFILLER_19_1688 vddd vssd sg13cmos5l_decap_4
XFILLER_19_1699 vddd vssd sg13cmos5l_decap_8
XFILLER_11_776 vddd vssd sg13cmos5l_decap_8
XFILLER_32_1866 vddd vssd sg13cmos5l_decap_8
XFILLER_32_1888 vddd vssd sg13cmos5l_decap_8
XFILLER_13_1254 vddd vssd sg13cmos5l_decap_8
XFILLER_26_1604 vddd vssd sg13cmos5l_decap_4
XFILLER_24_2051 vddd vssd sg13cmos5l_decap_8
XFILLER_6_1709 vddd vssd sg13cmos5l_decap_8
XFILLER_20_1214 vddd vssd sg13cmos5l_decap_4
XFILLER_19_832 vddd vssd sg13cmos5l_decap_4
XFILLER_24_1383 vddd vssd sg13cmos5l_decap_8
XFILLER_18_386 vddd vssd sg13cmos5l_decap_8
Xoutbuffers\[102\] dbus_out[5] _5448_/Y vddd vssd sg13cmos5l_buf_16
X_4760_ _4760_/Y _4512_/A _4757_/Y _4759_/Y vddd vssd sg13cmos5l_o21ai_1
X_3711_ _3711_/Y _4206_/A _6267_/A1 _3710_/Y vddd vssd sg13cmos5l_o21ai_1
X_4691_ _4691_/Y _4698_/A _4691_/B vddd vssd sg13cmos5l_nand2b_1
X_6430_ _6430_/X _6459_/A _6430_/A1 _6430_/S vddd vssd sg13cmos5l_mux2_1
X_3642_ _3655_/A _4916_/A _4900_/B vddd vssd sg13cmos5l_nand2_1
X_6361_ _6361_/Y _6361_/A _6361_/B vddd vssd sg13cmos5l_nand2_1
X_3573_ _5685_/B _7205_/Q vddd vssd sg13cmos5l_inv_1
X_5312_ _5331_/A _7150_/Q _7151_/Q vddd vssd sg13cmos5l_nor2_1
XFILLER_6_780 vddd vssd sg13cmos5l_decap_8
X_6292_ _6292_/Y _6285_/A _6291_/B _6291_/A vddd vssd sg13cmos5l_a21oi_1
X_5243_ _6250_/B _5243_/A _6181_/C vddd vssd sg13cmos5l_nand2_1
XFILLER_29_1272 vddd vssd sg13cmos5l_decap_8
X_5174_ _6147_/A _5262_/A _5174_/B vddd vssd sg13cmos5l_or2_1
XFILLER_9_1366 vddd vssd sg13cmos5l_decap_4
X_4125_ _4125_/X _5806_/B _6529_/A _6522_/A vddd vssd sg13cmos5l_a21o_1
XFILLER_28_106 vddd vssd sg13cmos5l_decap_8
X_4056_ _4056_/Y _5389_/A _4144_/B _4053_/Y _4054_/Y _4055_/X vddd vssd sg13cmos5l_a221oi_1
XFILLER_25_813 vddd vssd sg13cmos5l_decap_8
XFILLER_20_2493 vddd vssd sg13cmos5l_decap_8
XFILLER_0_1820 vddd vssd sg13cmos5l_decap_8
XFILLER_25_868 vddd vssd sg13cmos5l_decap_4
XFILLER_20_1770 vddd vssd sg13cmos5l_decap_8
XFILLER_0_2598 vddd vssd sg13cmos5l_decap_8
XFILLER_0_1875 vddd vssd sg13cmos5l_decap_4
X_4958_ _4958_/Y _4958_/A _4958_/B vddd vssd sg13cmos5l_xnor2_1
X_4889_ _4891_/C _4889_/A _4889_/B vddd vssd sg13cmos5l_and2_1
X_3909_ _3909_/Y _5956_/A _6568_/A _6561_/A vddd vssd sg13cmos5l_a21oi_1
X_6628_ _6628_/Y _6628_/A _6632_/S vddd vssd sg13cmos5l_nor2_1
XFILLER_14_1552 vddd vssd sg13cmos5l_decap_8
XFILLER_10_1416 vddd vssd sg13cmos5l_decap_4
X_6559_ _7232_/D _6559_/A1 _6560_/S _6558_/Y vddd vssd sg13cmos5l_a21oi_1
XFILLER_10_65 vddd vssd sg13cmos5l_decap_8
XFILLER_19_63 vddd vssd sg13cmos5l_decap_8
XFILLER_5_1720 vddd vssd sg13cmos5l_decap_4
XFILLER_21_1534 vddd vssd sg13cmos5l_decap_4
XFILLER_5_2498 vddd vssd sg13cmos5l_decap_8
XFILLER_21_1578 vddd vssd sg13cmos5l_decap_8
XFILLER_16_802 vddd vssd sg13cmos5l_decap_4
XFILLER_27_194 vddd vssd sg13cmos5l_decap_8
XFILLER_30_304 vddd vssd sg13cmos5l_decap_8
XFILLER_11_562 vddd vssd sg13cmos5l_decap_4
XFILLER_32_2397 vddd vssd sg13cmos5l_decap_8
XFILLER_11_595 vddd vssd sg13cmos5l_decap_8
XFILLER_22_1309 vddd vssd sg13cmos5l_decap_8
XFILLER_20_1000 vddd vssd sg13cmos5l_decap_8
X_5930_ _5930_/Y _5930_/A _5930_/B vddd vssd sg13cmos5l_nor2_1
XFILLER_4_1285 vddd vssd sg13cmos5l_decap_4
XFILLER_22_827 vddd vssd sg13cmos5l_decap_8
X_5861_ _5861_/Y _5861_/A _5861_/B _7228_/Q vddd vssd sg13cmos5l_nor3_1
X_5792_ _5792_/Y _5730_/A _5790_/Y _5791_/Y vddd vssd sg13cmos5l_a21oi_1
X_4812_ _4812_/Y _7104_/Q _4812_/B vddd vssd sg13cmos5l_nand2b_1
X_4743_ _4743_/Y _4743_/A _4762_/B vddd vssd sg13cmos5l_nor2_1
XFILLER_30_893 vddd vssd sg13cmos5l_decap_8
XFILLER_15_2584 vddd vssd sg13cmos5l_decap_8
X_4674_ _4674_/Y _4674_/A _4674_/B _4674_/C vddd vssd sg13cmos5l_nand3_1
X_6413_ _6413_/X _6765_/A _6413_/A1 _6416_/S vddd vssd sg13cmos5l_mux2_1
X_3625_ _3625_/Y _3625_/A vddd vssd sg13cmos5l_inv_1
X_7393_ _7393_/Q _7393_/CLK _7393_/D _6818_/Y vddd vssd sg13cmos5l_dfrbpq_1
X_6344_ _6344_/Y _6344_/A _6344_/B vddd vssd sg13cmos5l_nand2_1
XFILLER_11_1769 vddd vssd sg13cmos5l_decap_4
X_3556_ _5459_/B _3556_/A vddd vssd sg13cmos5l_inv_1
X_6275_ _6275_/X _6136_/A _5260_/C _6274_/Y vddd vssd sg13cmos5l_a21o_1
X_3487_ _3487_/Y _4775_/B vddd vssd sg13cmos5l_inv_1
X_5226_ _5227_/A _5226_/A _5267_/B vddd vssd sg13cmos5l_nor2_1
XFILLER_22_2555 vddd vssd sg13cmos5l_decap_8
X_5157_ _5157_/Y _5157_/A _5180_/B vddd vssd sg13cmos5l_nand2_1
X_5088_ _5100_/A _7276_/Q _7277_/Q _5265_/A vddd vssd sg13cmos5l_nor3_1
X_4108_ _4108_/Y _6590_/A _4108_/B vddd vssd sg13cmos5l_nand2_1
X_4039_ _4040_/C _7212_/Q _6514_/A _3929_/Y vddd vssd sg13cmos5l_a21oi_1
XFILLER_24_175 vddd vssd sg13cmos5l_decap_8
XFILLER_21_860 vddd vssd sg13cmos5l_decap_8
XFILLER_14_2083 vddd vssd sg13cmos5l_decap_8
XFILLER_21_42 vddd vssd sg13cmos5l_decap_8
XFILLER_10_1202 vddd vssd sg13cmos5l_decap_8
XFILLER_27_2422 vddd vssd sg13cmos5l_decap_8
XFILLER_27_2499 vddd vssd sg13cmos5l_decap_8
XFILLER_21_2021 vddd vssd sg13cmos5l_decap_4
XFILLER_21_2043 vddd vssd sg13cmos5l_decap_8
XFILLER_5_1561 vddd vssd sg13cmos5l_decap_4
XFILLER_29_971 vddd vssd sg13cmos5l_decap_8
Xtiedowns\[11\] _5871_/A vddd vssd sg13cmos5l_antennanp
XFILLER_5_1583 vddd vssd sg13cmos5l_decap_8
XFILLER_28_492 vddd vssd sg13cmos5l_decap_8
XFILLER_15_197 vddd vssd sg13cmos5l_decap_4
XFILLER_30_156 vddd vssd sg13cmos5l_decap_8
XFILLER_15_1135 vddd vssd sg13cmos5l_decap_4
XFILLER_7_44 vddd vssd sg13cmos5l_decap_8
XFILLER_32_1471 vddd vssd sg13cmos5l_decap_8
XFILLER_28_2219 vddd vssd sg13cmos5l_decap_8
X_4390_ _4394_/B _4390_/A _4390_/B _4390_/C _4390_/D vddd vssd sg13cmos5l_nor4_1
XFILLER_10_2470 vddd vssd sg13cmos5l_decap_8
XFILLER_6_2015 vddd vssd sg13cmos5l_decap_8
X_6060_ _6060_/Y _6239_/A _6060_/B _6060_/C vddd vssd sg13cmos5l_nor3_1
Xhold1008 _6604_/A _7258_/Q vddd vssd sg13cmos5l_dlygate4sd3_1
XFILLER_6_1347 vddd vssd sg13cmos5l_decap_8
X_5011_ _5012_/D _5011_/A _5011_/B _5011_/C vddd vssd sg13cmos5l_nand3_1
Xhold1019 _6533_/A1 _5806_/B vddd vssd sg13cmos5l_dlygate4sd3_1
X_6962_ _6962_/Y _6962_/A _6962_/B_N vddd vssd sg13cmos5l_nor2b_1
X_5913_ _5913_/Y _7098_/Q _5930_/A _5912_/Y vddd vssd sg13cmos5l_o21ai_1
X_6893_ _6893_/Y _6893_/A _6893_/B_N vddd vssd sg13cmos5l_nor2b_1
XFILLER_21_112 vddd vssd sg13cmos5l_decap_4
X_5844_ _5844_/Y _5971_/A1 _5843_/C _5843_/Y vddd vssd sg13cmos5l_o21ai_1
XFILLER_17_1978 vddd vssd sg13cmos5l_decap_8
X_5775_ _5790_/C _7214_/Q _7215_/Q vddd vssd sg13cmos5l_nand2_1
X_4726_ _4726_/X _4691_/B _4716_/Y _4736_/B1 vddd vssd sg13cmos5l_a21o_1
XFILLER_11_2234 vddd vssd sg13cmos5l_decap_4
X_4657_ _4657_/Y _4645_/Y _4654_/Y _4746_/B1 vddd vssd sg13cmos5l_o21ai_1
X_3608_ _4479_/B _3608_/A vddd vssd sg13cmos5l_inv_1
Xhold820 _7103_/D _6311_/Y vddd vssd sg13cmos5l_dlygate4sd3_1
X_7376_ _7376_/Q _7380_/CLK _7376_/D _6890_/Y vddd vssd sg13cmos5l_dfrbpq_1
Xhold853 hold853/X _7192_/Q vddd vssd sg13cmos5l_dlygate4sd3_1
X_4588_ _4588_/Y _4588_/A _4588_/B vddd vssd sg13cmos5l_nor2_1
Xhold842 _5931_/C _5930_/Y vddd vssd sg13cmos5l_dlygate4sd3_1
Xhold864 _7099_/D _6306_/X vddd vssd sg13cmos5l_dlygate4sd3_1
X_6327_ _6327_/Y _6344_/A _6327_/B vddd vssd sg13cmos5l_nand2_1
Xhold831 hold831/X _3596_/Y vddd vssd sg13cmos5l_dlygate4sd3_1
Xhold875 _7161_/D _6423_/X vddd vssd sg13cmos5l_dlygate4sd3_1
Xhold886 _7102_/D _6309_/X vddd vssd sg13cmos5l_dlygate4sd3_1
Xhold897 _7106_/D _6318_/Y vddd vssd sg13cmos5l_dlygate4sd3_1
X_3539_ _3539_/Y _3539_/A vddd vssd sg13cmos5l_inv_1
X_6258_ _6258_/Y _6254_/Y _6255_/Y _6257_/X vddd vssd sg13cmos5l_o21ai_1
X_6189_ _6189_/Y _6240_/A1 _6188_/D _5224_/B _5224_/A _6188_/Y vddd vssd sg13cmos5l_a221oi_1
X_5209_ _5242_/B _5208_/A _5209_/B vddd vssd sg13cmos5l_nand2b_1
XFILLER_6_2571 vddd vssd sg13cmos5l_decap_8
XFILLER_29_245 vddd vssd sg13cmos5l_decap_8
XFILLER_22_1651 vddd vssd sg13cmos5l_decap_8
XFILLER_16_42 vddd vssd sg13cmos5l_decap_8
XFILLER_31_1909 vddd vssd sg13cmos5l_decap_8
XFILLER_16_2178 vddd vssd sg13cmos5l_decap_4
XFILLER_8_105 vddd vssd sg13cmos5l_decap_8
XFILLER_32_63 vddd vssd sg13cmos5l_decap_8
XFILLER_29_2506 vddd vssd sg13cmos5l_decap_8
XFILLER_5_845 vddd vssd sg13cmos5l_decap_8
XFILLER_29_1816 vddd vssd sg13cmos5l_decap_8
Xtiedowns\[59\] mask_rev_in[15] vddd vssd sg13cmos5l_antennanp
XFILLER_4_377 vddd vssd sg13cmos5l_decap_8
XFILLER_23_2149 vddd vssd sg13cmos5l_decap_4
XFILLER_5_2070 vddd vssd sg13cmos5l_decap_8
XFILLER_5_2092 vddd vssd sg13cmos5l_decap_4
XFILLER_1_1255 vddd vssd sg13cmos5l_decap_8
XFILLER_32_955 vddd vssd sg13cmos5l_decap_8
X_3890_ _3890_/Y _7257_/Q _4019_/B _3894_/B vddd vssd sg13cmos5l_a21oi_1
X_5560_ _5560_/Y _7184_/Q _7185_/Q _5560_/C vddd vssd sg13cmos5l_nor3_1
XFILLER_12_2521 vddd vssd sg13cmos5l_decap_8
X_4511_ _4512_/B _5713_/A _4531_/A _4511_/C vddd vssd sg13cmos5l_nor3_1
X_5491_ _5493_/B _5491_/A _5491_/B vddd vssd sg13cmos5l_nand2_1
XFILLER_8_650 vddd vssd sg13cmos5l_decap_8
X_4442_ _4739_/B _4778_/A _4756_/B vddd vssd sg13cmos5l_and2_1
X_7230_ _7230_/Q _7296_/CLK _7230_/D fanout368/X vddd vssd sg13cmos5l_dfrbpq_1
XFILLER_12_2598 vddd vssd sg13cmos5l_decap_8
XFILLER_28_2027 vddd vssd sg13cmos5l_decap_8
X_7161_ _7161_/Q _7200_/CLK _7161_/D fanout360/X vddd vssd sg13cmos5l_dfrbpq_1
X_4373_ _4393_/A _5542_/A _7129_/Q vddd vssd sg13cmos5l_xor2_1
X_6112_ _6112_/Y _3822_/Y _5149_/D _6111_/Y vddd vssd sg13cmos5l_a21oi_1
X_7092_ _7092_/Q _7123_/CLK _7092_/D _6870_/B_N vddd vssd sg13cmos5l_dfrbpq_1
X_6043_ _6043_/Y _5067_/D _6041_/X _6042_/Y vddd vssd sg13cmos5l_o21ai_1
Xoutbuffers\[42\] bandgap_trim[3] _6283_/Y vddd vssd sg13cmos5l_buf_16
X_6945_ _6945_/Y _6965_/A _6945_/B_N vddd vssd sg13cmos5l_nor2b_1
XFILLER_23_944 vddd vssd sg13cmos5l_decap_4
XFILLER_17_2443 vddd vssd sg13cmos5l_decap_8
X_6876_ _6876_/Y _6893_/A _6915_/B_N vddd vssd sg13cmos5l_nor2b_1
XFILLER_23_999 vddd vssd sg13cmos5l_decap_8
X_5827_ _5848_/B _7223_/Q _7222_/Q vddd vssd sg13cmos5l_nor2b_1
X_5758_ _5759_/C _5758_/A _5758_/B vddd vssd sg13cmos5l_nand2_1
X_4709_ _4709_/Y _4685_/A _4708_/Y _4709_/B1 vddd vssd sg13cmos5l_o21ai_1
X_5689_ _5689_/Y _5687_/Y _5688_/Y _5693_/C vddd vssd sg13cmos5l_o21ai_1
XFILLER_11_2064 vddd vssd sg13cmos5l_decap_8
Xhold650 _7344_/D _4570_/Y vddd vssd sg13cmos5l_dlygate4sd3_1
Xhold672 hold672/X _6347_/Y vddd vssd sg13cmos5l_dlygate4sd3_1
X_7359_ _7359_/Q _7404_/CLK _7359_/D _6873_/Y vddd vssd sg13cmos5l_dfrbpq_1
Xhold661 _7357_/D _4399_/Y vddd vssd sg13cmos5l_dlygate4sd3_1
XFILLER_28_2594 vddd vssd sg13cmos5l_decap_8
XFILLER_24_2425 vddd vssd sg13cmos5l_decap_8
Xhold683 _5947_/B _6980_/Q vddd vssd sg13cmos5l_dlygate4sd3_1
Xhold694 _7098_/D _6305_/Y vddd vssd sg13cmos5l_dlygate4sd3_1
Xhold1361 _6484_/A _5633_/B vddd vssd sg13cmos5l_dlygate4sd3_1
Xhold1350 _3559_/A _7177_/Q vddd vssd sg13cmos5l_dlygate4sd3_1
Xhold1372 _6778_/A1 _3628_/Y vddd vssd sg13cmos5l_dlygate4sd3_1
Xhold1394 _4663_/A _4661_/Y vddd vssd sg13cmos5l_dlygate4sd3_1
XFILLER_27_63 vddd vssd sg13cmos5l_decap_8
XFILLER_22_2193 vddd vssd sg13cmos5l_decap_8
Xhold1383 hold1383/X _7224_/Q vddd vssd sg13cmos5l_dlygate4sd3_1
XFILLER_27_96 vddd vssd sg13cmos5l_decap_8
XFILLER_22_1492 vddd vssd sg13cmos5l_decap_8
XFILLER_18_1528 vddd vssd sg13cmos5l_decap_8
XFILLER_31_2429 vddd vssd sg13cmos5l_decap_8
XFILLER_16_1230 vddd vssd sg13cmos5l_decap_8
XFILLER_12_1127 vddd vssd sg13cmos5l_decap_8
XFILLER_4_23 vddd vssd sg13cmos5l_decap_8
XFILLER_5_686 vddd vssd sg13cmos5l_decap_8
XFILLER_4_67 vddd vssd sg13cmos5l_decap_8
XFILLER_7_2165 vddd vssd sg13cmos5l_decap_8
XFILLER_23_1256 vddd vssd sg13cmos5l_decap_8
XFILLER_7_1497 vddd vssd sg13cmos5l_decap_4
Xclkbuf_4_11__f_clk_regs _7357_/CLK clkbuf_3_5_0_clk_regs/X vddd vssd sg13cmos5l_buf_8
X_6730_ _6730_/X _6650_/A _6730_/A1 _6735_/S vddd vssd sg13cmos5l_mux2_1
X_4991_ _4991_/Y _7301_/Q _6121_/B vddd vssd sg13cmos5l_nor2_1
XFILLER_32_752 vddd vssd sg13cmos5l_decap_8
X_3942_ _3942_/Y _3937_/Y _3939_/X _3941_/Y vddd vssd sg13cmos5l_o21ai_1
XFILLER_17_1005 vddd vssd sg13cmos5l_decap_4
XFILLER_20_925 vddd vssd sg13cmos5l_decap_8
X_3873_ _6603_/A _3889_/A wire98/X vddd vssd sg13cmos5l_nand2_1
X_6661_ _6661_/Y _6661_/A _6664_/S vddd vssd sg13cmos5l_nand2_1
X_5612_ _5612_/X _5789_/A _5612_/B vddd vssd sg13cmos5l_and2_1
XFILLER_20_958 vddd vssd sg13cmos5l_decap_8
X_6592_ _7250_/D _6635_/A1 _6596_/S hold663/X vddd vssd sg13cmos5l_a21oi_1
X_5543_ _5543_/Y _5556_/C _5542_/Y _5557_/A vddd vssd sg13cmos5l_o21ai_1
XFILLER_12_2351 vddd vssd sg13cmos5l_decap_8
X_5474_ _5474_/Y _5469_/Y _5470_/X _5473_/Y vddd vssd sg13cmos5l_o21ai_1
X_4425_ _4461_/A _4458_/B _4501_/B _4812_/B vddd vssd sg13cmos5l_a21oi_1
X_7213_ _7213_/Q _7228_/CLK _7213_/D fanout364/X vddd vssd sg13cmos5l_dfrbpq_1
XFILLER_28_1112 vddd vssd sg13cmos5l_decap_8
X_7144_ _7144_/Q _7363_/CLK _7144_/D fanout350/X vddd vssd sg13cmos5l_dfrbpq_1
X_4356_ _4356_/Y _3671_/Y _4355_/C _4355_/Y vddd vssd sg13cmos5l_o21ai_1
Xfanout404 fanout404/X fanout408/X vddd vssd sg13cmos5l_buf_1
XFILLER_24_1009 vddd vssd sg13cmos5l_decap_8
Xfanout448 _4972_/A _6754_/A vddd vssd sg13cmos5l_buf_1
Xfanout426 _5898_/A1 _5967_/A vddd vssd sg13cmos5l_buf_1
Xfanout437 _5875_/A _5976_/A vddd vssd sg13cmos5l_buf_1
XFILLER_8_1217 vddd vssd sg13cmos5l_decap_8
Xfanout415 _6211_/A _5593_/A vddd vssd sg13cmos5l_buf_1
X_7075_ _7075_/Q _7077_/CLK _7075_/D fanout353/X vddd vssd sg13cmos5l_dfrbpq_1
X_4287_ _4288_/B _4293_/C _4287_/B _4290_/C vddd vssd sg13cmos5l_nand3_1
X_6026_ _6026_/Y _6023_/Y _6024_/X _6025_/Y vddd vssd sg13cmos5l_o21ai_1
XFILLER_27_524 vddd vssd sg13cmos5l_decap_8
XFILLER_3_1873 vddd vssd sg13cmos5l_decap_8
XFILLER_19_2527 vddd vssd sg13cmos5l_decap_8
X_6928_ _6928_/Y _6965_/A _6945_/B_N vddd vssd sg13cmos5l_nor2b_1
X_6859_ _6859_/Y _6966_/A _6964_/B_N vddd vssd sg13cmos5l_nor2b_1
Xfanout33 _6735_/S _6726_/Y vddd vssd sg13cmos5l_buf_1
Xfanout55 _6308_/S _6301_/Y vddd vssd sg13cmos5l_buf_1
Xfanout44 _4960_/B _4913_/Y vddd vssd sg13cmos5l_buf_1
Xfanout66 _3961_/B _3928_/X vddd vssd sg13cmos5l_buf_1
Xfanout99 _6762_/B _3846_/A vddd vssd sg13cmos5l_buf_1
Xfanout77 _4263_/B _3749_/Y vddd vssd sg13cmos5l_buf_1
XFILLER_13_21 vddd vssd sg13cmos5l_decap_8
XFILLER_17_1583 vddd vssd sg13cmos5l_decap_8
XFILLER_6_417 vddd vssd sg13cmos5l_decap_4
XFILLER_30_2462 vddd vssd sg13cmos5l_decap_8
XFILLER_13_1458 vddd vssd sg13cmos5l_decap_4
X_3630__466 _7388_/CLK _7403_/CLK vddd vssd sg13cmos5l_inv_1
Xhold480 _4955_/A hold892/X vddd vssd sg13cmos5l_dlygate4sd3_1
XFILLER_1_133 vddd vssd sg13cmos5l_decap_8
XFILLER_28_2391 vddd vssd sg13cmos5l_decap_8
Xhold491 sram_addr[1] _5980_/X vddd vssd sg13cmos5l_dlygate4sd3_1
XFILLER_8_2452 vddd vssd sg13cmos5l_decap_8
XFILLER_24_1521 vddd vssd sg13cmos5l_decap_8
XFILLER_8_1751 vddd vssd sg13cmos5l_decap_8
XFILLER_24_1598 vddd vssd sg13cmos5l_decap_8
Xhold1180 _7299_/D _6669_/Y vddd vssd sg13cmos5l_dlygate4sd3_1
Xhold1191 _6582_/A1 _5204_/B vddd vssd sg13cmos5l_dlygate4sd3_1
XFILLER_2_1372 vddd vssd sg13cmos5l_decap_8
XFILLER_13_251 vddd vssd sg13cmos5l_decap_4
XFILLER_14_763 vddd vssd sg13cmos5l_decap_8
XFILLER_9_233 vddd vssd sg13cmos5l_decap_8
XFILLER_14_785 vddd vssd sg13cmos5l_decap_8
XFILLER_31_1525 vddd vssd sg13cmos5l_decap_4
XFILLER_16_1060 vddd vssd sg13cmos5l_decap_8
XFILLER_9_277 vddd vssd sg13cmos5l_decap_8
XFILLER_6_995 vddd vssd sg13cmos5l_decap_8
X_4210_ _4210_/Y _7238_/Q _6568_/A _6561_/A vddd vssd sg13cmos5l_a21oi_1
X_5190_ _5214_/A _7282_/Q _7283_/Q _5256_/B vddd vssd sg13cmos5l_nor3_1
XFILLER_9_1559 vddd vssd sg13cmos5l_decap_8
X_4141_ _4141_/Y _7171_/Q _6438_/A _6431_/A vddd vssd sg13cmos5l_a21oi_1
XFILLER_23_1020 vddd vssd sg13cmos5l_decap_8
X_4072_ _4072_/Y wire8/X _4071_/Y _3717_/Y vddd vssd sg13cmos5l_o21ai_1
XFILLER_7_1272 vddd vssd sg13cmos5l_decap_8
XFILLER_20_1941 vddd vssd sg13cmos5l_decap_8
X_4974_ sram_idata[2] _6722_/A _4980_/B vddd vssd sg13cmos5l_and2_1
X_6713_ _7040_/D _6713_/A1 _6717_/S _6713_/B1 vddd vssd sg13cmos5l_a21oi_1
X_3925_ _3925_/Y _3925_/A _3925_/B vddd vssd sg13cmos5l_nand2_1
X_6644_ _6644_/X _6644_/A0 _6650_/A _6645_/S vddd vssd sg13cmos5l_mux2_1
XFILLER_14_2435 vddd vssd sg13cmos5l_decap_8
XFILLER_20_744 vddd vssd sg13cmos5l_decap_8
Xclkload8 clkload8/X clkload8/A vddd vssd sg13cmos5l_buf_8
XFILLER_14_1723 vddd vssd sg13cmos5l_decap_8
X_3856_ _3856_/Y _3683_/A wire96/X _3748_/Y mask_rev_in[28] vddd vssd sg13cmos5l_a22oi_1
X_3787_ _3787_/Y mask_rev_in[30] _4263_/B _3786_/Y vddd vssd sg13cmos5l_o21ai_1
X_6575_ _7241_/D _6575_/A1 _6574_/B _6574_/Y vddd vssd sg13cmos5l_a21oi_1
XFILLER_3_409 vddd vssd sg13cmos5l_decap_8
X_5526_ _5528_/B _5526_/A _7178_/Q _7179_/Q _5529_/A vddd vssd sg13cmos5l_nand4_1
X_5457_ _5457_/Y _5457_/A _5472_/B vddd vssd sg13cmos5l_nor2b_1
X_4408_ _4409_/B _4419_/A _4408_/B vddd vssd sg13cmos5l_nor2_1
XFILLER_25_2531 vddd vssd sg13cmos5l_decap_8
X_5388_ _5388_/Y _5388_/A _5388_/B _5388_/C vddd vssd sg13cmos5l_nor3_1
Xfanout223 _6923_/A _6870_/A vddd vssd sg13cmos5l_buf_1
XFILLER_5_2603 vddd vssd sg13cmos5l_decap_4
Xfanout201 _6464_/A _6690_/A vddd vssd sg13cmos5l_buf_1
Xfanout212 _6835_/A _6914_/A vddd vssd sg13cmos5l_buf_1
Xfanout234 _4496_/A _4385_/A vddd vssd sg13cmos5l_buf_1
Xfanout245 _4778_/A _4782_/A vddd vssd sg13cmos5l_buf_1
Xfanout256 _4920_/A hold1291/X vddd vssd sg13cmos5l_buf_1
XFILLER_8_1036 vddd vssd sg13cmos5l_decap_8
X_7127_ _7127_/Q _7268_/CLK _7127_/D fanout387/X vddd vssd sg13cmos5l_dfrbpq_1
X_4339_ _4339_/Y _4342_/A _4339_/B _4339_/C vddd vssd sg13cmos5l_nand3_1
Xfanout267 _5212_/A hold1420/X vddd vssd sg13cmos5l_buf_1
Xfanout289 _5633_/B hold1360/X vddd vssd sg13cmos5l_buf_1
X_7058_ _7058_/Q _7146_/CLK _7058_/D fanout350/X vddd vssd sg13cmos5l_dfrbpq_1
Xfanout278 _5901_/D _7233_/Q vddd vssd sg13cmos5l_buf_1
X_6903__468 _7390_/CLK _7164_/CLK vddd vssd sg13cmos5l_inv_1
X_6009_ _6009_/Y _6009_/A _6057_/B vddd vssd sg13cmos5l_nor2b_1
XFILLER_21_1749 vddd vssd sg13cmos5l_decap_8
XFILLER_27_365 vddd vssd sg13cmos5l_decap_8
XFILLER_19_2335 vddd vssd sg13cmos5l_decap_8
XFILLER_32_2502 vddd vssd sg13cmos5l_decap_8
XFILLER_24_42 vddd vssd sg13cmos5l_decap_8
XFILLER_23_560 vddd vssd sg13cmos5l_decap_8
XFILLER_11_711 vddd vssd sg13cmos5l_decap_8
XFILLER_32_2579 vddd vssd sg13cmos5l_decap_8
XFILLER_32_1845 vddd vssd sg13cmos5l_decap_8
XFILLER_7_759 vddd vssd sg13cmos5l_decap_8
XFILLER_10_287 vddd vssd sg13cmos5l_decap_4
XFILLER_3_921 vddd vssd sg13cmos5l_decap_8
XFILLER_6_0 vddd vssd sg13cmos5l_decap_8
Xtiedowns\[41\] dbus_in_right[9] vddd vssd sg13cmos5l_antennanp
XFILLER_3_998 vddd vssd sg13cmos5l_decap_4
XFILLER_4_2146 vddd vssd sg13cmos5l_decap_4
XFILLER_1_35 vddd vssd sg13cmos5l_decap_8
XFILLER_4_2179 vddd vssd sg13cmos5l_decap_8
XFILLER_8_1592 vddd vssd sg13cmos5l_decap_8
XFILLER_8_1581 vddd vssd sg13cmos5l_decap_4
X_3710_ _3710_/Y _7039_/Q _6696_/A _4189_/B1 _7297_/Q vddd vssd sg13cmos5l_a22oi_1
XFILLER_18_1166 vddd vssd sg13cmos5l_decap_8
X_4690_ _4690_/Y _4169_/A _4671_/Y _4758_/B1 vddd vssd sg13cmos5l_a21oi_1
X_3641_ _3641_/Y _5985_/S _4901_/B vddd vssd sg13cmos5l_nor2_1
X_3572_ _5693_/C _3572_/A vddd vssd sg13cmos5l_inv_1
X_6360_ _7126_/D _6342_/A _6359_/B hold644/X vddd vssd sg13cmos5l_o21ai_1
X_5311_ _5326_/D _7151_/Q _7150_/Q vddd vssd sg13cmos5l_nor2b_1
X_6291_ _6291_/Y _6291_/A _6291_/B vddd vssd sg13cmos5l_nor2_1
XFILLER_29_1240 vddd vssd sg13cmos5l_decap_8
X_5242_ _5251_/B _5242_/A _5242_/B vddd vssd sg13cmos5l_nor2_1
XFILLER_9_1301 vddd vssd sg13cmos5l_decap_8
XFILLER_25_1115 vddd vssd sg13cmos5l_decap_8
X_5173_ _5183_/A _5173_/A _5173_/B vddd vssd sg13cmos5l_or2_1
XFILLER_9_1356 vddd vssd sg13cmos5l_decap_4
X_4124_ _4124_/Y _7223_/Q _6538_/A _4122_/Y _4123_/Y _6529_/A vddd vssd sg13cmos5l_a221oi_1
X_4055_ _4055_/X _7156_/Q _6410_/A _6402_/A vddd vssd sg13cmos5l_a21o_1
XFILLER_20_2472 vddd vssd sg13cmos5l_decap_8
XFILLER_0_2566 vddd vssd sg13cmos5l_decap_8
XFILLER_25_847 vddd vssd sg13cmos5l_decap_8
XFILLER_16_2519 vddd vssd sg13cmos5l_decap_8
XFILLER_16_1829 vddd vssd sg13cmos5l_decap_8
X_4957_ _4957_/Y _4958_/A _4960_/B vddd vssd sg13cmos5l_nand2_1
X_4888_ _4889_/B _4934_/A _7145_/Q _7144_/Q _4937_/A vddd vssd sg13cmos5l_a22oi_1
X_3908_ _3908_/Y _3908_/A _3925_/A vddd vssd sg13cmos5l_nand2_1
X_6627_ _6632_/S wire88/X _6779_/B vddd vssd sg13cmos5l_and2_1
X_3839_ _3839_/Y _7044_/Q _6711_/A _4183_/B1 vddd vssd sg13cmos5l_o21ai_1
XFILLER_10_2118 vddd vssd sg13cmos5l_decap_8
XFILLER_31_2590 vddd vssd sg13cmos5l_decap_8
X_6558_ _6558_/Y _6558_/A _6560_/S vddd vssd sg13cmos5l_nor2_1
XFILLER_10_1439 vddd vssd sg13cmos5l_decap_8
X_6489_ _7197_/D _6552_/A _6489_/A1 _6489_/S vddd vssd sg13cmos5l_mux2_1
XFILLER_10_44 vddd vssd sg13cmos5l_decap_8
X_5509_ _5529_/B _7179_/Q _7178_/Q vddd vssd sg13cmos5l_nor2b_1
XFILLER_0_924 vddd vssd sg13cmos5l_decap_8
XFILLER_19_42 vddd vssd sg13cmos5l_decap_8
XFILLER_5_2477 vddd vssd sg13cmos5l_decap_8
XFILLER_21_1557 vddd vssd sg13cmos5l_decap_8
XFILLER_27_173 vddd vssd sg13cmos5l_decap_8
XFILLER_19_2176 vddd vssd sg13cmos5l_decap_8
XFILLER_19_1431 vddd vssd sg13cmos5l_decap_8
XFILLER_15_379 vddd vssd sg13cmos5l_decap_8
XFILLER_15_1328 vddd vssd sg13cmos5l_decap_8
XFILLER_32_2376 vddd vssd sg13cmos5l_decap_8
XFILLER_32_1653 vddd vssd sg13cmos5l_decap_8
XFILLER_7_556 vddd vssd sg13cmos5l_decap_4
XFILLER_7_578 vddd vssd sg13cmos5l_decap_8
XFILLER_26_2136 vddd vssd sg13cmos5l_decap_8
XFILLER_32_7 vddd vssd sg13cmos5l_decap_8
XFILLER_6_1518 vddd vssd sg13cmos5l_decap_4
Xclkbuf_leaf_11_SCK_regs _7190_/CLK clkload5/A vddd vssd sg13cmos5l_buf_8
XFILLER_19_630 vddd vssd sg13cmos5l_decap_8
X_5860_ _5860_/Y _3591_/Y _7319_/Q _5859_/Y vddd vssd sg13cmos5l_o21ai_1
XFILLER_22_806 vddd vssd sg13cmos5l_decap_8
X_4811_ _4811_/Y _4547_/A _4809_/Y hold674/X vddd vssd sg13cmos5l_o21ai_1
X_5791_ _5791_/Y _5794_/A _5791_/B _5791_/C vddd vssd sg13cmos5l_nor3_1
X_4742_ _4742_/Y _4758_/B1 _4738_/Y _4741_/Y vddd vssd sg13cmos5l_o21ai_1
XFILLER_15_2563 vddd vssd sg13cmos5l_decap_8
X_4673_ _4673_/Y _5513_/A _4673_/B vddd vssd sg13cmos5l_xnor2_1
X_3624_ _3624_/Y _3624_/A vddd vssd sg13cmos5l_inv_1
X_6412_ _7154_/D _6748_/A1 _6416_/S hold941/X vddd vssd sg13cmos5l_o21ai_1
XFILLER_11_2449 vddd vssd sg13cmos5l_decap_8
X_7392_ _7392_/Q _7392_/CLK _7392_/D _6819_/Y vddd vssd sg13cmos5l_dfrbpq_1
XFILLER_11_1737 vddd vssd sg13cmos5l_decap_8
X_6343_ _7118_/D _6343_/A1 _6344_/B _6342_/Y vddd vssd sg13cmos5l_o21ai_1
X_3555_ _5429_/B _3555_/A vddd vssd sg13cmos5l_inv_1
Xoutbuffers\[72\] idac1_value[4] _7044_/Q vddd vssd sg13cmos5l_buf_16
X_6274_ _6274_/Y _6144_/A _6273_/A _6272_/Y _6273_/Y _5260_/C vddd vssd sg13cmos5l_a221oi_1
X_3486_ _3486_/Y _4765_/B vddd vssd sg13cmos5l_inv_1
X_5225_ _5233_/C _5225_/A _5258_/B vddd vssd sg13cmos5l_nor2_1
XFILLER_22_2534 vddd vssd sg13cmos5l_decap_8
XFILLER_5_1039 vddd vssd sg13cmos5l_decap_8
X_5156_ _5159_/C _5242_/A _5173_/B vddd vssd sg13cmos5l_nor2_1
X_5087_ _5265_/A _7274_/Q _7275_/Q vddd vssd sg13cmos5l_nand2_1
X_4107_ _4108_/B _7259_/Q _4106_/A _4019_/B _7255_/Q vddd vssd sg13cmos5l_a22oi_1
X_4038_ _4040_/B _7216_/Q _6522_/A vddd vssd sg13cmos5l_nand2_1
XFILLER_24_154 vddd vssd sg13cmos5l_decap_8
X_5989_ _5989_/X _5988_/A _5989_/A2 _5988_/Y vddd vssd sg13cmos5l_a21o_1
XFILLER_13_839 vddd vssd sg13cmos5l_decap_8
XANTENNA_50 _6344_/A vddd vssd sg13cmos5l_antennanp
XFILLER_21_21 vddd vssd sg13cmos5l_decap_8
XFILLER_27_2401 vddd vssd sg13cmos5l_decap_8
XFILLER_21_98 vddd vssd sg13cmos5l_decap_8
XFILLER_10_1247 vddd vssd sg13cmos5l_decap_8
XFILLER_27_2478 vddd vssd sg13cmos5l_decap_8
X_6909__474 _7396_/CLK _7375_/CLK vddd vssd sg13cmos5l_inv_1
XFILLER_0_765 vddd vssd sg13cmos5l_decap_8
XFILLER_0_787 vddd vssd sg13cmos5l_decap_4
XFILLER_21_2088 vddd vssd sg13cmos5l_decap_8
XFILLER_16_666 vddd vssd sg13cmos5l_decap_8
XFILLER_30_135 vddd vssd sg13cmos5l_decap_8
XFILLER_15_1114 vddd vssd sg13cmos5l_decap_8
XFILLER_8_832 vddd vssd sg13cmos5l_decap_4
XFILLER_32_1450 vddd vssd sg13cmos5l_decap_8
XFILLER_7_23 vddd vssd sg13cmos5l_decap_8
XFILLER_8_854 vddd vssd sg13cmos5l_decap_8
XFILLER_10_1770 vddd vssd sg13cmos5l_decap_8
XFILLER_28_1519 vddd vssd sg13cmos5l_decap_8
X_5010_ _5011_/C _5010_/A _5010_/B vddd vssd sg13cmos5l_nor2_1
Xhold1009 _6605_/B1 _6604_/Y vddd vssd sg13cmos5l_dlygate4sd3_1
XFILLER_6_1326 vddd vssd sg13cmos5l_decap_8
X_6961_ _6961_/Y _6961_/A _6962_/B_N vddd vssd sg13cmos5l_nor2b_1
X_5912_ _5912_/Y _5909_/Y _5910_/Y _5911_/Y vddd vssd sg13cmos5l_o21ai_1
X_6892_ _6892_/Y _6893_/A _6893_/B_N vddd vssd sg13cmos5l_nor2b_1
X_5843_ _5843_/Y _5843_/A _5843_/B _5843_/C vddd vssd sg13cmos5l_nand3_1
XFILLER_22_636 vddd vssd sg13cmos5l_decap_4
XFILLER_21_135 vddd vssd sg13cmos5l_decap_8
X_5774_ _5791_/C _7214_/Q _7215_/Q vddd vssd sg13cmos5l_nand2b_1
X_4725_ _4725_/Y _4724_/Y _4725_/B vddd vssd sg13cmos5l_nand2b_1
XFILLER_11_2224 vddd vssd sg13cmos5l_decap_4
X_4656_ _4656_/Y _4656_/A _4656_/B vddd vssd sg13cmos5l_nor2_1
X_3607_ _3607_/Y _3607_/A vddd vssd sg13cmos5l_inv_1
X_4587_ _4588_/B _4575_/Y _4584_/Y _4746_/B1 vddd vssd sg13cmos5l_o21ai_1
Xhold810 hold810/X _4479_/B vddd vssd sg13cmos5l_dlygate4sd3_1
X_7375_ _7375_/Q _7375_/CLK _7375_/D _6889_/Y vddd vssd sg13cmos5l_dfrbpq_1
Xhold821 hold821/X _7093_/Q vddd vssd sg13cmos5l_dlygate4sd3_1
XFILLER_11_1545 vddd vssd sg13cmos5l_decap_8
Xhold854 _7192_/D _6480_/X vddd vssd sg13cmos5l_dlygate4sd3_1
X_3538_ _3538_/Y _5308_/D vddd vssd sg13cmos5l_inv_1
Xhold843 _6973_/D _5931_/Y vddd vssd sg13cmos5l_dlygate4sd3_1
Xhold832 _7107_/D _6320_/Y vddd vssd sg13cmos5l_dlygate4sd3_1
X_6326_ _6326_/Y _6326_/A1 _6327_/B _6325_/Y vddd vssd sg13cmos5l_o21ai_1
XFILLER_11_1589 vddd vssd sg13cmos5l_decap_8
XFILLER_27_1018 vddd vssd sg13cmos5l_decap_8
Xhold876 hold876/X _7100_/Q vddd vssd sg13cmos5l_dlygate4sd3_1
Xhold898 _6539_/A _7222_/Q vddd vssd sg13cmos5l_dlygate4sd3_1
Xhold865 hold865/X _7404_/Q vddd vssd sg13cmos5l_dlygate4sd3_1
Xhold887 _3531_/A _7094_/Q vddd vssd sg13cmos5l_dlygate4sd3_1
X_3469_ _3469_/Y _3469_/A vddd vssd sg13cmos5l_inv_1
X_6257_ _6257_/X _6121_/A _6121_/B _6256_/Y vddd vssd sg13cmos5l_a21o_1
X_6188_ _6188_/Y _6188_/A _6188_/B _6188_/C _6188_/D vddd vssd sg13cmos5l_nor4_1
XFILLER_24_1917 vddd vssd sg13cmos5l_decap_8
Xhold1510 hold1510/X _7312_/Q vddd vssd sg13cmos5l_dlygate4sd3_1
X_5208_ _5264_/B _5208_/A _5209_/B vddd vssd sg13cmos5l_nor2b_1
XFILLER_6_2550 vddd vssd sg13cmos5l_decap_8
XFILLER_29_224 vddd vssd sg13cmos5l_decap_8
X_5139_ _5149_/A _5218_/A _5177_/B vddd vssd sg13cmos5l_nor2_1
XFILLER_2_2414 vddd vssd sg13cmos5l_decap_4
XFILLER_22_1630 vddd vssd sg13cmos5l_decap_8
XFILLER_16_21 vddd vssd sg13cmos5l_decap_8
XFILLER_13_625 vddd vssd sg13cmos5l_decap_8
XFILLER_16_1445 vddd vssd sg13cmos5l_decap_8
XFILLER_32_42 vddd vssd sg13cmos5l_decap_8
XFILLER_27_2253 vddd vssd sg13cmos5l_decap_8
XFILLER_7_2325 vddd vssd sg13cmos5l_decap_4
XFILLER_23_2128 vddd vssd sg13cmos5l_decap_8
XFILLER_0_562 vddd vssd sg13cmos5l_decap_8
XFILLER_7_1646 vddd vssd sg13cmos5l_decap_8
XFILLER_23_1416 vddd vssd sg13cmos5l_decap_8
Xclkbuf_4_10__f_clk_regs _7355_/CLK clkbuf_3_5_0_clk_regs/X vddd vssd sg13cmos5l_buf_8
XFILLER_21_1195 vddd vssd sg13cmos5l_decap_8
XFILLER_32_934 vddd vssd sg13cmos5l_decap_8
XFILLER_16_485 vddd vssd sg13cmos5l_decap_8
XFILLER_31_422 vddd vssd sg13cmos5l_decap_8
XFILLER_12_2500 vddd vssd sg13cmos5l_decap_8
X_4510_ _4510_/Y _4531_/A _4511_/C _4508_/C vddd vssd sg13cmos5l_o21ai_1
X_5490_ _5491_/B _5807_/A1 _5483_/Y _5498_/D vddd vssd sg13cmos5l_o21ai_1
XFILLER_12_2577 vddd vssd sg13cmos5l_decap_8
X_4441_ _4756_/B _4781_/A _4798_/B vddd vssd sg13cmos5l_and2_1
X_7160_ _7160_/Q _7200_/CLK _7160_/D fanout360/X vddd vssd sg13cmos5l_dfrbpq_1
X_6111_ _6111_/Y _3797_/X _5150_/A _6109_/Y _6110_/Y _5149_/D vddd vssd sg13cmos5l_a221oi_1
X_4372_ _4420_/B _3494_/Y _7095_/Q _4370_/Y _4371_/Y vddd vssd sg13cmos5l_a22oi_1
X_7091_ _7091_/Q _7123_/CLK _7091_/D _6865_/B_N vddd vssd sg13cmos5l_dfrbpq_1
XFILLER_21_0 vddd vssd sg13cmos5l_decap_8
X_6042_ _6042_/Y _5074_/C _5241_/A _5067_/D _6154_/A vddd vssd sg13cmos5l_a22oi_1
XFILLER_6_1134 vddd vssd sg13cmos5l_decap_8
XFILLER_6_1189 vddd vssd sg13cmos5l_decap_4
XFILLER_26_216 vddd vssd sg13cmos5l_decap_8
Xoutbuffers\[35\] biasgen_ref_vbg _7061_/Q vddd vssd sg13cmos5l_buf_16
X_6944_ _6944_/Y _6966_/A _6964_/B_N vddd vssd sg13cmos5l_nor2b_1
XFILLER_1_1790 vddd vssd sg13cmos5l_decap_8
X_6875_ _6875_/Y _6893_/A _6917_/B_N vddd vssd sg13cmos5l_nor2b_1
X_5826_ _5826_/X _5842_/A _5848_/A vddd vssd sg13cmos5l_and2_1
XFILLER_17_2499 vddd vssd sg13cmos5l_decap_8
X_5757_ _5759_/B _5757_/A _5764_/B _5758_/B vddd vssd sg13cmos5l_nand3_1
X_4708_ _4708_/Y _4703_/Y _4706_/Y _4707_/Y vddd vssd sg13cmos5l_a21oi_1
XFILLER_11_2043 vddd vssd sg13cmos5l_decap_8
X_5688_ _5688_/Y _6212_/A1 _5705_/C _7205_/Q vddd vssd sg13cmos5l_o21ai_1
X_4639_ _4639_/Y _4653_/A _4732_/B vddd vssd sg13cmos5l_nand2_1
Xhold662 _6591_/A _7250_/Q vddd vssd sg13cmos5l_dlygate4sd3_1
Xhold651 _4290_/A _7372_/Q vddd vssd sg13cmos5l_dlygate4sd3_1
Xhold640 _7397_/D _3656_/Y vddd vssd sg13cmos5l_dlygate4sd3_1
X_7358_ _7358_/Q _7403_/CLK _7358_/D _6872_/Y vddd vssd sg13cmos5l_dfrbpq_1
XFILLER_28_2573 vddd vssd sg13cmos5l_decap_8
X_7289_ _7289_/Q _7289_/CLK _7289_/D fanout378/X vddd vssd sg13cmos5l_dfrbpq_1
XFILLER_24_2404 vddd vssd sg13cmos5l_decap_8
Xhold684 _6981_/D _5947_/X vddd vssd sg13cmos5l_dlygate4sd3_1
XFILLER_1_326 vddd vssd sg13cmos5l_decap_4
Xhold673 _4820_/B _7333_/Q vddd vssd sg13cmos5l_dlygate4sd3_1
Xhold695 _4272_/A hold695/A vddd vssd sg13cmos5l_dlygate4sd3_1
X_6309_ _6309_/X hold885/X _6342_/A _6805_/B vddd vssd sg13cmos5l_mux2_1
XFILLER_28_1861 vddd vssd sg13cmos5l_decap_4
XFILLER_8_1955 vddd vssd sg13cmos5l_decap_8
Xhold1340 _6422_/A1 _5389_/A vddd vssd sg13cmos5l_dlygate4sd3_1
XFILLER_24_1758 vddd vssd sg13cmos5l_decap_8
Xhold1351 _6452_/A1 _5498_/D vddd vssd sg13cmos5l_dlygate4sd3_1
Xhold1373 _7082_/D _6778_/Y vddd vssd sg13cmos5l_dlygate4sd3_1
Xhold1395 _7340_/D _4663_/Y vddd vssd sg13cmos5l_dlygate4sd3_1
XFILLER_27_42 vddd vssd sg13cmos5l_decap_8
Xhold1362 _4743_/A _7336_/Q vddd vssd sg13cmos5l_dlygate4sd3_1
Xhold1384 _6542_/A1 _5837_/B vddd vssd sg13cmos5l_dlygate4sd3_1
XFILLER_2_2299 vddd vssd sg13cmos5l_decap_4
XFILLER_2_1576 vddd vssd sg13cmos5l_decap_8
XFILLER_26_783 vddd vssd sg13cmos5l_decap_8
XFILLER_18_1507 vddd vssd sg13cmos5l_decap_8
XFILLER_31_2408 vddd vssd sg13cmos5l_decap_8
XFILLER_13_444 vddd vssd sg13cmos5l_decap_8
XFILLER_12_1106 vddd vssd sg13cmos5l_decap_8
Xtiedowns\[71\] mask_rev_in[27] vddd vssd sg13cmos5l_antennanp
XFILLER_29_2359 vddd vssd sg13cmos5l_decap_8
XFILLER_7_2122 vddd vssd sg13cmos5l_decap_8
XFILLER_7_2155 vddd vssd sg13cmos5l_decap_4
XFILLER_0_392 vddd vssd sg13cmos5l_decap_8
XFILLER_7_1476 vddd vssd sg13cmos5l_decap_8
X_4990_ _4990_/Y _5207_/A _5074_/C vddd vssd sg13cmos5l_nand2_1
X_3941_ _3941_/Y _5647_/B _6483_/A _6475_/A vddd vssd sg13cmos5l_a21oi_1
XFILLER_17_794 vddd vssd sg13cmos5l_decap_8
XFILLER_1_1097 vddd vssd sg13cmos5l_decap_4
X_3872_ _4106_/A _6597_/A _3959_/A vddd vssd sg13cmos5l_nor2_1
X_6660_ _6660_/Y _6660_/A1 _6663_/S _6659_/Y vddd vssd sg13cmos5l_o21ai_1
X_5611_ _5611_/Y _5757_/A _5609_/B _5609_/Y _5603_/Y _5612_/B vddd vssd sg13cmos5l_a221oi_1
XFILLER_20_937 vddd vssd sg13cmos5l_decap_8
X_6591_ _6591_/Y _6591_/A _6596_/S vddd vssd sg13cmos5l_nor2_1
XFILLER_30_1217 vddd vssd sg13cmos5l_decap_8
X_5542_ _5542_/Y _5542_/A _5557_/B vddd vssd sg13cmos5l_nor2b_1
X_5473_ _5473_/Y _5526_/A _5471_/Y _5472_/Y vddd vssd sg13cmos5l_a21oi_1
X_4424_ _4424_/Y _4458_/A _7083_/Q vddd vssd sg13cmos5l_nand2_1
X_7212_ _7212_/Q _7228_/CLK _7212_/D fanout364/X vddd vssd sg13cmos5l_dfrbpq_1
Xfanout405 _6968_/B_N _6969_/B_N vddd vssd sg13cmos5l_buf_1
X_4355_ _4355_/Y _4355_/A _4355_/B _4355_/C vddd vssd sg13cmos5l_nand3_1
X_7143_ _7143_/Q _7386_/CLK _7143_/D fanout354/X vddd vssd sg13cmos5l_dfrbpq_1
X_7074_ _7074_/Q _7190_/CLK _7074_/D fanout357/X vddd vssd sg13cmos5l_dfrbpq_1
Xfanout416 _5593_/A io_in[8] vddd vssd sg13cmos5l_buf_1
Xfanout427 _5967_/A io_in[5] vddd vssd sg13cmos5l_buf_1
Xfanout438 _5976_/A io_in[1] vddd vssd sg13cmos5l_buf_1
Xfanout449 _6754_/A SDI vddd vssd sg13cmos5l_buf_1
X_4286_ _4290_/C _4315_/A _4305_/A vddd vssd sg13cmos5l_nor2_1
X_6025_ _6025_/Y _6072_/A _5032_/B _5025_/C vddd vssd sg13cmos5l_a21oi_1
XFILLER_19_2506 vddd vssd sg13cmos5l_decap_8
X_6927_ _6927_/Y _6948_/A _6969_/B_N vddd vssd sg13cmos5l_nor2b_1
X_6858_ _6858_/Y _6961_/A _6960_/B_N vddd vssd sg13cmos5l_nor2b_1
XFILLER_23_753 vddd vssd sg13cmos5l_decap_8
XFILLER_22_252 vddd vssd sg13cmos5l_decap_4
Xfanout45 _4736_/B1 _4395_/Y vddd vssd sg13cmos5l_buf_1
Xfanout34 _6388_/B _6373_/Y vddd vssd sg13cmos5l_buf_1
Xfanout56 _4746_/B1 _4516_/Y vddd vssd sg13cmos5l_buf_1
XFILLER_11_904 vddd vssd sg13cmos5l_decap_8
XFILLER_22_285 vddd vssd sg13cmos5l_decap_8
Xfanout67 _3966_/B _3934_/B vddd vssd sg13cmos5l_buf_1
Xfanout78 _4262_/A2 _3744_/Y vddd vssd sg13cmos5l_buf_1
X_5809_ _5809_/Y _5752_/A _5813_/C _5808_/Y vddd vssd sg13cmos5l_a21oi_1
XFILLER_30_2441 vddd vssd sg13cmos5l_decap_8
X_6789_ _6789_/Y _6789_/A _6789_/B vddd vssd sg13cmos5l_nor2_1
XFILLER_13_77 vddd vssd sg13cmos5l_decap_8
XFILLER_13_1437 vddd vssd sg13cmos5l_decap_8
Xhold481 sram_addr[2] _5981_/X vddd vssd sg13cmos5l_dlygate4sd3_1
XFILLER_1_112 vddd vssd sg13cmos5l_decap_8
XFILLER_28_2370 vddd vssd sg13cmos5l_decap_8
Xhold492 _4942_/A hold492/A vddd vssd sg13cmos5l_dlygate4sd3_1
XFILLER_24_2278 vddd vssd sg13cmos5l_decap_8
Xhold1170 _3572_/A _7204_/Q vddd vssd sg13cmos5l_dlygate4sd3_1
XFILLER_2_2074 vddd vssd sg13cmos5l_decap_8
Xhold1192 _6595_/A0 _7252_/Q vddd vssd sg13cmos5l_dlygate4sd3_1
Xhold1181 _3617_/A _7239_/Q vddd vssd sg13cmos5l_dlygate4sd3_1
XFILLER_18_1304 vddd vssd sg13cmos5l_decap_8
XFILLER_14_742 vddd vssd sg13cmos5l_decap_8
Xclkbuf_leaf_36_SCK_regs _7214_/CLK clkload3/A vddd vssd sg13cmos5l_buf_8
XFILLER_9_256 vddd vssd sg13cmos5l_decap_8
XFILLER_29_2101 vddd vssd sg13cmos5l_decap_8
XFILLER_6_974 vddd vssd sg13cmos5l_decap_8
XFILLER_9_2206 vddd vssd sg13cmos5l_decap_4
XFILLER_9_1538 vddd vssd sg13cmos5l_decap_8
XFILLER_9_1516 vddd vssd sg13cmos5l_decap_4
X_4140_ _4140_/Y _4137_/Y _4138_/X _4139_/Y vddd vssd sg13cmos5l_o21ai_1
X_4071_ _4071_/Y _7130_/Q _6363_/A vddd vssd sg13cmos5l_nor2_1
X_4973_ sram_idata[1] _6765_/A _4980_/B vddd vssd sg13cmos5l_and2_1
X_6712_ _6712_/Y _6712_/A _6717_/S vddd vssd sg13cmos5l_nor2_1
X_3924_ _6514_/A _3924_/A _6395_/A vddd vssd sg13cmos5l_nor2_1
XFILLER_32_572 vddd vssd sg13cmos5l_decap_8
X_6643_ _6643_/X _6643_/A0 _6636_/A _6645_/S vddd vssd sg13cmos5l_mux2_1
XFILLER_14_2414 vddd vssd sg13cmos5l_decap_8
Xclkload9 clkload9/X clkload9/A vddd vssd sg13cmos5l_buf_8
X_3855_ _3855_/Y mask_rev_in[20] _3745_/Y _4263_/B vddd vssd sg13cmos5l_o21ai_1
X_3786_ _3786_/Y _3786_/A wire96/X vddd vssd sg13cmos5l_nand2_1
X_6574_ _6574_/Y _6581_/A _6574_/B vddd vssd sg13cmos5l_nor2_1
X_5525_ _5528_/A _5727_/A _5524_/C _5524_/Y vddd vssd sg13cmos5l_o21ai_1
XFILLER_12_1481 vddd vssd sg13cmos5l_decap_8
X_5456_ _5471_/C _7170_/Q _7171_/Q vddd vssd sg13cmos5l_nand2_1
X_4407_ _4407_/Y _4410_/A _4413_/B _4404_/A vddd vssd sg13cmos5l_a21oi_1
XFILLER_25_2510 vddd vssd sg13cmos5l_decap_8
X_5387_ _5388_/C _5789_/A _5387_/B vddd vssd sg13cmos5l_and2_1
Xfanout213 _6914_/A _7370_/Q vddd vssd sg13cmos5l_buf_1
Xfanout202 _6532_/A _6690_/A vddd vssd sg13cmos5l_buf_1
Xfanout235 _4385_/A hold1464/X vddd vssd sg13cmos5l_buf_1
X_4338_ _4338_/X _4338_/A _4338_/B vddd vssd sg13cmos5l_xor2_1
Xfanout224 _6870_/A _6951_/A vddd vssd sg13cmos5l_buf_1
Xfanout246 _4782_/A hold1452/X vddd vssd sg13cmos5l_buf_1
X_7126_ _7126_/Q _7263_/CLK _7126_/D fanout389/X vddd vssd sg13cmos5l_dfrbpq_1
X_7057_ _7057_/Q _7285_/CLK _7057_/D fanout383/X vddd vssd sg13cmos5l_dfrbpq_1
Xfanout268 _5224_/A _7281_/Q vddd vssd sg13cmos5l_buf_1
XFILLER_25_2587 vddd vssd sg13cmos5l_decap_8
Xfanout279 _5901_/B hold1412/X vddd vssd sg13cmos5l_buf_1
X_4269_ _4269_/Y _4269_/A _7374_/Q vddd vssd sg13cmos5l_nor2_1
Xfanout257 _5988_/A _4909_/B1 vddd vssd sg13cmos5l_buf_1
X_6008_ _6008_/Y _7290_/Q _6007_/Y _5992_/Y vddd vssd sg13cmos5l_o21ai_1
XFILLER_19_1613 vddd vssd sg13cmos5l_decap_8
XFILLER_24_21 vddd vssd sg13cmos5l_decap_8
XFILLER_23_550 vddd vssd sg13cmos5l_decap_8
XFILLER_32_2558 vddd vssd sg13cmos5l_decap_8
XFILLER_32_1824 vddd vssd sg13cmos5l_decap_8
XFILLER_24_98 vddd vssd sg13cmos5l_decap_8
XFILLER_11_745 vddd vssd sg13cmos5l_decap_8
XFILLER_17_1381 vddd vssd sg13cmos5l_decap_4
XFILLER_6_215 vddd vssd sg13cmos5l_decap_4
XFILLER_13_1278 vddd vssd sg13cmos5l_decap_8
XFILLER_26_2329 vddd vssd sg13cmos5l_decap_8
XFILLER_2_443 vddd vssd sg13cmos5l_decap_4
XFILLER_26_1639 vddd vssd sg13cmos5l_decap_8
Xtiedowns\[34\] dbus_in_right[2] vddd vssd sg13cmos5l_antennanp
XFILLER_1_14 vddd vssd sg13cmos5l_decap_8
XFILLER_4_2125 vddd vssd sg13cmos5l_decap_8
XFILLER_8_1560 vddd vssd sg13cmos5l_decap_8
XFILLER_8_2294 vddd vssd sg13cmos5l_decap_4
XFILLER_24_2086 vddd vssd sg13cmos5l_decap_8
XFILLER_24_1352 vddd vssd sg13cmos5l_decap_8
X_3640_ _4900_/B _7087_/Q _7086_/Q vddd vssd sg13cmos5l_nand2b_1
X_3571_ _5690_/B _3571_/A vddd vssd sg13cmos5l_inv_1
X_6290_ _6290_/Y _6291_/A _6287_/B _6287_/A vddd vssd sg13cmos5l_a21oi_1
X_5310_ _5310_/Y _5310_/A vddd vssd sg13cmos5l_inv_1
XFILLER_9_2014 vddd vssd sg13cmos5l_decap_8
X_5241_ _5254_/A _5241_/A _5241_/B vddd vssd sg13cmos5l_nand2_1
X_5172_ _6154_/B _5261_/A _5172_/B vddd vssd sg13cmos5l_nand2b_1
X_4123_ _4123_/Y _5861_/B _6545_/A _6538_/A vddd vssd sg13cmos5l_a21oi_1
X_4054_ _4054_/Y _5413_/A _6424_/A _4144_/B vddd vssd sg13cmos5l_a21oi_1
XFILLER_20_2451 vddd vssd sg13cmos5l_decap_8
XFILLER_7_1081 vddd vssd sg13cmos5l_decap_8
XFILLER_0_1899 vddd vssd sg13cmos5l_decap_8
XFILLER_0_1866 vddd vssd sg13cmos5l_decap_4
X_4956_ _4956_/Y _4943_/B _4955_/Y _4954_/Y vddd vssd sg13cmos5l_o21ai_1
XFILLER_32_1109 vddd vssd sg13cmos5l_decap_8
XFILLER_32_380 vddd vssd sg13cmos5l_decap_8
X_3907_ _6561_/A _3955_/A _3924_/A vddd vssd sg13cmos5l_nor2_1
X_4887_ _4889_/A _4940_/A _7143_/Q _7142_/Q _4942_/A vddd vssd sg13cmos5l_a22oi_1
X_3838_ _3838_/Y _7049_/Q _3831_/X _3833_/Y vddd vssd sg13cmos5l_a21oi_1
X_6626_ _6626_/X _6626_/A0 _6336_/A _6626_/S vddd vssd sg13cmos5l_mux2_1
XFILLER_20_597 vddd vssd sg13cmos5l_decap_8
X_6557_ _7231_/D _6690_/A _6557_/A1 _6560_/S vddd vssd sg13cmos5l_mux2_1
X_3769_ _6088_/A dbus_in_left[6] dbus_in_right[6] vddd vssd sg13cmos5l_or2_1
XFILLER_3_218 vddd vssd sg13cmos5l_decap_4
X_5508_ _5508_/X _5523_/A _5529_/A vddd vssd sg13cmos5l_and2_1
X_6488_ _7196_/D _6488_/A1 _6489_/S _6487_/Y vddd vssd sg13cmos5l_a21oi_1
XFILLER_10_23 vddd vssd sg13cmos5l_decap_8
X_5439_ _5439_/Y _5326_/A _5437_/B _5437_/Y _5431_/Y _5440_/B vddd vssd sg13cmos5l_a221oi_1
XFILLER_27_1937 vddd vssd sg13cmos5l_decap_8
XFILLER_19_21 vddd vssd sg13cmos5l_decap_8
XFILLER_5_2445 vddd vssd sg13cmos5l_decap_4
X_7109_ _7109_/Q _7123_/CLK _7109_/D _6865_/B_N vddd vssd sg13cmos5l_dfrbpq_1
XFILLER_25_2384 vddd vssd sg13cmos5l_decap_8
XFILLER_19_119 vddd vssd sg13cmos5l_decap_4
XFILLER_5_2456 vddd vssd sg13cmos5l_decap_8
XFILLER_19_98 vddd vssd sg13cmos5l_decap_8
XFILLER_5_1755 vddd vssd sg13cmos5l_decap_4
XFILLER_28_675 vddd vssd sg13cmos5l_decap_8
XFILLER_27_152 vddd vssd sg13cmos5l_decap_8
XFILLER_21_1547 vddd vssd sg13cmos5l_decap_4
XFILLER_19_2133 vddd vssd sg13cmos5l_decap_8
XFILLER_3_1490 vddd vssd sg13cmos5l_decap_8
XFILLER_32_2300 vddd vssd sg13cmos5l_decap_8
XFILLER_15_1307 vddd vssd sg13cmos5l_decap_4
XFILLER_32_1632 vddd vssd sg13cmos5l_decap_8
XFILLER_32_1687 vddd vssd sg13cmos5l_decap_8
XFILLER_25_7 vddd vssd sg13cmos5l_decap_4
XFILLER_24_1182 vddd vssd sg13cmos5l_decap_8
XFILLER_4_1254 vddd vssd sg13cmos5l_decap_8
X_4810_ _4810_/Y _4820_/B _4810_/B vddd vssd sg13cmos5l_nand2_1
X_5790_ _5790_/Y _5794_/A _5791_/B _5790_/C vddd vssd sg13cmos5l_nor3_1
XFILLER_15_2542 vddd vssd sg13cmos5l_decap_8
X_4741_ _4741_/Y _4507_/X _4736_/X _4740_/Y _4460_/B vddd vssd sg13cmos5l_a22oi_1
X_4672_ _4672_/Y _4169_/A _4651_/Y _4758_/B1 vddd vssd sg13cmos5l_a21oi_1
XFILLER_15_1863 vddd vssd sg13cmos5l_decap_4
X_6411_ _6411_/Y _6411_/A _6416_/S vddd vssd sg13cmos5l_nand2_1
X_3623_ _5956_/A _3623_/A vddd vssd sg13cmos5l_inv_1
X_7391_ _7391_/Q _7391_/CLK _7391_/D _6820_/Y vddd vssd sg13cmos5l_dfrbpq_1
XFILLER_31_1186 vddd vssd sg13cmos5l_decap_4
X_6342_ _6342_/Y _6342_/A _6344_/B vddd vssd sg13cmos5l_nand2_1
X_3554_ _3554_/Y _7165_/Q vddd vssd sg13cmos5l_inv_1
X_6273_ _6273_/Y _6273_/A _6273_/B vddd vssd sg13cmos5l_nor2_1
X_3485_ _3485_/Y _4733_/A vddd vssd sg13cmos5l_inv_1
Xoutbuffers\[65\] idac2_value[2] _7047_/Q vddd vssd sg13cmos5l_buf_16
X_5224_ _5234_/B _5224_/A _5224_/B vddd vssd sg13cmos5l_nand2_1
XFILLER_22_2513 vddd vssd sg13cmos5l_decap_8
X_5155_ _5159_/B _5241_/A _5175_/B vddd vssd sg13cmos5l_and2_1
XFILLER_9_1176 vddd vssd sg13cmos5l_decap_8
XFILLER_9_1198 vddd vssd sg13cmos5l_decap_8
X_5086_ _6060_/B _7284_/Q _7285_/Q _5256_/A vddd vssd sg13cmos5l_nor3_1
X_4106_ _4106_/Y _4106_/A _4106_/B vddd vssd sg13cmos5l_nor2_1
XFILLER_0_2331 vddd vssd sg13cmos5l_decap_8
X_4037_ _4040_/A _4034_/Y _4035_/X _4036_/Y vddd vssd sg13cmos5l_o21ai_1
XFILLER_24_133 vddd vssd sg13cmos5l_decap_8
XFILLER_20_1591 vddd vssd sg13cmos5l_decap_8
XFILLER_25_678 vddd vssd sg13cmos5l_decap_8
X_5988_ _5988_/Y _5988_/A _5988_/B _5988_/C vddd vssd sg13cmos5l_nor3_1
X_4939_ _4939_/Y _4940_/A _4954_/B vddd vssd sg13cmos5l_nand2_1
XANTENNA_40 _6777_/A vddd vssd sg13cmos5l_antennanp
XANTENNA_51 _6344_/A vddd vssd sg13cmos5l_antennanp
X_6609_ _6614_/S _6609_/A _6736_/B vddd vssd sg13cmos5l_nor2_1
XFILLER_21_77 vddd vssd sg13cmos5l_decap_8
XFILLER_27_2457 vddd vssd sg13cmos5l_decap_8
XFILLER_7_2529 vddd vssd sg13cmos5l_decap_8
XFILLER_27_1789 vddd vssd sg13cmos5l_decap_4
XFILLER_23_1609 vddd vssd sg13cmos5l_decap_8
XFILLER_21_2034 vddd vssd sg13cmos5l_decap_4
XFILLER_5_2275 vddd vssd sg13cmos5l_decap_8
XFILLER_21_1388 vddd vssd sg13cmos5l_decap_8
XFILLER_30_114 vddd vssd sg13cmos5l_decap_8
XFILLER_19_1273 vddd vssd sg13cmos5l_decap_8
XFILLER_12_851 vddd vssd sg13cmos5l_decap_8
XFILLER_32_2185 vddd vssd sg13cmos5l_decap_8
XFILLER_7_79 vddd vssd sg13cmos5l_decap_8
XFILLER_8_899 vddd vssd sg13cmos5l_decap_8
X_6960_ _6960_/Y _6961_/A _6960_/B_N vddd vssd sg13cmos5l_nor2b_1
X_5911_ _5911_/Y _7097_/Q _5927_/B _5930_/A _7098_/Q vddd vssd sg13cmos5l_a22oi_1
XFILLER_4_1062 vddd vssd sg13cmos5l_decap_8
XFILLER_4_1095 vddd vssd sg13cmos5l_decap_8
X_6891_ _6891_/Y _6917_/A _6915_/B_N vddd vssd sg13cmos5l_nor2b_1
XFILLER_22_615 vddd vssd sg13cmos5l_decap_8
X_5842_ _5843_/C _5842_/A _5842_/B vddd vssd sg13cmos5l_nand2_1
X_5773_ _5786_/A _5794_/A _5773_/B vddd vssd sg13cmos5l_nor2_1
Xoutbuffers\[9\] proj_1v2_ena _7032_/Q vddd vssd sg13cmos5l_buf_16
X_4724_ _4724_/Y _4656_/A _4710_/X _4746_/B1 vddd vssd sg13cmos5l_o21ai_1
X_4655_ _4656_/B _4655_/A _4655_/B vddd vssd sg13cmos5l_xor2_1
X_4586_ _4588_/A _4656_/A _4586_/B vddd vssd sg13cmos5l_nor2_1
X_3606_ _3606_/Y _3606_/A vddd vssd sg13cmos5l_inv_1
Xhold811 _7119_/D _6345_/Y vddd vssd sg13cmos5l_dlygate4sd3_1
Xhold800 _7131_/D _6368_/X vddd vssd sg13cmos5l_dlygate4sd3_1
X_7374_ _7374_/Q _7404_/CLK _7374_/D _6888_/Y vddd vssd sg13cmos5l_dfrbpq_1
X_3537_ _5294_/B _3537_/A vddd vssd sg13cmos5l_inv_1
Xhold833 hold833/X _7133_/Q vddd vssd sg13cmos5l_dlygate4sd3_1
Xhold844 hold844/X _7397_/Q vddd vssd sg13cmos5l_dlygate4sd3_1
Xhold822 _7093_/D _6800_/X vddd vssd sg13cmos5l_dlygate4sd3_1
X_6325_ _6325_/Y _6342_/A _6327_/B vddd vssd sg13cmos5l_nand2_1
Xhold855 _6507_/A _7206_/Q vddd vssd sg13cmos5l_dlygate4sd3_1
Xhold877 _7100_/D _6307_/X vddd vssd sg13cmos5l_dlygate4sd3_1
Xhold866 _3673_/B _3674_/S vddd vssd sg13cmos5l_dlygate4sd3_1
Xhold888 hold888/X _3531_/Y vddd vssd sg13cmos5l_dlygate4sd3_1
X_3468_ _3468_/Y _4971_/A vddd vssd sg13cmos5l_inv_1
X_6256_ _6256_/Y _4385_/A _7301_/Q _6121_/B vddd vssd sg13cmos5l_a21oi_1
Xhold899 hold899/X _6539_/Y vddd vssd sg13cmos5l_dlygate4sd3_1
Xhold1500 hold505/A _7018_/Q vddd vssd sg13cmos5l_dlygate4sd3_1
XFILLER_29_203 vddd vssd sg13cmos5l_decap_8
X_6187_ _6187_/Y _6169_/Y _6186_/Y _6168_/Y vddd vssd sg13cmos5l_o21ai_1
X_5207_ _5214_/C _5207_/A _5241_/B vddd vssd sg13cmos5l_and2_1
X_5138_ _5150_/A _5228_/A _5166_/B vddd vssd sg13cmos5l_nor2_1
Xhold1511 hold937/A _7305_/Q vddd vssd sg13cmos5l_dlygate4sd3_1
XFILLER_2_2448 vddd vssd sg13cmos5l_decap_8
XFILLER_26_921 vddd vssd sg13cmos5l_decap_4
X_5069_ _5072_/C _5069_/A _5069_/B vddd vssd sg13cmos5l_nand2_1
XFILLER_22_1697 vddd vssd sg13cmos5l_decap_8
XFILLER_0_2172 vddd vssd sg13cmos5l_decap_4
XFILLER_16_77 vddd vssd sg13cmos5l_decap_8
XFILLER_16_2136 vddd vssd sg13cmos5l_decap_8
XFILLER_13_659 vddd vssd sg13cmos5l_decap_8
XFILLER_32_21 vddd vssd sg13cmos5l_decap_8
XFILLER_16_1468 vddd vssd sg13cmos5l_decap_8
XFILLER_32_98 vddd vssd sg13cmos5l_decap_8
XFILLER_10_1045 vddd vssd sg13cmos5l_decap_8
XFILLER_7_1625 vddd vssd sg13cmos5l_decap_8
XFILLER_7_1669 vddd vssd sg13cmos5l_decap_8
XFILLER_17_932 vddd vssd sg13cmos5l_decap_8
XFILLER_32_913 vddd vssd sg13cmos5l_decap_8
XFILLER_17_998 vddd vssd sg13cmos5l_decap_8
XFILLER_12_2556 vddd vssd sg13cmos5l_decap_8
XFILLER_32_1292 vddd vssd sg13cmos5l_decap_8
X_4440_ _4798_/B _5315_/A _6009_/A vddd vssd sg13cmos5l_and2_1
XFILLER_8_685 vddd vssd sg13cmos5l_decap_8
XFILLER_12_1855 vddd vssd sg13cmos5l_decap_8
XFILLER_10_2291 vddd vssd sg13cmos5l_decap_8
X_6110_ _6110_/Y _6177_/A _5150_/C _5150_/A vddd vssd sg13cmos5l_a21oi_1
X_4371_ _4371_/Y _3494_/A _3530_/Y _3531_/Y _4404_/A vddd vssd sg13cmos5l_a22oi_1
X_7090_ _7090_/Q _7263_/CLK _7090_/D _6865_/B_N vddd vssd sg13cmos5l_dfrbpq_1
X_6041_ _6041_/X _6040_/Y _6088_/A _6041_/S vddd vssd sg13cmos5l_mux2_1
XFILLER_14_0 vddd vssd sg13cmos5l_decap_8
X_6943_ _6943_/Y _6966_/A _6964_/B_N vddd vssd sg13cmos5l_nor2b_1
Xoutbuffers\[28\] voltgen_sink1[1] _7068_/Q vddd vssd sg13cmos5l_buf_16
XFILLER_23_913 vddd vssd sg13cmos5l_decap_8
X_6874_ _6874_/Y _6893_/A _6874_/B_N vddd vssd sg13cmos5l_nor2b_1
X_5825_ _5848_/A _5837_/B _7225_/Q vddd vssd sg13cmos5l_nor2_1
XFILLER_17_2478 vddd vssd sg13cmos5l_decap_8
XFILLER_17_1722 vddd vssd sg13cmos5l_decap_8
XFILLER_31_990 vddd vssd sg13cmos5l_decap_4
Xtiedowns\[0\] sram_odata[0] vddd vssd sg13cmos5l_antennanp
X_5756_ _5759_/A _5756_/A _5756_/B _5756_/C vddd vssd sg13cmos5l_nand3_1
X_5687_ _5687_/Y _6211_/A _7202_/Q _7203_/Q vddd vssd sg13cmos5l_nor3_1
X_4707_ _4707_/Y _4771_/A1 _3599_/Y _4771_/B1 _4701_/X _4684_/A vddd vssd sg13cmos5l_a221oi_1
XFILLER_11_2022 vddd vssd sg13cmos5l_decap_8
X_4638_ _4640_/A _4684_/A _4636_/Y _4637_/Y vddd vssd sg13cmos5l_o21ai_1
XFILLER_11_1332 vddd vssd sg13cmos5l_decap_8
Xhold630 _7326_/D _4860_/Y vddd vssd sg13cmos5l_dlygate4sd3_1
X_4569_ _4569_/Y _4582_/A _4810_/B vddd vssd sg13cmos5l_nand2_1
Xhold652 _4291_/B _4290_/X vddd vssd sg13cmos5l_dlygate4sd3_1
Xhold663 hold663/X _6591_/Y vddd vssd sg13cmos5l_dlygate4sd3_1
Xhold641 _6357_/A _7125_/Q vddd vssd sg13cmos5l_dlygate4sd3_1
XFILLER_11_1376 vddd vssd sg13cmos5l_decap_8
X_7357_ _7357_/Q _7357_/CLK _7357_/D _6871_/Y vddd vssd sg13cmos5l_dfrbpq_1
XFILLER_28_2552 vddd vssd sg13cmos5l_decap_8
X_7288_ _7288_/Q _7300_/CLK _7288_/D fanout379/X vddd vssd sg13cmos5l_dfrbpq_1
X_6308_ _6308_/X hold883/X _6661_/A _6308_/S vddd vssd sg13cmos5l_mux2_1
Xhold685 hold685/X _7268_/Q vddd vssd sg13cmos5l_dlygate4sd3_1
Xhold674 hold674/X _4810_/Y vddd vssd sg13cmos5l_dlygate4sd3_1
Xhold696 _7403_/D _5281_/X vddd vssd sg13cmos5l_dlygate4sd3_1
X_6239_ _6239_/Y _6239_/A _6239_/B vddd vssd sg13cmos5l_nor2_1
Xhold1341 _3567_/A _7193_/Q vddd vssd sg13cmos5l_dlygate4sd3_1
Xhold1330 hold1330/X _7217_/Q vddd vssd sg13cmos5l_dlygate4sd3_1
Xhold1352 _7177_/D _6452_/Y vddd vssd sg13cmos5l_dlygate4sd3_1
XFILLER_27_21 vddd vssd sg13cmos5l_decap_8
XFILLER_2_2278 vddd vssd sg13cmos5l_decap_8
Xhold1363 _4752_/B1 _4732_/Y vddd vssd sg13cmos5l_dlygate4sd3_1
Xhold1385 _6682_/A0 _7319_/Q vddd vssd sg13cmos5l_dlygate4sd3_1
Xhold1374 hold1374/X _7338_/Q vddd vssd sg13cmos5l_dlygate4sd3_1
Xhold1396 hold1396/X _7187_/Q vddd vssd sg13cmos5l_dlygate4sd3_1
XFILLER_14_913 vddd vssd sg13cmos5l_decap_8
XFILLER_25_294 vddd vssd sg13cmos5l_decap_8
XFILLER_13_423 vddd vssd sg13cmos5l_decap_8
XFILLER_9_416 vddd vssd sg13cmos5l_decap_4
Xtiedowns\[64\] mask_rev_in[20] vddd vssd sg13cmos5l_antennanp
XFILLER_5_655 vddd vssd sg13cmos5l_decap_8
XFILLER_29_1604 vddd vssd sg13cmos5l_decap_8
XFILLER_7_2101 vddd vssd sg13cmos5l_decap_4
XFILLER_7_1400 vddd vssd sg13cmos5l_decap_8
XFILLER_0_371 vddd vssd sg13cmos5l_decap_8
XFILLER_7_1433 vddd vssd sg13cmos5l_decap_8
X_3940_ _6475_/A _3940_/A _3940_/B _3961_/B vddd vssd sg13cmos5l_nor3_1
Xoutbuffers\[118\] dbus_out[21] _5906_/Y vddd vssd sg13cmos5l_buf_16
X_3871_ _3884_/A _7265_/Q _3889_/A _3962_/A vddd vssd sg13cmos5l_nand3_1
XFILLER_32_787 vddd vssd sg13cmos5l_decap_8
X_5610_ _5612_/B _7190_/Q _7191_/Q _5610_/C vddd vssd sg13cmos5l_nor3_1
X_6590_ _6596_/S _6590_/A _6736_/B vddd vssd sg13cmos5l_nor2_1
X_5541_ _5556_/C _7182_/Q _7183_/Q vddd vssd sg13cmos5l_nand2_1
XFILLER_12_2320 vddd vssd sg13cmos5l_decap_4
XFILLER_12_1630 vddd vssd sg13cmos5l_decap_8
X_5472_ _5472_/Y _7172_/Q _5472_/B _5472_/C vddd vssd sg13cmos5l_nor3_1
X_7211_ _7211_/Q _7228_/CLK _7211_/D fanout365/X vddd vssd sg13cmos5l_dfrbpq_1
X_4423_ _4484_/B _4812_/B _4458_/B vddd vssd sg13cmos5l_nor2_1
X_7142_ _7142_/Q _7386_/CLK _7142_/D fanout354/X vddd vssd sg13cmos5l_dfrbpq_1
X_4354_ _4354_/X _4354_/A _4354_/B vddd vssd sg13cmos5l_xor2_1
X_7073_ _7073_/Q _7077_/CLK _7073_/D fanout357/X vddd vssd sg13cmos5l_dfrbpq_1
Xfanout406 _6969_/B_N _6923_/B_N vddd vssd sg13cmos5l_buf_1
XFILLER_28_1147 vddd vssd sg13cmos5l_decap_8
Xfanout439 _5544_/A fanout443/X vddd vssd sg13cmos5l_buf_1
Xfanout428 _5727_/A _5971_/A1 vddd vssd sg13cmos5l_buf_1
Xfanout417 _5319_/A _5888_/A vddd vssd sg13cmos5l_buf_1
X_4285_ _4285_/Y _6713_/A1 _4284_/B hold716/X vddd vssd sg13cmos5l_o21ai_1
X_6024_ _6024_/X _3901_/X _5042_/A _5032_/B vddd vssd sg13cmos5l_a21o_1
Xclkbuf_leaf_6_SCK_regs _7363_/CLK clkload4/A vddd vssd sg13cmos5l_buf_8
XFILLER_23_2482 vddd vssd sg13cmos5l_decap_8
XFILLER_3_2598 vddd vssd sg13cmos5l_decap_8
X_6926_ _6926_/Y _6965_/A _6945_/B_N vddd vssd sg13cmos5l_nor2b_1
XFILLER_23_732 vddd vssd sg13cmos5l_decap_8
XFILLER_19_1817 vddd vssd sg13cmos5l_decap_8
X_6857_ _6857_/Y _6961_/A _6960_/B_N vddd vssd sg13cmos5l_nor2b_1
XFILLER_23_776 vddd vssd sg13cmos5l_decap_8
XFILLER_17_2264 vddd vssd sg13cmos5l_decap_8
Xfanout35 _6382_/B _6373_/Y vddd vssd sg13cmos5l_buf_1
Xfanout24 _4810_/B _4491_/Y vddd vssd sg13cmos5l_buf_1
Xfanout46 _4798_/A _4395_/Y vddd vssd sg13cmos5l_buf_1
Xfanout79 _4172_/A2 _4259_/B vddd vssd sg13cmos5l_buf_1
Xfanout57 _4804_/B1 _4516_/Y vddd vssd sg13cmos5l_buf_1
Xfanout68 _6538_/A _3916_/Y vddd vssd sg13cmos5l_buf_1
X_5808_ _5808_/Y _6225_/A _7220_/Q _5806_/Y vddd vssd sg13cmos5l_o21ai_1
X_6788_ _7087_/D _6788_/A0 _6788_/A1 _6788_/S vddd vssd sg13cmos5l_mux2_1
XFILLER_30_2420 vddd vssd sg13cmos5l_decap_8
X_5739_ _5764_/A _5762_/A _7213_/Q vddd vssd sg13cmos5l_nor2_1
XFILLER_13_56 vddd vssd sg13cmos5l_decap_8
XFILLER_30_2497 vddd vssd sg13cmos5l_decap_8
XFILLER_11_1140 vddd vssd sg13cmos5l_decap_8
Xhold482 _4937_/A hold482/A vddd vssd sg13cmos5l_dlygate4sd3_1
Xhold493 sram_addr[6] _5985_/X vddd vssd sg13cmos5l_dlygate4sd3_1
XFILLER_8_2487 vddd vssd sg13cmos5l_decap_8
Xhold1160 _7181_/D _6460_/Y vddd vssd sg13cmos5l_dlygate4sd3_1
Xhold1171 _6504_/A1 _5693_/C vddd vssd sg13cmos5l_dlygate4sd3_1
Xhold1193 _7252_/D _6595_/X vddd vssd sg13cmos5l_dlygate4sd3_1
Xhold1182 _6572_/A1 _5968_/B vddd vssd sg13cmos5l_dlygate4sd3_1
XFILLER_26_592 vddd vssd sg13cmos5l_decap_8
XFILLER_26_581 vddd vssd sg13cmos5l_decap_4
XFILLER_18_1338 vddd vssd sg13cmos5l_decap_8
XFILLER_13_1983 vddd vssd sg13cmos5l_decap_8
XFILLER_29_1478 vddd vssd sg13cmos5l_decap_8
X_4070_ wire8/A _4067_/Y _4068_/Y _4069_/Y vddd vssd sg13cmos5l_a21oi_1
XFILLER_3_1149 vddd vssd sg13cmos5l_decap_8
XFILLER_24_518 vddd vssd sg13cmos5l_decap_8
XFILLER_17_570 vddd vssd sg13cmos5l_decap_8
X_4972_ sram_idata[0] _4972_/A _4980_/B vddd vssd sg13cmos5l_and2_1
X_6711_ _6717_/S _6711_/A _6762_/C vddd vssd sg13cmos5l_nor2_1
X_3923_ _3923_/Y _7221_/Q _6529_/A _3920_/Y _3918_/Y _6522_/A vddd vssd sg13cmos5l_a221oi_1
X_6642_ _7282_/D _6704_/A1 _6645_/S _6642_/B1 vddd vssd sg13cmos5l_a21oi_1
XFILLER_18_2584 vddd vssd sg13cmos5l_decap_8
X_3854_ _3854_/Y mask_rev_in[12] wire85/X _3962_/A _3786_/A _3853_/Y vddd vssd sg13cmos5l_a221oi_1
X_3785_ _3785_/Y _3786_/A wire98/X _4262_/A2 mask_rev_in[22] _3784_/Y vddd vssd sg13cmos5l_a221oi_1
X_6573_ _6573_/X _6550_/A hold868/X _6574_/B vddd vssd sg13cmos5l_mux2_1
Xoutbuffers\[95\] io_out[10] _6258_/Y vddd vssd sg13cmos5l_buf_16
XFILLER_8_290 vddd vssd sg13cmos5l_decap_4
X_5524_ _5524_/Y _5524_/A _5524_/B _5524_/C vddd vssd sg13cmos5l_nand3_1
X_5455_ _5472_/C _7170_/Q _7171_/Q vddd vssd sg13cmos5l_nand2b_1
X_4406_ _4406_/Y _4419_/A _4406_/B vddd vssd sg13cmos5l_nor2_1
X_5386_ _5388_/B _5386_/A _7161_/Q _5386_/C vddd vssd sg13cmos5l_nor3_1
Xfanout214 _6956_/A _6959_/A vddd vssd sg13cmos5l_buf_1
Xfanout203 _6690_/A fanout208/X vddd vssd sg13cmos5l_buf_1
X_7125_ _7125_/Q _7268_/CLK _7125_/D fanout387/X vddd vssd sg13cmos5l_dfrbpq_1
Xfanout236 _5659_/A hold1424/X vddd vssd sg13cmos5l_buf_1
XFILLER_25_2566 vddd vssd sg13cmos5l_decap_8
X_4337_ _4337_/Y _4320_/X _4325_/B _4325_/A vddd vssd sg13cmos5l_o21ai_1
Xfanout225 _6951_/A _6954_/A vddd vssd sg13cmos5l_buf_1
Xfanout247 _4781_/A _4787_/A1 vddd vssd sg13cmos5l_buf_1
X_7056_ _7056_/Q _7300_/CLK _7056_/D fanout375/X vddd vssd sg13cmos5l_dfrbpq_1
Xfanout269 _5223_/A _7280_/Q vddd vssd sg13cmos5l_buf_1
X_4268_ _7389_/D _4265_/Y _4267_/Y hold573/X vddd vssd sg13cmos5l_o21ai_1
Xfanout258 _4916_/A _4909_/B1 vddd vssd sg13cmos5l_buf_1
X_6007_ _6007_/Y _6185_/C _5011_/A _6006_/Y vddd vssd sg13cmos5l_o21ai_1
X_4199_ _4199_/Y _7258_/Q _4106_/A _4196_/Y _4197_/X _4198_/X vddd vssd sg13cmos5l_a221oi_1
XFILLER_3_1672 vddd vssd sg13cmos5l_decap_8
XFILLER_32_2537 vddd vssd sg13cmos5l_decap_8
XFILLER_32_1803 vddd vssd sg13cmos5l_decap_8
XFILLER_24_77 vddd vssd sg13cmos5l_decap_8
XFILLER_17_2083 vddd vssd sg13cmos5l_decap_8
XFILLER_7_706 vddd vssd sg13cmos5l_decap_8
XFILLER_13_1202 vddd vssd sg13cmos5l_decap_8
XFILLER_17_1393 vddd vssd sg13cmos5l_decap_4
XFILLER_3_989 vddd vssd sg13cmos5l_decap_4
XFILLER_24_2032 vddd vssd sg13cmos5l_decap_4
XFILLER_24_2065 vddd vssd sg13cmos5l_decap_8
Xtiedowns\[27\] dbus_in_left[7] vddd vssd sg13cmos5l_antennanp
XFILLER_4_1414 vddd vssd sg13cmos5l_decap_8
XFILLER_24_1397 vddd vssd sg13cmos5l_decap_8
X_3570_ _5666_/B _3570_/A vddd vssd sg13cmos5l_inv_1
XFILLER_13_2492 vddd vssd sg13cmos5l_decap_8
X_5240_ _5251_/A _5240_/A _5265_/B vddd vssd sg13cmos5l_nor2_1
X_5171_ _6146_/B _5256_/A _5171_/B vddd vssd sg13cmos5l_nor2_1
XFILLER_29_1286 vddd vssd sg13cmos5l_decap_8
X_4122_ _4122_/Y _4119_/Y _4120_/Y _4121_/Y vddd vssd sg13cmos5l_o21ai_1
X_4053_ _4053_/Y _4050_/Y _4051_/Y _4052_/Y vddd vssd sg13cmos5l_o21ai_1
XFILLER_0_2524 vddd vssd sg13cmos5l_decap_8
XFILLER_25_827 vddd vssd sg13cmos5l_decap_8
XFILLER_0_1834 vddd vssd sg13cmos5l_decap_8
Xoutbuffers\[10\] proj_3v3_ena _7031_/Q vddd vssd sg13cmos5l_buf_16
X_4955_ _4955_/Y _4955_/A _4955_/B vddd vssd sg13cmos5l_xnor2_1
X_3906_ _3906_/Y _3897_/Y _3898_/Y _3905_/Y vddd vssd sg13cmos5l_o21ai_1
X_4886_ _4891_/B _4958_/A _7137_/Q _7136_/Q _4961_/A _4885_/Y vddd vssd sg13cmos5l_a221oi_1
X_6625_ _6625_/X _6625_/A0 _6773_/A _6626_/S vddd vssd sg13cmos5l_mux2_1
X_3837_ _6711_/A _3984_/B _3947_/A vddd vssd sg13cmos5l_nand2_1
XFILLER_18_1680 vddd vssd sg13cmos5l_decap_4
XFILLER_14_2267 vddd vssd sg13cmos5l_decap_4
X_3768_ _6177_/A dbus_in_left[6] dbus_in_right[6] vddd vssd sg13cmos5l_nor2_1
XFILLER_14_1566 vddd vssd sg13cmos5l_decap_4
X_6556_ _7230_/D _6704_/A1 _6560_/S _6555_/Y vddd vssd sg13cmos5l_o21ai_1
X_5507_ _5529_/A _7180_/Q _7181_/Q vddd vssd sg13cmos5l_nor2_1
X_6487_ _6487_/Y _6558_/A _6489_/S vddd vssd sg13cmos5l_nor2_1
X_3699_ _4009_/B _3753_/A _3753_/B vddd vssd sg13cmos5l_or2_1
X_5438_ _5440_/B _7166_/Q _7167_/Q _5438_/C vddd vssd sg13cmos5l_nor3_1
X_5369_ _5370_/B _5369_/A _5369_/B vddd vssd sg13cmos5l_nor2_1
XFILLER_0_948 vddd vssd sg13cmos5l_decap_4
XFILLER_25_2363 vddd vssd sg13cmos5l_decap_8
XFILLER_0_959 vddd vssd sg13cmos5l_decap_8
XFILLER_5_2424 vddd vssd sg13cmos5l_decap_8
X_7108_ _7108_/Q _7123_/CLK _7108_/D fanout396/X vddd vssd sg13cmos5l_dfrbpq_1
X_7039_ _7039_/Q _7289_/CLK _7039_/D fanout374/X vddd vssd sg13cmos5l_dfrbpq_1
XFILLER_25_1640 vddd vssd sg13cmos5l_decap_8
XFILLER_25_1695 vddd vssd sg13cmos5l_decap_8
XFILLER_19_77 vddd vssd sg13cmos5l_decap_8
XFILLER_28_654 vddd vssd sg13cmos5l_decap_8
XFILLER_27_131 vddd vssd sg13cmos5l_decap_8
XFILLER_32_1611 vddd vssd sg13cmos5l_decap_8
Xclkbuf_3_3_0_clk_regs clkbuf_3_3_0_clk_regs/X clkbuf_0_clk_regs/X vddd vssd sg13cmos5l_buf_8
XFILLER_32_1699 vddd vssd sg13cmos5l_decap_8
XFILLER_8_2070 vddd vssd sg13cmos5l_decap_8
XFILLER_18_7 vddd vssd sg13cmos5l_decap_8
XFILLER_4_1233 vddd vssd sg13cmos5l_decap_8
XFILLER_8_1391 vddd vssd sg13cmos5l_decap_8
XFILLER_4_1266 vddd vssd sg13cmos5l_decap_8
Xoutbuffers\[100\] dbus_out[3] _5395_/Y vddd vssd sg13cmos5l_buf_16
Xclkbuf_leaf_20_SCK_regs _7276_/CLK clkload6/A vddd vssd sg13cmos5l_buf_8
XFILLER_15_2521 vddd vssd sg13cmos5l_decap_8
X_4740_ _4740_/Y _7337_/Q _4740_/B vddd vssd sg13cmos5l_xnor2_1
X_4671_ _4671_/Y _4674_/B _4674_/C vddd vssd sg13cmos5l_nand2_1
X_3622_ _3622_/Y _3622_/A vddd vssd sg13cmos5l_inv_1
XFILLER_15_2598 vddd vssd sg13cmos5l_decap_8
X_7390_ _7390_/Q _7390_/CLK _7390_/D _6821_/Y vddd vssd sg13cmos5l_dfrbpq_1
X_6410_ _6416_/S _6410_/A _6753_/B vddd vssd sg13cmos5l_nand2_1
X_6341_ _7117_/D hold786/X _6344_/B _6340_/Y vddd vssd sg13cmos5l_o21ai_1
X_3553_ _5413_/A _3553_/A vddd vssd sg13cmos5l_inv_1
X_3484_ _3484_/Y _4677_/B vddd vssd sg13cmos5l_inv_1
X_6272_ _6272_/Y _6272_/A _6272_/B vddd vssd sg13cmos5l_nand2_1
X_5223_ _5224_/B _5223_/A _5223_/B vddd vssd sg13cmos5l_nor2_1
XFILLER_29_1083 vddd vssd sg13cmos5l_decap_8
X_5154_ _5159_/A _7296_/Q _5233_/A _6123_/D vddd vssd sg13cmos5l_or3_1
Xoutbuffers\[58\] voltgen_value[2] _7056_/Q vddd vssd sg13cmos5l_buf_16
X_4105_ _4106_/B _7263_/Q _6609_/A vddd vssd sg13cmos5l_nor2_1
X_5085_ _5256_/A _7282_/Q _7283_/Q vddd vssd sg13cmos5l_nand2_1
XFILLER_22_2569 vddd vssd sg13cmos5l_decap_8
XFILLER_0_2310 vddd vssd sg13cmos5l_decap_8
X_4036_ _4036_/Y _5812_/C _6529_/A vddd vssd sg13cmos5l_nand2_1
XFILLER_0_2343 vddd vssd sg13cmos5l_decap_8
XFILLER_24_112 vddd vssd sg13cmos5l_decap_8
XFILLER_0_2387 vddd vssd sg13cmos5l_decap_8
XFILLER_0_1653 vddd vssd sg13cmos5l_decap_8
X_5987_ _5988_/C _7365_/Q _4339_/C vddd vssd sg13cmos5l_nor2b_1
XFILLER_16_2318 vddd vssd sg13cmos5l_decap_8
XFILLER_24_189 vddd vssd sg13cmos5l_decap_8
X_4938_ _7312_/D _4937_/A _4934_/B _4937_/Y vddd vssd sg13cmos5l_a21o_1
XFILLER_16_1606 vddd vssd sg13cmos5l_decap_4
XFILLER_16_1617 vddd vssd sg13cmos5l_decap_8
XFILLER_21_874 vddd vssd sg13cmos5l_decap_8
XANTENNA_30 _3755_/A vddd vssd sg13cmos5l_antennanp
X_4869_ _4869_/Y _4832_/Y _4868_/Y hold802/X vddd vssd sg13cmos5l_o21ai_1
XANTENNA_41 _6777_/A vddd vssd sg13cmos5l_antennanp
XFILLER_21_896 vddd vssd sg13cmos5l_decap_8
XANTENNA_52 _6344_/A vddd vssd sg13cmos5l_antennanp
X_6608_ _6608_/X hold970/X _6336_/A _6608_/S vddd vssd sg13cmos5l_mux2_1
XFILLER_14_2097 vddd vssd sg13cmos5l_decap_8
XFILLER_10_1216 vddd vssd sg13cmos5l_decap_4
XFILLER_21_56 vddd vssd sg13cmos5l_decap_8
X_6539_ _6539_/Y _6539_/A _6543_/B vddd vssd sg13cmos5l_nand2_1
XFILLER_27_2436 vddd vssd sg13cmos5l_decap_8
XFILLER_27_1724 vddd vssd sg13cmos5l_decap_8
XFILLER_7_2508 vddd vssd sg13cmos5l_decap_8
XFILLER_25_2171 vddd vssd sg13cmos5l_decap_8
XFILLER_21_2057 vddd vssd sg13cmos5l_decap_8
XFILLER_5_1531 vddd vssd sg13cmos5l_decap_8
XFILLER_28_473 vddd vssd sg13cmos5l_decap_4
XFILLER_19_1252 vddd vssd sg13cmos5l_decap_8
XFILLER_15_1149 vddd vssd sg13cmos5l_decap_8
XFILLER_7_58 vddd vssd sg13cmos5l_decap_8
XFILLER_10_2484 vddd vssd sg13cmos5l_decap_8
XFILLER_10_1794 vddd vssd sg13cmos5l_decap_8
XFILLER_6_2029 vddd vssd sg13cmos5l_decap_8
XFILLER_21_2591 vddd vssd sg13cmos5l_decap_8
X_5910_ _5910_/Y _7096_/Q _5927_/A vddd vssd sg13cmos5l_nor2_1
XFILLER_4_1074 vddd vssd sg13cmos5l_decap_8
XFILLER_19_495 vddd vssd sg13cmos5l_decap_4
X_6890_ _6890_/Y _6916_/A _6915_/B_N vddd vssd sg13cmos5l_nor2b_1
X_5841_ _5843_/B _5841_/A _5848_/B _5842_/B vddd vssd sg13cmos5l_nand3_1
XFILLER_21_126 vddd vssd sg13cmos5l_decap_4
XFILLER_15_690 vddd vssd sg13cmos5l_decap_8
X_5772_ _5773_/B _5772_/A _5772_/B vddd vssd sg13cmos5l_nor2_1
X_4723_ _4725_/B _4745_/A1 _4722_/Y _4720_/Y vddd vssd sg13cmos5l_o21ai_1
X_4654_ _4654_/Y _4651_/Y _4652_/Y _4653_/Y _4460_/B _4650_/Y vddd vssd sg13cmos5l_a221oi_1
XFILLER_11_1503 vddd vssd sg13cmos5l_decap_8
X_4585_ _4586_/B _6811_/A _7015_/D vddd vssd sg13cmos5l_xor2_1
X_3605_ _3605_/Y _3605_/A vddd vssd sg13cmos5l_inv_1
Xhold801 _4867_/B _7324_/Q vddd vssd sg13cmos5l_dlygate4sd3_1
X_7373_ _7373_/Q _7380_/CLK _7373_/D _6887_/Y vddd vssd sg13cmos5l_dfrbpq_1
Xhold812 _4963_/A hold812/A vddd vssd sg13cmos5l_dlygate4sd3_1
X_3536_ _5294_/A _7146_/Q vddd vssd sg13cmos5l_inv_1
Xhold834 _7133_/D _6370_/X vddd vssd sg13cmos5l_dlygate4sd3_1
Xhold823 _6666_/A _7298_/Q vddd vssd sg13cmos5l_dlygate4sd3_1
X_6324_ _7109_/D _6324_/A1 _6327_/B _6323_/Y vddd vssd sg13cmos5l_o21ai_1
Xhold845 _4905_/A hold845/A vddd vssd sg13cmos5l_dlygate4sd3_1
X_6255_ _6255_/Y _6276_/A _5252_/B _6278_/A1 vddd vssd sg13cmos5l_o21ai_1
Xhold878 _3597_/A _7108_/Q vddd vssd sg13cmos5l_dlygate4sd3_1
Xhold889 _7094_/D _6802_/Y vddd vssd sg13cmos5l_dlygate4sd3_1
Xhold867 _7358_/D _4358_/Y vddd vssd sg13cmos5l_dlygate4sd3_1
Xhold856 hold856/X _6507_/Y vddd vssd sg13cmos5l_dlygate4sd3_1
X_3467_ _4458_/B _7083_/Q vddd vssd sg13cmos5l_inv_1
X_5206_ _5241_/B _7260_/Q _7261_/Q vddd vssd sg13cmos5l_nor2b_1
Xhold1501 _4336_/A _7364_/Q vddd vssd sg13cmos5l_dlygate4sd3_1
X_6186_ _6186_/Y _7298_/Q _6186_/B _6186_/C vddd vssd sg13cmos5l_nor3_1
XFILLER_6_2585 vddd vssd sg13cmos5l_decap_8
Xhold1512 hold1512/X _7311_/Q vddd vssd sg13cmos5l_dlygate4sd3_1
X_5137_ _5148_/A _5222_/A _5176_/B vddd vssd sg13cmos5l_nor2_1
XFILLER_29_259 vddd vssd sg13cmos5l_decap_8
XFILLER_26_1790 vddd vssd sg13cmos5l_decap_8
X_5068_ _5072_/B _5068_/A _5068_/B _5068_/C _5068_/D vddd vssd sg13cmos5l_nand4_1
XFILLER_22_1676 vddd vssd sg13cmos5l_decap_8
X_4019_ _4019_/Y _7256_/Q _4019_/B vddd vssd sg13cmos5l_nand2b_1
XFILLER_16_56 vddd vssd sg13cmos5l_decap_8
XFILLER_21_682 vddd vssd sg13cmos5l_decap_8
XFILLER_32_77 vddd vssd sg13cmos5l_decap_8
XFILLER_4_325 vddd vssd sg13cmos5l_decap_8
XFILLER_10_1024 vddd vssd sg13cmos5l_decap_8
XFILLER_4_369 vddd vssd sg13cmos5l_decap_4
XFILLER_0_553 vddd vssd sg13cmos5l_decap_4
XFILLER_7_1604 vddd vssd sg13cmos5l_decap_8
XFILLER_27_1598 vddd vssd sg13cmos5l_decap_8
XFILLER_17_911 vddd vssd sg13cmos5l_decap_8
XFILLER_17_944 vddd vssd sg13cmos5l_decap_8
XFILLER_32_969 vddd vssd sg13cmos5l_decap_8
XFILLER_16_1992 vddd vssd sg13cmos5l_decap_8
XFILLER_8_664 vddd vssd sg13cmos5l_decap_8
XFILLER_12_2535 vddd vssd sg13cmos5l_decap_8
XFILLER_32_1282 vddd vssd sg13cmos5l_decap_8
X_4370_ _4370_/Y _4404_/A _3531_/Y _4369_/Y vddd vssd sg13cmos5l_o21ai_1
X_6040_ _6040_/Y _6036_/Y _6038_/X _6039_/Y vddd vssd sg13cmos5l_o21ai_1
XFILLER_6_1103 vddd vssd sg13cmos5l_decap_8
X_6942_ _6942_/Y _6962_/A _6962_/B_N vddd vssd sg13cmos5l_nor2b_1
XFILLER_1_2482 vddd vssd sg13cmos5l_decap_8
X_6873_ _6873_/Y _6917_/A _6874_/B_N vddd vssd sg13cmos5l_nor2b_1
X_5824_ _5842_/A _7222_/Q _7223_/Q vddd vssd sg13cmos5l_nor2_1
XFILLER_17_2457 vddd vssd sg13cmos5l_decap_8
XFILLER_30_2602 vddd vssd sg13cmos5l_decap_4
XFILLER_17_1756 vddd vssd sg13cmos5l_decap_8
X_5755_ _5756_/C _5764_/B _5758_/B _5743_/Y vddd vssd sg13cmos5l_a21oi_1
X_5686_ _5686_/Y _5705_/C _5699_/C vddd vssd sg13cmos5l_nor2_1
XFILLER_15_2192 vddd vssd sg13cmos5l_decap_4
X_4706_ _4706_/Y _4647_/B _4705_/Y _4590_/A vddd vssd sg13cmos5l_a21oi_1
XFILLER_30_1945 vddd vssd sg13cmos5l_decap_4
X_4637_ _4637_/Y _4684_/A _4635_/Y _4685_/A vddd vssd sg13cmos5l_a21oi_1
XFILLER_11_2078 vddd vssd sg13cmos5l_decap_8
Xhold620 _4312_/B _4299_/Y vddd vssd sg13cmos5l_dlygate4sd3_1
XFILLER_28_2531 vddd vssd sg13cmos5l_decap_8
X_4568_ _4570_/A _4546_/A _4566_/Y _4567_/Y vddd vssd sg13cmos5l_o21ai_1
Xhold653 hold653/X _4291_/Y vddd vssd sg13cmos5l_dlygate4sd3_1
Xhold631 _4421_/A _7349_/Q vddd vssd sg13cmos5l_dlygate4sd3_1
Xhold642 hold642/X _6357_/Y vddd vssd sg13cmos5l_dlygate4sd3_1
X_7356_ _7356_/Q _7357_/CLK _7356_/D _6870_/Y vddd vssd sg13cmos5l_dfrbpq_1
X_7287_ _7287_/Q _7289_/CLK _7287_/D fanout379/X vddd vssd sg13cmos5l_dfrbpq_1
X_4499_ _4499_/Y _4553_/A _4495_/Y _4498_/Y vddd vssd sg13cmos5l_a21oi_1
X_6307_ _6307_/X hold876/X _6732_/A _6308_/S vddd vssd sg13cmos5l_mux2_1
Xhold686 _7268_/D _6619_/X vddd vssd sg13cmos5l_dlygate4sd3_1
Xhold697 _4416_/A _7351_/Q vddd vssd sg13cmos5l_dlygate4sd3_1
Xhold664 _4297_/A _7375_/Q vddd vssd sg13cmos5l_dlygate4sd3_1
Xhold675 _7333_/D _4811_/Y vddd vssd sg13cmos5l_dlygate4sd3_1
X_3519_ _5133_/A _3519_/A vddd vssd sg13cmos5l_inv_1
XFILLER_24_2439 vddd vssd sg13cmos5l_decap_8
X_6238_ _6238_/Y _6238_/A1 _6209_/Y _6237_/Y vddd vssd sg13cmos5l_a21oi_1
X_6169_ _6169_/Y _7314_/Q _3522_/Y _6278_/A1 vddd vssd sg13cmos5l_o21ai_1
Xhold1342 _6482_/A1 _5606_/B vddd vssd sg13cmos5l_dlygate4sd3_1
Xhold1331 _6528_/A1 _5794_/B vddd vssd sg13cmos5l_dlygate4sd3_1
Xhold1320 _6663_/A0 _7296_/Q vddd vssd sg13cmos5l_dlygate4sd3_1
Xhold1364 _7336_/D _4752_/Y vddd vssd sg13cmos5l_dlygate4sd3_1
Xhold1353 _3765_/A SDO vddd vssd sg13cmos5l_dlygate4sd3_1
Xhold1375 _4709_/B1 _4687_/Y vddd vssd sg13cmos5l_dlygate4sd3_1
Xhold1386 _7319_/D _6682_/X vddd vssd sg13cmos5l_dlygate4sd3_1
XFILLER_27_77 vddd vssd sg13cmos5l_decap_8
Xhold1397 _6471_/A1 _5569_/B vddd vssd sg13cmos5l_dlygate4sd3_1
XFILLER_25_273 vddd vssd sg13cmos5l_decap_8
XFILLER_16_1244 vddd vssd sg13cmos5l_decap_8
Xtiedowns\[57\] mask_rev_in[13] vddd vssd sg13cmos5l_antennanp
XFILLER_4_37 vddd vssd sg13cmos5l_decap_8
XFILLER_27_2063 vddd vssd sg13cmos5l_decap_8
XFILLER_1_1066 vddd vssd sg13cmos5l_decap_4
XFILLER_32_766 vddd vssd sg13cmos5l_decap_8
X_3870_ _6609_/A _3889_/A _3962_/A vddd vssd sg13cmos5l_nand2_1
XFILLER_14_1907 vddd vssd sg13cmos5l_decap_8
X_5540_ _5557_/C _7182_/Q _7183_/Q vddd vssd sg13cmos5l_nand2b_1
XFILLER_12_490 vddd vssd sg13cmos5l_decap_4
X_5471_ _5471_/Y _7172_/Q _5472_/B _5471_/C vddd vssd sg13cmos5l_nor3_1
X_7210_ _7210_/Q _7210_/CLK _7210_/D fanout362/X vddd vssd sg13cmos5l_dfrbpq_1
X_4422_ _4422_/Y _5926_/A _4421_/A _4421_/Y vddd vssd sg13cmos5l_a21oi_1
XFILLER_12_1653 vddd vssd sg13cmos5l_decap_4
XFILLER_12_1686 vddd vssd sg13cmos5l_decap_8
X_7141_ _7141_/Q _7363_/CLK _7141_/D fanout352/X vddd vssd sg13cmos5l_dfrbpq_1
X_4353_ _4354_/B _4353_/A _4355_/B vddd vssd sg13cmos5l_nand2_1
Xfanout407 _6923_/B_N fanout408/X vddd vssd sg13cmos5l_buf_1
X_7072_ _7072_/Q _7146_/CLK _7072_/D fanout351/X vddd vssd sg13cmos5l_dfrbpq_1
Xfanout418 _5779_/A1 _5888_/A vddd vssd sg13cmos5l_buf_1
X_4284_ _4284_/Y _4965_/B _4284_/B vddd vssd sg13cmos5l_nand2_1
Xfanout429 _5971_/A1 io_in[4] vddd vssd sg13cmos5l_buf_1
X_6023_ _6023_/Y _3822_/Y _5042_/B _6021_/Y _6022_/Y _5042_/A vddd vssd sg13cmos5l_a221oi_1
Xoutbuffers\[40\] bandgap_trim[1] _6284_/Y vddd vssd sg13cmos5l_buf_16
XFILLER_23_2461 vddd vssd sg13cmos5l_decap_8
X_6925_ _6925_/Y _6948_/A _6969_/B_N vddd vssd sg13cmos5l_nor2b_1
XFILLER_17_2221 vddd vssd sg13cmos5l_decap_8
X_6856_ _6856_/Y _6959_/A _6958_/B_N vddd vssd sg13cmos5l_nor2b_1
Xfanout36 _6372_/S _6371_/S vddd vssd sg13cmos5l_buf_1
XFILLER_23_766 vddd vssd sg13cmos5l_decap_8
Xfanout25 _4732_/B _4491_/Y vddd vssd sg13cmos5l_buf_1
Xfanout47 _4144_/B _6417_/A vddd vssd sg13cmos5l_buf_1
Xfanout69 _6746_/A _3826_/Y vddd vssd sg13cmos5l_buf_1
XFILLER_17_1553 vddd vssd sg13cmos5l_decap_8
XFILLER_13_2129 vddd vssd sg13cmos5l_decap_8
Xfanout58 _4745_/A1 _4528_/A vddd vssd sg13cmos5l_buf_1
X_3999_ _4000_/B _3683_/A wire96/X _3748_/Y mask_rev_in[27] vddd vssd sg13cmos5l_a22oi_1
XFILLER_11_939 vddd vssd sg13cmos5l_decap_8
X_6787_ _7086_/D _6787_/A0 _6727_/A _6788_/S vddd vssd sg13cmos5l_mux2_1
X_5807_ _5807_/Y _5807_/A1 _5813_/C _5805_/Y _5812_/C _5806_/Y vddd vssd sg13cmos5l_a221oi_1
X_5738_ _5758_/A _7210_/Q _7211_/Q vddd vssd sg13cmos5l_nor2_1
XFILLER_10_427 vddd vssd sg13cmos5l_decap_4
XFILLER_13_35 vddd vssd sg13cmos5l_decap_8
XFILLER_30_2476 vddd vssd sg13cmos5l_decap_8
X_5669_ _5669_/Y _5669_/A _5669_/B _5669_/C vddd vssd sg13cmos5l_nor3_1
X_7339_ _7339_/Q _7342_/CLK _7339_/D _6853_/Y vddd vssd sg13cmos5l_dfrbpq_1
Xhold483 sram_addr[8] _5989_/X vddd vssd sg13cmos5l_dlygate4sd3_1
Xhold494 _4940_/A hold494/A vddd vssd sg13cmos5l_dlygate4sd3_1
XFILLER_24_1502 vddd vssd sg13cmos5l_decap_8
XFILLER_8_1721 vddd vssd sg13cmos5l_decap_4
XFILLER_8_2466 vddd vssd sg13cmos5l_decap_8
XFILLER_8_1765 vddd vssd sg13cmos5l_decap_4
XFILLER_24_1568 vddd vssd sg13cmos5l_decap_8
Xhold1150 _6430_/A1 _7165_/Q vddd vssd sg13cmos5l_dlygate4sd3_1
Xhold1194 _6630_/A0 _7275_/Q vddd vssd sg13cmos5l_dlygate4sd3_1
Xhold1161 _3548_/A _7153_/Q vddd vssd sg13cmos5l_dlygate4sd3_1
Xhold1172 _6614_/A0 _7265_/Q vddd vssd sg13cmos5l_dlygate4sd3_1
Xhold1183 _7239_/D _6572_/Y vddd vssd sg13cmos5l_dlygate4sd3_1
XFILLER_2_1386 vddd vssd sg13cmos5l_decap_8
XFILLER_13_221 vddd vssd sg13cmos5l_decap_8
XFILLER_13_276 vddd vssd sg13cmos5l_decap_8
XFILLER_14_799 vddd vssd sg13cmos5l_decap_8
XFILLER_16_1074 vddd vssd sg13cmos5l_decap_8
XFILLER_10_983 vddd vssd sg13cmos5l_decap_8
XFILLER_29_2136 vddd vssd sg13cmos5l_decap_8
XFILLER_20_1922 vddd vssd sg13cmos5l_decap_8
XFILLER_20_1955 vddd vssd sg13cmos5l_decap_4
X_4971_ _4971_/Y _4971_/A _4971_/B vddd vssd sg13cmos5l_xnor2_1
XFILLER_20_1988 vddd vssd sg13cmos5l_decap_8
X_6710_ _6710_/X _6710_/A0 _6803_/A _6710_/S vddd vssd sg13cmos5l_mux2_1
XFILLER_18_2563 vddd vssd sg13cmos5l_decap_8
X_3922_ _3922_/Y _3925_/A _3922_/B vddd vssd sg13cmos5l_nand2_1
X_6641_ _6641_/Y _6641_/A _6645_/S vddd vssd sg13cmos5l_nor2_1
X_3853_ _3853_/Y _3626_/Y _4172_/B1 _3851_/Y _3852_/Y vddd vssd sg13cmos5l_a22oi_1
XFILLER_20_758 vddd vssd sg13cmos5l_decap_8
XFILLER_14_2449 vddd vssd sg13cmos5l_decap_8
XFILLER_14_1748 vddd vssd sg13cmos5l_decap_8
XFILLER_14_1737 vddd vssd sg13cmos5l_decap_4
X_3784_ _3784_/Y _3679_/Y _3782_/Y _3783_/Y vddd vssd sg13cmos5l_a21oi_1
XFILLER_9_781 vddd vssd sg13cmos5l_decap_8
X_6572_ _6572_/Y _6572_/A1 _6574_/B _6571_/Y vddd vssd sg13cmos5l_a21oi_1
XFILLER_12_2151 vddd vssd sg13cmos5l_decap_8
XFILLER_30_1038 vddd vssd sg13cmos5l_decap_8
X_5523_ _5524_/C _5523_/A _5523_/B vddd vssd sg13cmos5l_nand2_1
XFILLER_12_2173 vddd vssd sg13cmos5l_decap_4
X_5454_ _5467_/A _5465_/B _5454_/B vddd vssd sg13cmos5l_nor2_1
Xoutbuffers\[88\] io_out[3] _6079_/Y vddd vssd sg13cmos5l_buf_16
X_5385_ _5388_/A _5326_/A _5383_/B _5382_/Y _5383_/Y _5387_/B vddd vssd sg13cmos5l_a221oi_1
X_4405_ _4405_/Y _4405_/A _4409_/A vddd vssd sg13cmos5l_xnor2_1
XFILLER_5_91 vddd vssd sg13cmos5l_decap_8
Xfanout204 _6668_/A fanout208/X vddd vssd sg13cmos5l_buf_1
X_7124_ _7124_/Q _7268_/CLK _7124_/D fanout389/X vddd vssd sg13cmos5l_dfrbpq_1
X_4336_ _4338_/A _4336_/A _4355_/B vddd vssd sg13cmos5l_nand2_1
XFILLER_25_2545 vddd vssd sg13cmos5l_decap_8
XFILLER_25_1800 vddd vssd sg13cmos5l_decap_8
Xfanout237 _5623_/A _4582_/A vddd vssd sg13cmos5l_buf_1
Xfanout226 _6954_/A _7370_/Q vddd vssd sg13cmos5l_buf_1
Xfanout215 _6959_/A _6954_/A vddd vssd sg13cmos5l_buf_1
X_7055_ _7055_/Q _7289_/CLK _7055_/D fanout378/X vddd vssd sg13cmos5l_dfrbpq_1
X_4267_ _4267_/Y _4267_/A _4267_/B _4267_/C vddd vssd sg13cmos5l_nand3_1
Xfanout248 _5315_/A _4820_/B vddd vssd sg13cmos5l_buf_1
Xfanout259 _5926_/A _6979_/D vddd vssd sg13cmos5l_buf_1
X_4198_ _4198_/X _7254_/Q _4019_/B _3894_/B vddd vssd sg13cmos5l_a21o_1
X_6006_ _6006_/Y _6004_/Y _6006_/B vddd vssd sg13cmos5l_nand2b_1
XFILLER_3_1651 vddd vssd sg13cmos5l_decap_8
XFILLER_27_379 vddd vssd sg13cmos5l_decap_4
XFILLER_19_1637 vddd vssd sg13cmos5l_decap_8
XFILLER_32_2516 vddd vssd sg13cmos5l_decap_8
XFILLER_24_56 vddd vssd sg13cmos5l_decap_8
X_6839_ _6839_/Y _6840_/A _6840_/B_N vddd vssd sg13cmos5l_nor2b_1
XFILLER_32_1859 vddd vssd sg13cmos5l_decap_8
XFILLER_13_1247 vddd vssd sg13cmos5l_decap_8
XFILLER_3_935 vddd vssd sg13cmos5l_decap_8
XFILLER_2_434 vddd vssd sg13cmos5l_decap_4
XFILLER_24_2011 vddd vssd sg13cmos5l_decap_8
XFILLER_8_2241 vddd vssd sg13cmos5l_decap_8
XFILLER_24_1332 vddd vssd sg13cmos5l_decap_4
XFILLER_19_825 vddd vssd sg13cmos5l_decap_8
XFILLER_24_1376 vddd vssd sg13cmos5l_decap_8
XFILLER_20_1207 vddd vssd sg13cmos5l_decap_8
XFILLER_13_2471 vddd vssd sg13cmos5l_decap_8
XFILLER_6_773 vddd vssd sg13cmos5l_decap_8
XFILLER_29_1254 vddd vssd sg13cmos5l_decap_8
X_5170_ _5184_/A _5257_/A _5170_/B vddd vssd sg13cmos5l_or2_1
X_4121_ _4121_/Y _5901_/B _6554_/A _6545_/A vddd vssd sg13cmos5l_a21oi_1
X_4052_ _4052_/Y _5442_/A _6431_/A _6424_/A vddd vssd sg13cmos5l_a21oi_1
XFILLER_0_2503 vddd vssd sg13cmos5l_decap_8
XFILLER_25_806 vddd vssd sg13cmos5l_decap_8
XFILLER_20_2486 vddd vssd sg13cmos5l_decap_8
XFILLER_20_1730 vddd vssd sg13cmos5l_decap_8
XFILLER_20_1763 vddd vssd sg13cmos5l_decap_8
X_4954_ _4954_/Y _4955_/A _4954_/B vddd vssd sg13cmos5l_nand2_1
XFILLER_14_2202 vddd vssd sg13cmos5l_decap_8
X_3905_ _3905_/Y _3694_/Y _3901_/X _6170_/A _4115_/A _6568_/A vddd vssd sg13cmos5l_a221oi_1
X_4885_ _4885_/Y _4942_/A _7142_/Q _4883_/Y vddd vssd sg13cmos5l_o21ai_1
X_3836_ _3836_/Y _6762_/B _3946_/A vddd vssd sg13cmos5l_nor2_1
X_6624_ _6624_/X _6624_/A0 _6788_/A1 _6626_/S vddd vssd sg13cmos5l_mux2_1
XFILLER_14_1523 vddd vssd sg13cmos5l_decap_8
X_3767_ wire75/A _3940_/A _3940_/B _6762_/B vddd vssd sg13cmos5l_nor3_1
XFILLER_14_1545 vddd vssd sg13cmos5l_decap_8
X_6555_ _6555_/Y _6555_/A _6560_/S vddd vssd sg13cmos5l_nand2_1
XFILLER_14_1589 vddd vssd sg13cmos5l_decap_8
XFILLER_10_1409 vddd vssd sg13cmos5l_decap_8
X_5506_ _5523_/A _7178_/Q _7179_/Q vddd vssd sg13cmos5l_nor2_1
X_6486_ _7195_/D _6532_/A _6486_/A1 _6489_/S vddd vssd sg13cmos5l_mux2_1
X_3698_ _3727_/B _3753_/A _3753_/B vddd vssd sg13cmos5l_nor2_1
X_5437_ _5437_/Y _5437_/A _5437_/B _5437_/C vddd vssd sg13cmos5l_nor3_1
XFILLER_10_58 vddd vssd sg13cmos5l_decap_8
X_5368_ _5369_/B _3539_/A _5372_/A _5374_/B vddd vssd sg13cmos5l_o21ai_1
XFILLER_0_938 vddd vssd sg13cmos5l_decap_4
XFILLER_25_2342 vddd vssd sg13cmos5l_decap_8
X_5299_ _5302_/B _5297_/X _5298_/X _5304_/A vddd vssd sg13cmos5l_a21oi_1
X_7107_ _7107_/Q _7264_/CLK _7107_/D fanout396/X vddd vssd sg13cmos5l_dfrbpq_1
X_4319_ _4357_/B _4319_/A _4342_/A vddd vssd sg13cmos5l_nor2b_1
X_7038_ _7038_/Q _7289_/CLK _7038_/D fanout374/X vddd vssd sg13cmos5l_dfrbpq_1
XFILLER_19_56 vddd vssd sg13cmos5l_decap_8
XFILLER_5_1713 vddd vssd sg13cmos5l_decap_8
XFILLER_27_110 vddd vssd sg13cmos5l_decap_8
XFILLER_21_1527 vddd vssd sg13cmos5l_decap_8
XFILLER_27_187 vddd vssd sg13cmos5l_decap_8
XFILLER_19_1478 vddd vssd sg13cmos5l_decap_8
XFILLER_30_1391 vddd vssd sg13cmos5l_decap_8
XFILLER_4_0 vddd vssd sg13cmos5l_decap_8
XFILLER_18_154 vddd vssd sg13cmos5l_decap_4
XFILLER_15_2500 vddd vssd sg13cmos5l_decap_8
XFILLER_15_872 vddd vssd sg13cmos5l_decap_8
XFILLER_15_2577 vddd vssd sg13cmos5l_decap_8
X_4670_ _4674_/C _4468_/B _4670_/B vddd vssd sg13cmos5l_nand2b_1
XFILLER_30_886 vddd vssd sg13cmos5l_decap_8
X_3621_ _6285_/B _3621_/A vddd vssd sg13cmos5l_inv_1
X_6340_ _6340_/Y _6661_/A _6344_/B vddd vssd sg13cmos5l_nand2_1
X_3552_ _5380_/B _3552_/A vddd vssd sg13cmos5l_inv_1
XFILLER_11_1718 vddd vssd sg13cmos5l_decap_4
X_3483_ _3483_/Y _4655_/B vddd vssd sg13cmos5l_inv_1
X_6271_ _6273_/B _6156_/A _5260_/D _6269_/Y _6270_/Y _6272_/B vddd vssd sg13cmos5l_a221oi_1
XFILLER_9_1112 vddd vssd sg13cmos5l_decap_4
X_5222_ _5233_/B _5222_/A _6185_/D vddd vssd sg13cmos5l_nor2_1
X_5153_ _6123_/D _5248_/A _5171_/B vddd vssd sg13cmos5l_nor2_1
X_4104_ _4104_/Y _4101_/Y _4102_/Y _4103_/Y vddd vssd sg13cmos5l_o21ai_1
XFILLER_22_2548 vddd vssd sg13cmos5l_decap_8
X_5084_ _5101_/C _7272_/Q _7273_/Q _5257_/A vddd vssd sg13cmos5l_nor3_1
X_4035_ _4035_/X _5837_/B _6538_/A _6529_/A vddd vssd sg13cmos5l_a21o_1
XFILLER_20_2272 vddd vssd sg13cmos5l_decap_8
XFILLER_0_2377 vddd vssd sg13cmos5l_decap_4
XFILLER_0_1632 vddd vssd sg13cmos5l_decap_8
XFILLER_24_168 vddd vssd sg13cmos5l_decap_8
X_5986_ _5986_/X _5986_/A0 _3662_/B _5991_/S vddd vssd sg13cmos5l_mux2_1
X_4937_ _4937_/Y _4937_/A _4937_/B _4949_/B vddd vssd sg13cmos5l_nor3_1
XANTENNA_20 _3758_/X vddd vssd sg13cmos5l_antennanp
X_4868_ _4868_/Y _4867_/A sram_odata[0] _4867_/Y vddd vssd sg13cmos5l_a21oi_1
XANTENNA_31 _3755_/A vddd vssd sg13cmos5l_antennanp
XANTENNA_53 _6344_/A vddd vssd sg13cmos5l_antennanp
X_3819_ _6687_/A _4010_/B _4010_/C _6395_/A vddd vssd sg13cmos5l_nor3_1
X_6607_ _6607_/X _6607_/A0 _6773_/A _6608_/S vddd vssd sg13cmos5l_mux2_1
XANTENNA_42 fanout208/X vddd vssd sg13cmos5l_antennanp
XFILLER_21_35 vddd vssd sg13cmos5l_decap_8
X_4799_ _4799_/Y _4507_/A _4789_/B _4806_/B _4460_/A _4797_/Y vddd vssd sg13cmos5l_a221oi_1
X_6538_ _6543_/B _6538_/A _6545_/B vddd vssd sg13cmos5l_nand2_1
XFILLER_27_2415 vddd vssd sg13cmos5l_decap_8
X_6469_ _6469_/Y _6469_/A _6474_/S vddd vssd sg13cmos5l_nand2_1
XFILLER_21_2014 vddd vssd sg13cmos5l_decap_8
XFILLER_29_920 vddd vssd sg13cmos5l_decap_8
XFILLER_21_1302 vddd vssd sg13cmos5l_decap_8
XFILLER_29_964 vddd vssd sg13cmos5l_decap_8
XFILLER_5_1554 vddd vssd sg13cmos5l_decap_8
XFILLER_12_820 vddd vssd sg13cmos5l_decap_4
XFILLER_32_2143 vddd vssd sg13cmos5l_decap_4
XFILLER_30_149 vddd vssd sg13cmos5l_decap_8
XFILLER_15_1128 vddd vssd sg13cmos5l_decap_8
XFILLER_7_37 vddd vssd sg13cmos5l_decap_8
XFILLER_12_897 vddd vssd sg13cmos5l_decap_8
XFILLER_32_1464 vddd vssd sg13cmos5l_decap_8
XFILLER_10_2463 vddd vssd sg13cmos5l_decap_8
XFILLER_30_7 vddd vssd sg13cmos5l_decap_4
XFILLER_6_2008 vddd vssd sg13cmos5l_decap_8
XFILLER_26_1279 vddd vssd sg13cmos5l_decap_8
XFILLER_21_2570 vddd vssd sg13cmos5l_decap_8
X_5840_ _5843_/A _5837_/B _5828_/Y _5839_/Y vddd vssd sg13cmos5l_o21ai_1
XFILLER_21_105 vddd vssd sg13cmos5l_decap_8
XFILLER_15_680 vddd vssd sg13cmos5l_decap_4
X_5771_ _5772_/B _6212_/A1 _5794_/C _5791_/B vddd vssd sg13cmos5l_o21ai_1
X_4722_ _4722_/Y _4762_/B _3598_/Y _4721_/Y vddd vssd sg13cmos5l_a21oi_1
X_4653_ _4653_/Y _4653_/A _4653_/B vddd vssd sg13cmos5l_xnor2_1
XFILLER_15_1662 vddd vssd sg13cmos5l_decap_8
X_3604_ _3863_/A _3604_/A vddd vssd sg13cmos5l_inv_1
X_4584_ _4584_/Y _4460_/B _4582_/Y _4583_/X _4507_/X _4581_/Y vddd vssd sg13cmos5l_a221oi_1
Xhold802 hold802/X _4866_/Y vddd vssd sg13cmos5l_dlygate4sd3_1
X_7372_ _7372_/Q _7375_/CLK _7372_/D _6886_/Y vddd vssd sg13cmos5l_dfrbpq_1
X_3535_ _4010_/A _3535_/A vddd vssd sg13cmos5l_inv_1
Xhold835 _3603_/A _7114_/Q vddd vssd sg13cmos5l_dlygate4sd3_1
Xhold824 hold824/X _6666_/Y vddd vssd sg13cmos5l_dlygate4sd3_1
Xhold813 hold813/X _4310_/Y vddd vssd sg13cmos5l_dlygate4sd3_1
X_6323_ _6323_/Y _6661_/A _6327_/B vddd vssd sg13cmos5l_nand2_1
Xhold846 _5275_/A _5274_/Y vddd vssd sg13cmos5l_dlygate4sd3_1
Xoutbuffers\[70\] idac1_value[2] _7042_/Q vddd vssd sg13cmos5l_buf_16
Xhold857 hold857/X _7185_/Q vddd vssd sg13cmos5l_dlygate4sd3_1
X_6254_ _6254_/Y _6049_/A _5251_/D _6253_/Y vddd vssd sg13cmos5l_a21oi_1
X_3466_ _4458_/A _4812_/B vddd vssd sg13cmos5l_inv_1
Xhold879 hold879/X _3597_/Y vddd vssd sg13cmos5l_dlygate4sd3_1
Xhold868 hold868/X _7240_/Q vddd vssd sg13cmos5l_dlygate4sd3_1
X_5205_ _6185_/D _7244_/Q _7245_/Q vddd vssd sg13cmos5l_nand2b_1
X_6185_ _6186_/C _7242_/Q _7243_/Q _6185_/C _6185_/D vddd vssd sg13cmos5l_nor4_1
Xhold1513 hold1513/X _7340_/Q vddd vssd sg13cmos5l_dlygate4sd3_1
Xhold1502 _3660_/A1 _7364_/Q vddd vssd sg13cmos5l_dlygate4sd3_1
X_5136_ _5151_/C _5136_/A _5178_/B vddd vssd sg13cmos5l_nor2b_1
XFILLER_6_2564 vddd vssd sg13cmos5l_decap_8
XFILLER_29_238 vddd vssd sg13cmos5l_decap_8
XFILLER_22_1644 vddd vssd sg13cmos5l_decap_8
X_5067_ _5068_/D _5233_/A _6041_/S _6039_/B _5067_/D vddd vssd sg13cmos5l_nor4_1
X_4018_ _4018_/Y _4015_/Y _4016_/Y _4017_/Y vddd vssd sg13cmos5l_o21ai_1
XFILLER_16_35 vddd vssd sg13cmos5l_decap_8
XFILLER_0_2196 vddd vssd sg13cmos5l_decap_8
XFILLER_0_1473 vddd vssd sg13cmos5l_decap_4
XFILLER_0_1440 vddd vssd sg13cmos5l_decap_4
X_5969_ _5969_/Y _5969_/A _5969_/B _5969_/C vddd vssd sg13cmos5l_nand3_1
XFILLER_12_138 vddd vssd sg13cmos5l_decap_8
XFILLER_32_56 vddd vssd sg13cmos5l_decap_8
XFILLER_21_661 vddd vssd sg13cmos5l_decap_8
XFILLER_5_838 vddd vssd sg13cmos5l_decap_8
XFILLER_10_1014 vddd vssd sg13cmos5l_decap_4
XFILLER_29_1809 vddd vssd sg13cmos5l_decap_8
XFILLER_0_532 vddd vssd sg13cmos5l_decap_8
XFILLER_27_1577 vddd vssd sg13cmos5l_decap_4
XFILLER_5_2030 vddd vssd sg13cmos5l_decap_8
XFILLER_5_2063 vddd vssd sg13cmos5l_decap_8
XFILLER_5_2085 vddd vssd sg13cmos5l_decap_8
XFILLER_16_400 vddd vssd sg13cmos5l_decap_8
XFILLER_1_1248 vddd vssd sg13cmos5l_decap_8
XFILLER_32_948 vddd vssd sg13cmos5l_decap_8
XFILLER_16_499 vddd vssd sg13cmos5l_decap_4
XFILLER_8_621 vddd vssd sg13cmos5l_decap_8
XFILLER_12_650 vddd vssd sg13cmos5l_decap_8
XFILLER_12_2514 vddd vssd sg13cmos5l_decap_8
XFILLER_12_694 vddd vssd sg13cmos5l_decap_8
XFILLER_32_1261 vddd vssd sg13cmos5l_decap_8
XFILLER_11_193 vddd vssd sg13cmos5l_decap_8
XFILLER_26_1054 vddd vssd sg13cmos5l_decap_8
XFILLER_6_1148 vddd vssd sg13cmos5l_decap_8
XFILLER_23_1975 vddd vssd sg13cmos5l_decap_8
X_6941_ _6941_/Y _6961_/A _6962_/B_N vddd vssd sg13cmos5l_nor2b_1
X_6872_ _6872_/Y _6893_/A _6893_/B_N vddd vssd sg13cmos5l_nor2b_1
XFILLER_17_2436 vddd vssd sg13cmos5l_decap_8
X_5823_ _5823_/Y _6238_/A1 _5819_/X _5822_/Y _5818_/Y vddd vssd sg13cmos5l_a22oi_1
X_5754_ _5756_/B _5762_/C _5754_/B vddd vssd sg13cmos5l_nand2b_1
X_5685_ _5699_/C _7204_/Q _5685_/B vddd vssd sg13cmos5l_nand2_1
XFILLER_15_2171 vddd vssd sg13cmos5l_decap_8
X_4705_ _4705_/Y _4745_/A1 _4699_/Y _4704_/X vddd vssd sg13cmos5l_o21ai_1
X_4636_ _4636_/Y _4771_/A1 _3602_/Y _4771_/B1 _4633_/B vddd vssd sg13cmos5l_a22oi_1
XFILLER_8_91 vddd vssd sg13cmos5l_decap_8
XFILLER_11_2057 vddd vssd sg13cmos5l_decap_8
Xhold621 _7374_/D _4302_/Y vddd vssd sg13cmos5l_dlygate4sd3_1
Xhold610 _4852_/A _7327_/Q vddd vssd sg13cmos5l_dlygate4sd3_1
X_7355_ _7355_/Q _7355_/CLK _7355_/D _6869_/Y vddd vssd sg13cmos5l_dfrbpq_1
XFILLER_28_2510 vddd vssd sg13cmos5l_decap_8
X_4567_ _4567_/Y _4546_/A _4565_/Y _4547_/A vddd vssd sg13cmos5l_a21oi_1
X_6306_ _6306_/X hold863/X _6796_/A _6308_/S vddd vssd sg13cmos5l_mux2_1
Xhold654 _7376_/D _4292_/Y vddd vssd sg13cmos5l_dlygate4sd3_1
Xhold632 _7349_/D _4422_/Y vddd vssd sg13cmos5l_dlygate4sd3_1
Xhold643 _6359_/A _7126_/Q vddd vssd sg13cmos5l_dlygate4sd3_1
X_7286_ _7286_/Q _7286_/CLK _7286_/D fanout379/X vddd vssd sg13cmos5l_dfrbpq_1
X_3518_ _5211_/A _3518_/A vddd vssd sg13cmos5l_inv_1
X_4498_ _4498_/Y _4553_/A _4498_/B vddd vssd sg13cmos5l_nor2_1
Xhold676 _6384_/A _7141_/Q vddd vssd sg13cmos5l_dlygate4sd3_1
Xhold665 hold665/X _4297_/Y vddd vssd sg13cmos5l_dlygate4sd3_1
Xhold687 hold687/X _7269_/Q vddd vssd sg13cmos5l_dlygate4sd3_1
XFILLER_28_2587 vddd vssd sg13cmos5l_decap_8
XFILLER_24_2418 vddd vssd sg13cmos5l_decap_8
Xhold698 _4417_/C _4416_/Y vddd vssd sg13cmos5l_dlygate4sd3_1
X_6237_ _6237_/Y _5976_/A _6235_/Y _6236_/Y _6234_/Y _6209_/Y vddd vssd sg13cmos5l_a221oi_1
X_6168_ _6168_/Y _5623_/A _6207_/S _6167_/Y vddd vssd sg13cmos5l_o21ai_1
Xhold1332 _6716_/A0 _7043_/Q vddd vssd sg13cmos5l_dlygate4sd3_1
Xhold1343 _7193_/D _6482_/Y vddd vssd sg13cmos5l_dlygate4sd3_1
XFILLER_22_2153 vddd vssd sg13cmos5l_decap_8
Xhold1310 _7247_/D _6587_/Y vddd vssd sg13cmos5l_dlygate4sd3_1
X_5119_ _5175_/B _7261_/Q _7260_/Q vddd vssd sg13cmos5l_nor2b_1
Xhold1321 _7296_/D _6663_/X vddd vssd sg13cmos5l_dlygate4sd3_1
XFILLER_22_2186 vddd vssd sg13cmos5l_decap_8
Xhold1354 _3766_/B1 _3765_/Y vddd vssd sg13cmos5l_dlygate4sd3_1
Xhold1365 hold921/A _7371_/Q vddd vssd sg13cmos5l_dlygate4sd3_1
Xhold1376 _7338_/D _4709_/Y vddd vssd sg13cmos5l_dlygate4sd3_1
X_6099_ _6100_/B _6098_/Y _6099_/B vddd vssd sg13cmos5l_nand2b_1
XFILLER_27_56 vddd vssd sg13cmos5l_decap_8
XFILLER_22_1485 vddd vssd sg13cmos5l_decap_8
Xhold1398 hold1398/X _7176_/Q vddd vssd sg13cmos5l_dlygate4sd3_1
Xhold1387 hold1387/X _7155_/Q vddd vssd sg13cmos5l_dlygate4sd3_1
XFILLER_26_742 vddd vssd sg13cmos5l_decap_8
XFILLER_16_1223 vddd vssd sg13cmos5l_decap_8
XFILLER_16_1278 vddd vssd sg13cmos5l_decap_8
XFILLER_11_2591 vddd vssd sg13cmos5l_decap_8
XFILLER_4_16 vddd vssd sg13cmos5l_decap_8
XFILLER_7_2136 vddd vssd sg13cmos5l_decap_8
XFILLER_27_1352 vddd vssd sg13cmos5l_decap_8
XFILLER_1_885 vddd vssd sg13cmos5l_decap_4
XFILLER_29_580 vddd vssd sg13cmos5l_decap_8
XFILLER_5_1192 vddd vssd sg13cmos5l_decap_4
XFILLER_32_745 vddd vssd sg13cmos5l_decap_8
XFILLER_31_233 vddd vssd sg13cmos5l_decap_8
XFILLER_20_918 vddd vssd sg13cmos5l_decap_8
XFILLER_16_2491 vddd vssd sg13cmos5l_decap_8
X_5470_ _5470_/X _5789_/A _5470_/B vddd vssd sg13cmos5l_and2_1
XFILLER_12_2344 vddd vssd sg13cmos5l_decap_8
X_4421_ _4421_/Y _4421_/A _4421_/B vddd vssd sg13cmos5l_nor2_1
XFILLER_12_2388 vddd vssd sg13cmos5l_decap_4
XFILLER_12_1698 vddd vssd sg13cmos5l_decap_8
XFILLER_28_1105 vddd vssd sg13cmos5l_decap_8
X_7140_ _7140_/Q _7386_/CLK _7140_/D _6819_/B_N vddd vssd sg13cmos5l_dfrbpq_1
X_4352_ _4352_/Y _4355_/A _4352_/B vddd vssd sg13cmos5l_nand2_1
Xfanout408 fanout408/X fanout409/X vddd vssd sg13cmos5l_buf_1
X_7071_ _7071_/Q _7071_/CLK _7071_/D fanout346/X vddd vssd sg13cmos5l_dfrbpq_1
Xfanout419 _5888_/A io_in[7] vddd vssd sg13cmos5l_buf_1
X_4283_ _4283_/X _4965_/B _4963_/A _4283_/S vddd vssd sg13cmos5l_mux2_1
X_6022_ _6022_/Y _3797_/X _5042_/D _5042_/B vddd vssd sg13cmos5l_a21oi_1
XFILLER_23_2440 vddd vssd sg13cmos5l_decap_8
XFILLER_23_1750 vddd vssd sg13cmos5l_decap_8
Xoutbuffers\[33\] bandgap_sink1[1] _7063_/Q vddd vssd sg13cmos5l_buf_16
XFILLER_3_1866 vddd vssd sg13cmos5l_decap_8
X_6924_ _6924_/Y _6948_/A _6969_/B_N vddd vssd sg13cmos5l_nor2b_1
XFILLER_22_200 vddd vssd sg13cmos5l_decap_8
XFILLER_17_2200 vddd vssd sg13cmos5l_decap_8
X_6855_ _6855_/Y _6961_/A _6960_/B_N vddd vssd sg13cmos5l_nor2b_1
Xfanout26 _4832_/B _4830_/Y vddd vssd sg13cmos5l_buf_1
Xfanout37 _6361_/B _6346_/Y vddd vssd sg13cmos5l_buf_1
XFILLER_17_1532 vddd vssd sg13cmos5l_decap_4
XFILLER_13_2108 vddd vssd sg13cmos5l_decap_4
X_6786_ _6788_/S _6786_/A _6786_/B _6789_/B vddd vssd sg13cmos5l_nor3_1
X_3998_ _3998_/Y _3995_/Y _3996_/Y _3997_/Y vddd vssd sg13cmos5l_a21oi_1
Xfanout59 _4769_/A1 _4528_/A vddd vssd sg13cmos5l_buf_1
Xfanout48 _6438_/A _3955_/Y vddd vssd sg13cmos5l_buf_1
X_5806_ _5806_/Y _7218_/Q _5806_/B vddd vssd sg13cmos5l_nor2_1
XFILLER_13_14 vddd vssd sg13cmos5l_decap_8
X_5737_ _5737_/Y _5735_/Y _5736_/Y _5711_/Y vddd vssd sg13cmos5l_o21ai_1
XFILLER_17_1576 vddd vssd sg13cmos5l_decap_8
XFILLER_30_2455 vddd vssd sg13cmos5l_decap_8
X_5668_ _5669_/C _5666_/Y _5667_/X _5674_/C vddd vssd sg13cmos5l_a21oi_1
X_5599_ _5599_/Y _7343_/Q _5606_/B vddd vssd sg13cmos5l_nor2_1
X_4619_ _4619_/Y _4619_/A _4630_/B vddd vssd sg13cmos5l_nand2_1
XFILLER_28_2340 vddd vssd sg13cmos5l_decap_4
X_7338_ _7338_/Q _7338_/CLK _7338_/D _6852_/Y vddd vssd sg13cmos5l_dfrbpq_1
XFILLER_8_7 vddd vssd sg13cmos5l_decap_8
XFILLER_28_2384 vddd vssd sg13cmos5l_decap_8
Xhold484 _4952_/A hold906/X vddd vssd sg13cmos5l_dlygate4sd3_1
Xhold495 sram_addr[7] _5986_/X vddd vssd sg13cmos5l_dlygate4sd3_1
XFILLER_1_126 vddd vssd sg13cmos5l_decap_8
XFILLER_8_1700 vddd vssd sg13cmos5l_decap_8
XFILLER_8_2445 vddd vssd sg13cmos5l_decap_8
X_7269_ _7269_/Q _7297_/CLK _7269_/D fanout382/X vddd vssd sg13cmos5l_dfrbpq_1
XFILLER_8_1744 vddd vssd sg13cmos5l_decap_8
XFILLER_24_1514 vddd vssd sg13cmos5l_decap_8
Xhold1140 _6631_/A0 _7276_/Q vddd vssd sg13cmos5l_dlygate4sd3_1
Xhold1151 _7165_/D _6430_/X vddd vssd sg13cmos5l_dlygate4sd3_1
XFILLER_2_2022 vddd vssd sg13cmos5l_decap_8
Xhold1162 _6409_/A1 _5327_/B vddd vssd sg13cmos5l_dlygate4sd3_1
Xhold1184 _6541_/A1 _7223_/Q vddd vssd sg13cmos5l_dlygate4sd3_1
Xhold1173 _7265_/D _6614_/X vddd vssd sg13cmos5l_dlygate4sd3_1
Xhold1195 _7275_/D _6630_/X vddd vssd sg13cmos5l_dlygate4sd3_1
XFILLER_22_1271 vddd vssd sg13cmos5l_decap_8
XFILLER_14_701 vddd vssd sg13cmos5l_decap_8
XFILLER_14_756 vddd vssd sg13cmos5l_decap_8
XFILLER_16_1020 vddd vssd sg13cmos5l_decap_8
XFILLER_9_226 vddd vssd sg13cmos5l_decap_8
XFILLER_10_962 vddd vssd sg13cmos5l_decap_8
XFILLER_5_454 vddd vssd sg13cmos5l_decap_8
XFILLER_6_988 vddd vssd sg13cmos5l_decap_8
XFILLER_23_1013 vddd vssd sg13cmos5l_decap_8
XFILLER_0_181 vddd vssd sg13cmos5l_decap_8
XFILLER_7_1265 vddd vssd sg13cmos5l_decap_8
Xclkbuf_leaf_14_SCK_regs _7199_/CLK clkload5/A vddd vssd sg13cmos5l_buf_8
XFILLER_20_1901 vddd vssd sg13cmos5l_decap_8
X_4970_ _7302_/D _4970_/A vddd vssd sg13cmos5l_inv_1
XFILLER_18_2542 vddd vssd sg13cmos5l_decap_8
X_3921_ _6522_/A _3924_/A _4057_/B vddd vssd sg13cmos5l_nor2_1
X_6640_ _6645_/S _6640_/A _6726_/B vddd vssd sg13cmos5l_and2_1
XFILLER_14_2428 vddd vssd sg13cmos5l_decap_8
X_3852_ _3852_/Y _7092_/Q _4172_/A2 _4172_/B1 vddd vssd sg13cmos5l_a21oi_1
XFILLER_20_737 vddd vssd sg13cmos5l_decap_8
XFILLER_14_1716 vddd vssd sg13cmos5l_decap_8
X_6571_ _6571_/Y _6668_/A _6574_/B vddd vssd sg13cmos5l_nor2_1
X_3783_ _3783_/Y mask_rev_in[14] _3679_/Y _3745_/Y vddd vssd sg13cmos5l_o21ai_1
XFILLER_9_760 vddd vssd sg13cmos5l_decap_8
X_5522_ _5524_/B _5757_/A _5529_/B _5523_/B vddd vssd sg13cmos5l_nand3_1
XFILLER_12_2141 vddd vssd sg13cmos5l_decap_4
X_5453_ _5454_/B _5453_/A _5453_/B vddd vssd sg13cmos5l_nor2_1
X_5384_ _5387_/B _7158_/Q _7159_/Q _5384_/C vddd vssd sg13cmos5l_nor3_1
X_4404_ _4409_/A _4404_/A _4410_/A _4413_/B vddd vssd sg13cmos5l_nand3_1
XFILLER_12_1495 vddd vssd sg13cmos5l_decap_8
X_4335_ _4335_/X _4335_/A _4335_/B vddd vssd sg13cmos5l_xor2_1
Xfanout205 _6636_/A fanout208/X vddd vssd sg13cmos5l_buf_1
XFILLER_5_70 vddd vssd sg13cmos5l_decap_8
X_7123_ _7123_/Q _7123_/CLK _7123_/D _6954_/B_N vddd vssd sg13cmos5l_dfrbpq_1
Xfanout216 _6961_/A _6962_/A vddd vssd sg13cmos5l_buf_1
XFILLER_25_2524 vddd vssd sg13cmos5l_decap_8
Xfanout238 _4577_/A _4382_/A vddd vssd sg13cmos5l_buf_1
Xfanout227 _4980_/B _4979_/B vddd vssd sg13cmos5l_buf_1
X_7054_ _7054_/Q _7286_/CLK _7054_/D fanout378/X vddd vssd sg13cmos5l_dfrbpq_1
X_4266_ _4267_/C sram_odata[0] _6299_/A vddd vssd sg13cmos5l_nand2b_1
Xfanout249 _6009_/A hold626/X vddd vssd sg13cmos5l_buf_1
X_4197_ _4197_/X _7262_/Q _6609_/A vddd vssd sg13cmos5l_or2_1
X_6005_ _6006_/B _6136_/A _5008_/A _4986_/A _4986_/B vddd vssd sg13cmos5l_a22oi_1
XFILLER_3_1630 vddd vssd sg13cmos5l_decap_8
XFILLER_24_35 vddd vssd sg13cmos5l_decap_8
XFILLER_17_2052 vddd vssd sg13cmos5l_decap_8
X_6838_ _6838_/Y _6913_/A _6840_/B_N vddd vssd sg13cmos5l_nor2b_1
XFILLER_32_1838 vddd vssd sg13cmos5l_decap_8
X_6769_ _6769_/X _6769_/A0 _6769_/A1 wire49/X vddd vssd sg13cmos5l_mux2_1
XFILLER_3_969 vddd vssd sg13cmos5l_decap_4
XFILLER_24_1311 vddd vssd sg13cmos5l_decap_8
XFILLER_4_2106 vddd vssd sg13cmos5l_decap_8
XFILLER_1_28 vddd vssd sg13cmos5l_decap_8
XFILLER_4_2139 vddd vssd sg13cmos5l_decap_8
XFILLER_14_542 vddd vssd sg13cmos5l_decap_8
XFILLER_18_1159 vddd vssd sg13cmos5l_decap_8
XFILLER_13_2450 vddd vssd sg13cmos5l_decap_8
XFILLER_29_1222 vddd vssd sg13cmos5l_decap_8
XFILLER_25_1108 vddd vssd sg13cmos5l_decap_8
X_4120_ _4120_/Y _7235_/Q _3908_/Y _3911_/Y vddd vssd sg13cmos5l_o21ai_1
X_4051_ _4051_/Y _5465_/B _3956_/Y _3962_/Y vddd vssd sg13cmos5l_o21ai_1
XFILLER_20_2465 vddd vssd sg13cmos5l_decap_8
XFILLER_0_2559 vddd vssd sg13cmos5l_decap_8
XFILLER_17_391 vddd vssd sg13cmos5l_decap_8
X_4953_ _4953_/Y _4943_/B _4952_/Y _4951_/Y vddd vssd sg13cmos5l_o21ai_1
X_3904_ _6170_/A dbus_in_left[11] dbus_in_right[11] vddd vssd sg13cmos5l_or2_1
X_6623_ _7270_/D _6635_/A1 _6626_/S hold957/X vddd vssd sg13cmos5l_a21oi_1
X_4884_ _4884_/Y _4958_/A _7137_/Q vddd vssd sg13cmos5l_nand2_1
XFILLER_32_394 vddd vssd sg13cmos5l_decap_8
X_3835_ _3946_/A _3940_/B _3835_/B vddd vssd sg13cmos5l_nand2b_1
XFILLER_14_1502 vddd vssd sg13cmos5l_decap_8
XFILLER_31_2583 vddd vssd sg13cmos5l_decap_8
XFILLER_14_1535 vddd vssd sg13cmos5l_decap_4
X_3766_ _3766_/Y _7023_/D _3764_/Y _3766_/B1 vddd vssd sg13cmos5l_a21oi_1
X_6554_ _6560_/S _6554_/A _6702_/B vddd vssd sg13cmos5l_nand2_1
X_5505_ _5505_/Y _5505_/A vddd vssd sg13cmos5l_inv_1
X_6485_ _7194_/D _6492_/A1 _6489_/S _6484_/Y vddd vssd sg13cmos5l_o21ai_1
X_3697_ _6175_/A dbus_in_left[7] dbus_in_right[7] vddd vssd sg13cmos5l_or2_1
X_5436_ _5437_/C _5434_/X _5435_/X _5442_/C vddd vssd sg13cmos5l_a21oi_1
XFILLER_10_37 vddd vssd sg13cmos5l_decap_8
X_5367_ _5369_/A _5566_/A _7158_/Q _7159_/Q vddd vssd sg13cmos5l_nor3_1
XFILLER_0_917 vddd vssd sg13cmos5l_decap_8
XFILLER_9_2562 vddd vssd sg13cmos5l_decap_8
X_5298_ _5298_/X _7148_/Q _5484_/A vddd vssd sg13cmos5l_or2_1
X_7106_ _7106_/Q _7123_/CLK _7106_/D _6933_/B_N vddd vssd sg13cmos5l_dfrbpq_1
X_4318_ _4319_/A _4272_/A _4315_/B _5279_/A vddd vssd sg13cmos5l_a21oi_1
XFILLER_9_2595 vddd vssd sg13cmos5l_decap_8
X_7037_ _7037_/Q _7289_/CLK _7037_/D fanout374/X vddd vssd sg13cmos5l_dfrbpq_1
XFILLER_25_2398 vddd vssd sg13cmos5l_decap_8
XFILLER_19_35 vddd vssd sg13cmos5l_decap_8
X_4249_ _4249_/Y _7136_/Q wire81/A vddd vssd sg13cmos5l_nand2_1
XFILLER_9_1872 vddd vssd sg13cmos5l_decap_4
XFILLER_27_166 vddd vssd sg13cmos5l_decap_8
XFILLER_19_2147 vddd vssd sg13cmos5l_decap_8
XFILLER_19_2169 vddd vssd sg13cmos5l_decap_8
XFILLER_32_1646 vddd vssd sg13cmos5l_decap_8
XFILLER_3_722 vddd vssd sg13cmos5l_decap_8
XFILLER_8_2061 vddd vssd sg13cmos5l_decap_4
Xtiedowns\[32\] dbus_in_right[0] vddd vssd sg13cmos5l_antennanp
XFILLER_19_623 vddd vssd sg13cmos5l_decap_8
XFILLER_18_133 vddd vssd sg13cmos5l_decap_8
XFILLER_15_2556 vddd vssd sg13cmos5l_decap_8
X_3620_ _3620_/Y _3620_/A vddd vssd sg13cmos5l_inv_1
X_3551_ _5373_/A _3551_/A vddd vssd sg13cmos5l_inv_1
XFILLER_13_1590 vddd vssd sg13cmos5l_decap_8
X_3482_ _3482_/Y _4632_/A vddd vssd sg13cmos5l_inv_1
X_6270_ _6270_/Y _6154_/A _6268_/A _5260_/D vddd vssd sg13cmos5l_a21oi_1
X_5221_ _5236_/B _5221_/A vddd vssd sg13cmos5l_inv_1
X_5152_ _5152_/Y _5152_/A _5152_/B _5152_/C vddd vssd sg13cmos5l_nand3_1
XFILLER_22_2527 vddd vssd sg13cmos5l_decap_8
X_4103_ _4103_/Y _3889_/A _3962_/A wire90/X _7267_/Q vddd vssd sg13cmos5l_a22oi_1
X_5083_ _5257_/A _7270_/Q _7271_/Q vddd vssd sg13cmos5l_nand2_1
XFILLER_20_2251 vddd vssd sg13cmos5l_decap_8
X_4034_ _4034_/Y _5868_/C _6545_/A _4032_/Y _4033_/Y _6538_/A vddd vssd sg13cmos5l_a221oi_1
XFILLER_20_1561 vddd vssd sg13cmos5l_decap_4
XFILLER_24_147 vddd vssd sg13cmos5l_decap_8
X_5985_ _5985_/X _5985_/A0 _3705_/B _5985_/S vddd vssd sg13cmos5l_mux2_1
XFILLER_21_832 vddd vssd sg13cmos5l_decap_8
X_4936_ _4936_/Y _4934_/A _4935_/Y _4934_/Y vddd vssd sg13cmos5l_o21ai_1
XANTENNA_32 _3755_/A vddd vssd sg13cmos5l_antennanp
XANTENNA_10 SDI vddd vssd sg13cmos5l_antennanp
X_4867_ _4867_/Y _4867_/A _4867_/B vddd vssd sg13cmos5l_nor2_1
XANTENNA_21 _6674_/Y vddd vssd sg13cmos5l_antennanp
X_3818_ _3818_/Y _7036_/Q _6696_/A _3694_/Y vddd vssd sg13cmos5l_a21oi_1
XANTENNA_43 _3933_/A vddd vssd sg13cmos5l_antennanp
XANTENNA_54 _6344_/A vddd vssd sg13cmos5l_antennanp
X_6606_ _6606_/X _6606_/A0 _6788_/A1 _6608_/S vddd vssd sg13cmos5l_mux2_1
XFILLER_31_2380 vddd vssd sg13cmos5l_decap_8
XFILLER_21_14 vddd vssd sg13cmos5l_decap_8
XFILLER_20_386 vddd vssd sg13cmos5l_decap_8
X_4798_ _4806_/B _4798_/A _4798_/B _4798_/C vddd vssd sg13cmos5l_or3_1
X_6537_ _6537_/Y _6537_/A1 _6536_/B _6536_/Y vddd vssd sg13cmos5l_a21oi_1
X_3749_ _3749_/Y _3786_/A wire98/X vddd vssd sg13cmos5l_nand2_1
X_6468_ _6474_/S _6468_/A _6475_/B vddd vssd sg13cmos5l_nand2_1
X_6399_ _7147_/D _6399_/A1 _6401_/S _6398_/Y vddd vssd sg13cmos5l_o21ai_1
X_5419_ _5419_/Y _7166_/Q _7167_/Q _5442_/A _5441_/B vddd vssd sg13cmos5l_nor4_1
XFILLER_0_758 vddd vssd sg13cmos5l_decap_8
XFILLER_25_1461 vddd vssd sg13cmos5l_decap_8
XFILLER_9_1680 vddd vssd sg13cmos5l_decap_8
XFILLER_30_128 vddd vssd sg13cmos5l_decap_8
XFILLER_15_1107 vddd vssd sg13cmos5l_decap_8
XFILLER_7_16 vddd vssd sg13cmos5l_decap_8
XFILLER_8_825 vddd vssd sg13cmos5l_decap_8
XFILLER_8_847 vddd vssd sg13cmos5l_decap_8
XFILLER_11_342 vddd vssd sg13cmos5l_decap_4
XFILLER_32_1443 vddd vssd sg13cmos5l_decap_8
XFILLER_10_1763 vddd vssd sg13cmos5l_decap_8
XFILLER_3_541 vddd vssd sg13cmos5l_decap_4
XFILLER_23_7 vddd vssd sg13cmos5l_decap_8
XFILLER_22_629 vddd vssd sg13cmos5l_decap_8
X_5770_ _5772_/A _6211_/A _7214_/Q _7215_/Q vddd vssd sg13cmos5l_nor3_1
X_4721_ _4721_/Y _4730_/A _4762_/B vddd vssd sg13cmos5l_nor2_1
X_4652_ _4652_/Y _4169_/A _4628_/X _4758_/B1 vddd vssd sg13cmos5l_a21oi_1
XFILLER_15_1630 vddd vssd sg13cmos5l_decap_8
XFILLER_11_2217 vddd vssd sg13cmos5l_decap_8
XFILLER_30_684 vddd vssd sg13cmos5l_decap_8
X_3603_ _3603_/Y _3603_/A vddd vssd sg13cmos5l_inv_1
X_4583_ _4583_/X _4556_/B _4577_/Y _4736_/B1 vddd vssd sg13cmos5l_a21o_1
Xhold803 _7324_/D _4869_/Y vddd vssd sg13cmos5l_dlygate4sd3_1
X_7371_ _7371_/Q _7375_/CLK _7371_/D _6885_/Y vddd vssd sg13cmos5l_dfrbpq_1
XFILLER_11_1538 vddd vssd sg13cmos5l_decap_8
X_3534_ _3534_/Y _3534_/A vddd vssd sg13cmos5l_inv_1
Xhold825 _5942_/A _6977_/Q vddd vssd sg13cmos5l_dlygate4sd3_1
Xhold836 hold836/X _3603_/Y vddd vssd sg13cmos5l_dlygate4sd3_1
Xhold814 _7370_/D _4311_/Y vddd vssd sg13cmos5l_dlygate4sd3_1
X_6322_ _6322_/Y hold879/X _6321_/B _6321_/Y vddd vssd sg13cmos5l_o21ai_1
Xhold858 _7185_/D _6467_/X vddd vssd sg13cmos5l_dlygate4sd3_1
X_3465_ _3465_/Y _4972_/A vddd vssd sg13cmos5l_inv_1
X_6253_ _6253_/Y _6251_/Y _6252_/X _5252_/B vddd vssd sg13cmos5l_o21ai_1
Xhold847 _4325_/A _7363_/Q vddd vssd sg13cmos5l_dlygate4sd3_1
Xhold869 _7240_/D _6573_/X vddd vssd sg13cmos5l_dlygate4sd3_1
Xoutbuffers\[63\] idac2_value[0] _7045_/Q vddd vssd sg13cmos5l_buf_16
X_5204_ _5244_/B _5204_/A _5204_/B vddd vssd sg13cmos5l_nor2_1
XFILLER_6_2543 vddd vssd sg13cmos5l_decap_8
X_6184_ _6186_/B _6136_/A _5216_/B _5244_/B _4986_/A _6183_/Y vddd vssd sg13cmos5l_a221oi_1
XFILLER_29_217 vddd vssd sg13cmos5l_decap_8
XFILLER_26_2493 vddd vssd sg13cmos5l_decap_8
Xhold1503 hold815/A _7313_/Q vddd vssd sg13cmos5l_dlygate4sd3_1
Xhold1514 _6798_/A _7384_/Q vddd vssd sg13cmos5l_dlygate4sd3_1
X_5135_ _5135_/Y _5135_/A _5135_/B vddd vssd sg13cmos5l_nand2_1
XFILLER_22_2357 vddd vssd sg13cmos5l_decap_4
XFILLER_22_1623 vddd vssd sg13cmos5l_decap_8
X_5066_ _6050_/A _5204_/A _7245_/Q _5167_/A vddd vssd sg13cmos5l_nor3_1
XFILLER_6_1864 vddd vssd sg13cmos5l_decap_8
XFILLER_2_1717 vddd vssd sg13cmos5l_decap_8
XFILLER_0_2142 vddd vssd sg13cmos5l_decap_8
X_4017_ _4017_/Y _7260_/Q _4106_/A _4019_/B vddd vssd sg13cmos5l_a21oi_1
XFILLER_16_14 vddd vssd sg13cmos5l_decap_8
XFILLER_0_2186 vddd vssd sg13cmos5l_decap_4
X_5968_ _5969_/C _7238_/Q _5968_/B _5968_/C vddd vssd sg13cmos5l_nand3b_1
X_4919_ _4920_/B _4961_/B vddd vssd sg13cmos5l_inv_1
XFILLER_32_35 vddd vssd sg13cmos5l_decap_8
XFILLER_16_1438 vddd vssd sg13cmos5l_decap_8
X_5899_ _5899_/Y _7232_/Q _5901_/D _5899_/C vddd vssd sg13cmos5l_nor3_1
XFILLER_27_2246 vddd vssd sg13cmos5l_decap_8
XFILLER_7_2318 vddd vssd sg13cmos5l_decap_8
XFILLER_7_1639 vddd vssd sg13cmos5l_decap_8
XFILLER_25_1280 vddd vssd sg13cmos5l_decap_8
XFILLER_21_1100 vddd vssd sg13cmos5l_decap_4
XFILLER_28_272 vddd vssd sg13cmos5l_decap_4
XFILLER_32_927 vddd vssd sg13cmos5l_decap_8
XFILLER_19_1062 vddd vssd sg13cmos5l_decap_8
Xclkbuf_leaf_39_SCK_regs _7380_/CLK clkbuf_3_0_0_SCK_regs/X vddd vssd sg13cmos5l_buf_8
XFILLER_32_1240 vddd vssd sg13cmos5l_decap_8
XFILLER_7_121 vddd vssd sg13cmos5l_decap_8
XFILLER_7_143 vddd vssd sg13cmos5l_decap_4
XFILLER_7_187 vddd vssd sg13cmos5l_decap_8
XFILLER_8_699 vddd vssd sg13cmos5l_decap_4
XFILLER_10_2272 vddd vssd sg13cmos5l_decap_8
X_6940_ _6940_/Y _6961_/A _6960_/B_N vddd vssd sg13cmos5l_nor2b_1
XFILLER_26_209 vddd vssd sg13cmos5l_decap_8
X_6871_ _6871_/Y _6952_/A _6933_/B_N vddd vssd sg13cmos5l_nor2b_1
XFILLER_23_927 vddd vssd sg13cmos5l_decap_8
X_5822_ _5822_/Y _5819_/A _5821_/Y _5819_/B vddd vssd sg13cmos5l_o21ai_1
XFILLER_22_437 vddd vssd sg13cmos5l_decap_8
X_5753_ _5754_/B _5627_/A _5762_/A _5752_/Y vddd vssd sg13cmos5l_o21ai_1
Xoutbuffers\[7\] proj_ibias_ena[0] _7033_/Q vddd vssd sg13cmos5l_buf_16
X_4704_ _4704_/X _4664_/B _4691_/Y _4736_/B1 vddd vssd sg13cmos5l_a21o_1
X_5684_ _5705_/C _7202_/Q _5690_/B vddd vssd sg13cmos5l_nand2_1
X_4635_ _4635_/Y _4633_/Y _4634_/Y _4624_/Y vddd vssd sg13cmos5l_o21ai_1
XFILLER_8_70 vddd vssd sg13cmos5l_decap_4
XFILLER_11_2036 vddd vssd sg13cmos5l_decap_8
X_4566_ _4566_/Y _4566_/A1 _3605_/Y _4488_/A _4563_/B vddd vssd sg13cmos5l_a22oi_1
Xhold600 hold600/X _4288_/Y vddd vssd sg13cmos5l_dlygate4sd3_1
Xhold611 hold611/X _4851_/Y vddd vssd sg13cmos5l_dlygate4sd3_1
X_7354_ _7354_/Q _7355_/CLK _7354_/D _6868_/Y vddd vssd sg13cmos5l_dfrbpq_1
X_3517_ _5020_/B _3517_/A vddd vssd sg13cmos5l_inv_1
X_6305_ _6305_/Y _6317_/A _6308_/S hold693/X vddd vssd sg13cmos5l_a21oi_1
Xhold622 _6805_/A _7096_/Q vddd vssd sg13cmos5l_dlygate4sd3_1
Xhold633 _6355_/A _7124_/Q vddd vssd sg13cmos5l_dlygate4sd3_1
Xhold644 hold644/X _6359_/Y vddd vssd sg13cmos5l_dlygate4sd3_1
X_7285_ _7285_/Q _7285_/CLK _7285_/D fanout385/X vddd vssd sg13cmos5l_dfrbpq_1
XFILLER_28_2566 vddd vssd sg13cmos5l_decap_8
X_4497_ _4498_/B _4551_/B _3607_/Y _4496_/Y vddd vssd sg13cmos5l_a21oi_1
Xhold677 hold677/X _6384_/Y vddd vssd sg13cmos5l_dlygate4sd3_1
Xhold666 _7375_/D _4298_/Y vddd vssd sg13cmos5l_dlygate4sd3_1
Xhold655 _6351_/A _7122_/Q vddd vssd sg13cmos5l_dlygate4sd3_1
Xhold688 _7269_/D _6620_/X vddd vssd sg13cmos5l_dlygate4sd3_1
Xhold699 _7351_/D _4417_/Y vddd vssd sg13cmos5l_dlygate4sd3_1
X_6236_ _6236_/Y _5873_/A _6232_/Y _6235_/Y vddd vssd sg13cmos5l_a21oi_1
Xhold1300 _7048_/D _6724_/X vddd vssd sg13cmos5l_dlygate4sd3_1
X_6167_ _6167_/Y _5513_/A _6207_/S _6167_/B1 vddd vssd sg13cmos5l_a21oi_1
XFILLER_8_1948 vddd vssd sg13cmos5l_decap_8
Xhold1311 _6694_/A1 _7027_/Q vddd vssd sg13cmos5l_dlygate4sd3_1
Xhold1322 _3537_/A _7147_/Q vddd vssd sg13cmos5l_dlygate4sd3_1
Xhold1333 _7043_/D _6716_/X vddd vssd sg13cmos5l_dlygate4sd3_1
XFILLER_22_2132 vddd vssd sg13cmos5l_decap_8
X_5118_ _6088_/B _7266_/Q _7267_/Q _5173_/B vddd vssd sg13cmos5l_nor3_1
XFILLER_6_2395 vddd vssd sg13cmos5l_decap_4
XFILLER_27_35 vddd vssd sg13cmos5l_decap_8
XFILLER_17_209 vddd vssd sg13cmos5l_decap_8
Xhold1377 hold1377/X _7246_/Q vddd vssd sg13cmos5l_dlygate4sd3_1
Xhold1366 _4307_/B _4306_/X vddd vssd sg13cmos5l_dlygate4sd3_1
Xhold1355 _7396_/D _3766_/Y vddd vssd sg13cmos5l_dlygate4sd3_1
XFILLER_6_1661 vddd vssd sg13cmos5l_decap_4
X_6098_ _6098_/Y _5133_/A _7319_/Q _6167_/B1 vddd vssd sg13cmos5l_o21ai_1
Xhold1344 _3519_/A _7294_/Q vddd vssd sg13cmos5l_dlygate4sd3_1
X_5049_ _5068_/A _5223_/A _5224_/A _5249_/A vddd vssd sg13cmos5l_or3_1
Xhold1399 _6450_/A1 _5498_/C vddd vssd sg13cmos5l_dlygate4sd3_1
Xhold1388 _6413_/A1 _5348_/B vddd vssd sg13cmos5l_dlygate4sd3_1
XFILLER_2_1569 vddd vssd sg13cmos5l_decap_8
XFILLER_26_776 vddd vssd sg13cmos5l_decap_8
XFILLER_13_437 vddd vssd sg13cmos5l_decap_8
XFILLER_11_2570 vddd vssd sg13cmos5l_decap_8
XFILLER_1_842 vddd vssd sg13cmos5l_decap_4
XFILLER_7_2115 vddd vssd sg13cmos5l_decap_8
XFILLER_7_1414 vddd vssd sg13cmos5l_decap_8
XFILLER_0_385 vddd vssd sg13cmos5l_decap_8
XFILLER_17_787 vddd vssd sg13cmos5l_decap_8
XFILLER_31_212 vddd vssd sg13cmos5l_decap_8
XFILLER_20_908 vddd vssd sg13cmos5l_decap_4
XFILLER_31_267 vddd vssd sg13cmos5l_decap_4
XFILLER_13_960 vddd vssd sg13cmos5l_decap_4
XFILLER_16_2470 vddd vssd sg13cmos5l_decap_8
XFILLER_32_1081 vddd vssd sg13cmos5l_decap_8
X_4420_ _4421_/B _4492_/A _4420_/B vddd vssd sg13cmos5l_nor2_1
X_4351_ _4352_/B _4355_/B _4355_/C vddd vssd sg13cmos5l_nand2_1
Xfanout409 fanout409/X fanout410/X vddd vssd sg13cmos5l_buf_1
X_7070_ _7070_/Q _7077_/CLK _7070_/D fanout351/X vddd vssd sg13cmos5l_dfrbpq_1
X_4282_ _4282_/X _4963_/A _4309_/A _4284_/B vddd vssd sg13cmos5l_mux2_1
XFILLER_4_691 vddd vssd sg13cmos5l_decap_8
X_6021_ _6021_/Y _5032_/C _6019_/Y _6020_/Y vddd vssd sg13cmos5l_o21ai_1
XFILLER_23_2496 vddd vssd sg13cmos5l_decap_8
X_6905__470 _7392_/CLK _7210_/CLK vddd vssd sg13cmos5l_inv_1
XFILLER_7_1981 vddd vssd sg13cmos5l_decap_8
XFILLER_12_0 vddd vssd sg13cmos5l_decap_8
Xoutbuffers\[26\] voltgen_sink2[2] _7072_/Q vddd vssd sg13cmos5l_buf_16
X_6923_ _6923_/Y _6923_/A _6923_/B_N vddd vssd sg13cmos5l_nor2b_1
X_6854_ _6854_/Y _6959_/A _6960_/B_N vddd vssd sg13cmos5l_nor2b_1
XFILLER_23_746 vddd vssd sg13cmos5l_decap_8
Xfanout38 _6359_/B _6346_/Y vddd vssd sg13cmos5l_buf_1
X_6785_ _6785_/Y _6317_/A _6784_/B _6784_/Y vddd vssd sg13cmos5l_o21ai_1
X_3997_ _3997_/Y mask_rev_in[19] _3745_/Y _4263_/B vddd vssd sg13cmos5l_o21ai_1
X_5805_ _5805_/Y _5861_/A _5806_/B vddd vssd sg13cmos5l_nor2_1
X_5736_ _5736_/Y _5875_/A _5734_/A _5710_/Y vddd vssd sg13cmos5l_o21ai_1
XFILLER_30_2434 vddd vssd sg13cmos5l_decap_8
X_5667_ _5667_/X _6225_/A _5673_/A vddd vssd sg13cmos5l_or2_1
X_4618_ _4630_/B _4674_/A _4642_/B _5542_/A vddd vssd sg13cmos5l_a21o_1
X_5598_ _5613_/C _7190_/Q _7191_/Q vddd vssd sg13cmos5l_nand2_1
XFILLER_11_1154 vddd vssd sg13cmos5l_decap_8
X_4549_ _4549_/X _4577_/A _4572_/B _5623_/A vddd vssd sg13cmos5l_a21o_1
Xmax_cap171 _6803_/A hold1477/X vddd vssd sg13cmos5l_buf_8
X_7337_ _7337_/Q _7338_/CLK _7337_/D _6851_/Y vddd vssd sg13cmos5l_dfrbpq_1
Xhold496 hold496/X hold496/A vddd vssd sg13cmos5l_dlygate4sd3_1
XFILLER_28_2363 vddd vssd sg13cmos5l_decap_8
Xhold485 sram_addr[3] _5982_/X vddd vssd sg13cmos5l_dlygate4sd3_1
X_7268_ _7268_/Q _7268_/CLK _7268_/D fanout382/X vddd vssd sg13cmos5l_dfrbpq_1
XFILLER_24_2216 vddd vssd sg13cmos5l_decap_4
X_6219_ _6219_/Y _6219_/A _6219_/B _6235_/A vddd vssd sg13cmos5l_nor3_1
X_7199_ _7199_/Q _7199_/CLK _7199_/D fanout367/X vddd vssd sg13cmos5l_dfrbpq_1
Xhold1130 _6707_/A0 _7036_/Q vddd vssd sg13cmos5l_dlygate4sd3_1
Xhold1141 _7276_/D _6631_/X vddd vssd sg13cmos5l_dlygate4sd3_1
XFILLER_6_2181 vddd vssd sg13cmos5l_decap_8
Xhold1174 _6645_/A0 _7285_/Q vddd vssd sg13cmos5l_dlygate4sd3_1
Xhold1152 _6706_/A0 _7035_/Q vddd vssd sg13cmos5l_dlygate4sd3_1
Xhold1163 _7153_/D _6409_/Y vddd vssd sg13cmos5l_dlygate4sd3_1
Xhold1185 _7223_/D _6541_/X vddd vssd sg13cmos5l_dlygate4sd3_1
XFILLER_2_2067 vddd vssd sg13cmos5l_decap_8
XFILLER_2_1300 vddd vssd sg13cmos5l_decap_4
Xhold1196 _3583_/A _7220_/Q vddd vssd sg13cmos5l_dlygate4sd3_1
XFILLER_16_1098 vddd vssd sg13cmos5l_decap_8
Xtiedowns\[62\] mask_rev_in[18] vddd vssd sg13cmos5l_antennanp
XFILLER_9_1509 vddd vssd sg13cmos5l_decap_8
XFILLER_7_1211 vddd vssd sg13cmos5l_decap_8
XFILLER_2_2590 vddd vssd sg13cmos5l_decap_8
X_3920_ _3920_/Y _3920_/A _6538_/A vddd vssd sg13cmos5l_nand2_1
Xoutbuffers\[116\] dbus_out[19] _5851_/Y vddd vssd sg13cmos5l_buf_16
XFILLER_18_2521 vddd vssd sg13cmos5l_decap_8
X_3851_ _3851_/Y _7100_/Q _4256_/B _3850_/Y vddd vssd sg13cmos5l_a21oi_1
XFILLER_18_2598 vddd vssd sg13cmos5l_decap_8
X_3782_ _3782_/Y mask_rev_in[6] _4081_/B _3781_/Y vddd vssd sg13cmos5l_o21ai_1
X_6570_ _7238_/D _6704_/A1 _6574_/B hold932/X vddd vssd sg13cmos5l_o21ai_1
X_5521_ _5524_/A _5527_/B _5516_/Y _5520_/Y vddd vssd sg13cmos5l_o21ai_1
XFILLER_13_790 vddd vssd sg13cmos5l_decap_8
XFILLER_8_260 vddd vssd sg13cmos5l_decap_8
X_5452_ _5453_/B _3539_/A _5475_/C _5475_/B vddd vssd sg13cmos5l_o21ai_1
XFILLER_12_1474 vddd vssd sg13cmos5l_decap_8
X_5383_ _5383_/Y _5383_/A _5383_/B _5383_/C vddd vssd sg13cmos5l_nor3_1
X_4403_ _4413_/B _4412_/A _4415_/B vddd vssd sg13cmos5l_and2_1
XFILLER_25_2503 vddd vssd sg13cmos5l_decap_8
X_4334_ _4335_/B _4320_/X _4326_/C _4336_/A vddd vssd sg13cmos5l_o21ai_1
X_7122_ _7122_/Q _7264_/CLK _7122_/D _6956_/B_N vddd vssd sg13cmos5l_dfrbpq_1
X_7053_ _7053_/Q _7286_/CLK _7053_/D fanout378/X vddd vssd sg13cmos5l_dfrbpq_1
Xfanout206 _6788_/A1 _6782_/A vddd vssd sg13cmos5l_buf_1
Xfanout217 _6962_/A _6954_/A vddd vssd sg13cmos5l_buf_1
Xfanout228 _4979_/B _6299_/A vddd vssd sg13cmos5l_buf_1
Xfanout239 _4382_/A hold1473/X vddd vssd sg13cmos5l_buf_1
X_4265_ _4265_/Y _6299_/A wire1/X vddd vssd sg13cmos5l_nor2_1
X_6004_ _6004_/Y _6144_/A _5010_/B _6002_/Y _6003_/Y _5008_/A vddd vssd sg13cmos5l_a221oi_1
X_4196_ _4196_/Y _4193_/X _4194_/Y _4195_/Y vddd vssd sg13cmos5l_o21ai_1
XFILLER_24_14 vddd vssd sg13cmos5l_decap_8
XFILLER_23_521 vddd vssd sg13cmos5l_decap_8
XFILLER_19_1606 vddd vssd sg13cmos5l_decap_8
XFILLER_23_543 vddd vssd sg13cmos5l_decap_8
X_6837_ _6837_/Y _6956_/A _6956_/B_N vddd vssd sg13cmos5l_nor2b_1
XFILLER_11_738 vddd vssd sg13cmos5l_decap_8
XFILLER_32_1817 vddd vssd sg13cmos5l_decap_8
X_6768_ _6768_/Y _6768_/A1 wire49/X _6767_/Y vddd vssd sg13cmos5l_o21ai_1
XFILLER_17_1374 vddd vssd sg13cmos5l_decap_8
XFILLER_6_208 vddd vssd sg13cmos5l_decap_8
XFILLER_30_2253 vddd vssd sg13cmos5l_decap_4
X_6699_ _6699_/X _6699_/A0 _6520_/A _6709_/S vddd vssd sg13cmos5l_mux2_1
X_5719_ _5719_/Y _5783_/A _7209_/Q vddd vssd sg13cmos5l_nor2_1
XFILLER_3_904 vddd vssd sg13cmos5l_decap_8
XFILLER_8_1553 vddd vssd sg13cmos5l_decap_8
XFILLER_24_1345 vddd vssd sg13cmos5l_decap_8
XFILLER_2_1152 vddd vssd sg13cmos5l_decap_8
XFILLER_18_1105 vddd vssd sg13cmos5l_decap_4
XFILLER_18_1116 vddd vssd sg13cmos5l_decap_8
XFILLER_10_771 vddd vssd sg13cmos5l_decap_8
XFILLER_9_2007 vddd vssd sg13cmos5l_decap_8
XFILLER_20_2400 vddd vssd sg13cmos5l_decap_4
X_4050_ _4050_/Y _5498_/C _6445_/A _4048_/Y _4049_/Y _6438_/A vddd vssd sg13cmos5l_a221oi_1
XFILLER_20_2444 vddd vssd sg13cmos5l_decap_8
XFILLER_7_1074 vddd vssd sg13cmos5l_decap_8
XFILLER_0_2538 vddd vssd sg13cmos5l_decap_8
XFILLER_18_882 vddd vssd sg13cmos5l_decap_8
X_4952_ _4952_/Y _4952_/A _4952_/B vddd vssd sg13cmos5l_xnor2_1
X_3903_ _6188_/A dbus_in_left[11] dbus_in_right[11] vddd vssd sg13cmos5l_nor2_1
X_4883_ _4883_/Y _4946_/A _7141_/Q vddd vssd sg13cmos5l_nand2_1
XFILLER_32_373 vddd vssd sg13cmos5l_decap_8
X_3834_ _3947_/A _3940_/B _3936_/B vddd vssd sg13cmos5l_nor2_1
X_6622_ _6622_/Y _6622_/A _6626_/S vddd vssd sg13cmos5l_nor2_1
XFILLER_31_2562 vddd vssd sg13cmos5l_decap_8
X_3765_ _3765_/Y _3765_/A _7023_/D vddd vssd sg13cmos5l_nor2_1
X_6553_ _6553_/Y _6553_/A1 _6552_/B _6552_/Y vddd vssd sg13cmos5l_a21oi_1
Xoutbuffers\[93\] io_out[8] _6187_/Y vddd vssd sg13cmos5l_buf_16
X_3696_ _3696_/Y dbus_in_left[7] dbus_in_right[7] vddd vssd sg13cmos5l_nor2_1
X_6484_ _6484_/Y _6484_/A _6489_/S vddd vssd sg13cmos5l_nand2_1
X_5504_ _5505_/A io_in[0] _5480_/Y _5501_/Y _5503_/Y vddd vssd sg13cmos5l_a22oi_1
X_5435_ _5435_/X _5484_/A _5442_/A vddd vssd sg13cmos5l_or2_1
XFILLER_10_16 vddd vssd sg13cmos5l_decap_8
X_5366_ _5372_/A _7158_/Q _5380_/B vddd vssd sg13cmos5l_nand2_1
XFILLER_9_2541 vddd vssd sg13cmos5l_decap_8
X_5297_ _5297_/X _5308_/D _5464_/A vddd vssd sg13cmos5l_or2_1
X_4317_ _5988_/B _4317_/A _5279_/A vddd vssd sg13cmos5l_nor2_1
X_7105_ _7105_/Q _7263_/CLK _7105_/D _6933_/B_N vddd vssd sg13cmos5l_dfrbpq_1
X_7036_ _7036_/Q _7201_/CLK _7036_/D fanout370/X vddd vssd sg13cmos5l_dfrbpq_1
XFILLER_25_2377 vddd vssd sg13cmos5l_decap_8
X_4248_ _4248_/Y _4245_/Y _4246_/Y _4247_/Y vddd vssd sg13cmos5l_a21oi_1
XFILLER_19_14 vddd vssd sg13cmos5l_decap_8
XFILLER_5_2438 vddd vssd sg13cmos5l_decap_8
XFILLER_5_1748 vddd vssd sg13cmos5l_decap_8
XFILLER_23_2090 vddd vssd sg13cmos5l_decap_8
X_4179_ _4179_/Y _4179_/A1 sram_odata[1] _3756_/X wire3/X _4300_/B vddd vssd sg13cmos5l_a221oi_1
XFILLER_28_668 vddd vssd sg13cmos5l_decap_8
XFILLER_27_145 vddd vssd sg13cmos5l_decap_8
XFILLER_3_1472 vddd vssd sg13cmos5l_decap_8
XFILLER_19_2126 vddd vssd sg13cmos5l_decap_8
XFILLER_24_896 vddd vssd sg13cmos5l_decap_4
XFILLER_17_1160 vddd vssd sg13cmos5l_decap_8
XFILLER_32_1625 vddd vssd sg13cmos5l_decap_8
XFILLER_7_528 vddd vssd sg13cmos5l_decap_4
XFILLER_3_701 vddd vssd sg13cmos5l_decap_4
XFILLER_8_2040 vddd vssd sg13cmos5l_decap_8
Xtiedowns\[25\] dbus_in_left[5] vddd vssd sg13cmos5l_antennanp
XFILLER_24_1131 vddd vssd sg13cmos5l_decap_8
XFILLER_8_1372 vddd vssd sg13cmos5l_decap_8
XFILLER_24_1175 vddd vssd sg13cmos5l_decap_8
XFILLER_18_112 vddd vssd sg13cmos5l_decap_8
XFILLER_4_1247 vddd vssd sg13cmos5l_decap_8
XFILLER_15_2535 vddd vssd sg13cmos5l_decap_8
XFILLER_15_1856 vddd vssd sg13cmos5l_decap_8
XFILLER_15_1834 vddd vssd sg13cmos5l_decap_4
XFILLER_13_2270 vddd vssd sg13cmos5l_decap_8
X_3550_ _5340_/B _7157_/Q vddd vssd sg13cmos5l_inv_1
XFILLER_6_550 vddd vssd sg13cmos5l_decap_8
X_3481_ _3481_/Y _4609_/A vddd vssd sg13cmos5l_inv_1
X_5220_ _5221_/A _5136_/A _6181_/C vddd vssd sg13cmos5l_nand2b_1
X_5151_ _5152_/C _7295_/Q _5233_/A _5151_/C _5151_/D vddd vssd sg13cmos5l_nor4_1
XFILLER_29_1097 vddd vssd sg13cmos5l_decap_4
XFILLER_22_2506 vddd vssd sg13cmos5l_decap_8
X_4102_ _4102_/Y _7271_/Q _6621_/A _6615_/A vddd vssd sg13cmos5l_o21ai_1
X_5082_ _5102_/A _7293_/Q _5193_/B vddd vssd sg13cmos5l_nor2_1
X_4033_ _4033_/Y _7232_/Q _6554_/A _6545_/A vddd vssd sg13cmos5l_a21oi_1
XFILLER_0_2324 vddd vssd sg13cmos5l_decap_8
XFILLER_4_2493 vddd vssd sg13cmos5l_decap_8
XFILLER_0_2357 vddd vssd sg13cmos5l_decap_8
XFILLER_24_126 vddd vssd sg13cmos5l_decap_8
XFILLER_20_1584 vddd vssd sg13cmos5l_decap_8
XFILLER_18_690 vddd vssd sg13cmos5l_decap_8
XFILLER_0_1623 vddd vssd sg13cmos5l_decap_4
X_5984_ _5984_/X hold950/X _3693_/B _5991_/S vddd vssd sg13cmos5l_mux2_1
X_4935_ _4935_/Y _4935_/A _4935_/B vddd vssd sg13cmos5l_nand2_1
XANTENNA_11 SDI vddd vssd sg13cmos5l_antennanp
X_4866_ _4866_/Y _4832_/B _4867_/B vddd vssd sg13cmos5l_nand2b_1
Xtiedowns\[9\] _5416_/A vddd vssd sg13cmos5l_antennanp
XANTENNA_22 _6674_/Y vddd vssd sg13cmos5l_antennanp
XFILLER_18_1491 vddd vssd sg13cmos5l_decap_4
XANTENNA_55 _6801_/A vddd vssd sg13cmos5l_antennanp
XFILLER_14_2067 vddd vssd sg13cmos5l_decap_8
X_3817_ _3817_/Y _3815_/Y _3816_/Y hold588/X vddd vssd sg13cmos5l_o21ai_1
XANTENNA_44 _3744_/Y vddd vssd sg13cmos5l_antennanp
X_6605_ _7258_/D _6635_/A1 _6608_/S _6605_/B1 vddd vssd sg13cmos5l_a21oi_1
X_4797_ _4797_/Y _4821_/A _4780_/Y _4512_/A vddd vssd sg13cmos5l_a21oi_1
XANTENNA_33 _3755_/A vddd vssd sg13cmos5l_antennanp
X_3748_ _3748_/Y _6301_/A _3959_/A vddd vssd sg13cmos5l_nor2_1
X_6536_ _6536_/Y _6552_/A _6536_/B vddd vssd sg13cmos5l_nor2_1
XFILLER_14_1366 vddd vssd sg13cmos5l_decap_8
X_6467_ _6467_/X _6459_/A hold857/X _6467_/S vddd vssd sg13cmos5l_mux2_1
X_3679_ _3679_/Y _3786_/A _3875_/A vddd vssd sg13cmos5l_nand2_1
X_6398_ _6398_/Y _6405_/A _6401_/S vddd vssd sg13cmos5l_nand2_1
X_5418_ _5418_/Y _5590_/A1 _5417_/A _5415_/Y _5417_/Y vddd vssd sg13cmos5l_a22oi_1
XFILLER_27_1738 vddd vssd sg13cmos5l_decap_8
X_5349_ _5349_/Y _5807_/A1 _5340_/B _5347_/Y _7156_/Q vddd vssd sg13cmos5l_a22oi_1
XFILLER_9_2393 vddd vssd sg13cmos5l_decap_8
XFILLER_5_2268 vddd vssd sg13cmos5l_decap_8
X_7019_ _7019_/Q _7020_/CLK _7019_/D _6966_/Y vddd vssd sg13cmos5l_dfrbpq_1
XFILLER_21_1326 vddd vssd sg13cmos5l_decap_4
XFILLER_30_107 vddd vssd sg13cmos5l_decap_8
XFILLER_24_671 vddd vssd sg13cmos5l_decap_8
XFILLER_19_1233 vddd vssd sg13cmos5l_decap_8
XFILLER_19_1266 vddd vssd sg13cmos5l_decap_8
XFILLER_12_844 vddd vssd sg13cmos5l_decap_8
XFILLER_32_1422 vddd vssd sg13cmos5l_decap_8
XFILLER_32_2178 vddd vssd sg13cmos5l_decap_8
XFILLER_10_1742 vddd vssd sg13cmos5l_decap_8
XFILLER_10_2498 vddd vssd sg13cmos5l_decap_8
XFILLER_11_70 vddd vssd sg13cmos5l_decap_8
XFILLER_16_7 vddd vssd sg13cmos5l_decap_8
XFILLER_1_2600 vddd vssd sg13cmos5l_decap_8
XFILLER_4_1088 vddd vssd sg13cmos5l_decap_8
X_4720_ _4720_/Y _4713_/Y _4714_/X _4719_/Y vddd vssd sg13cmos5l_o21ai_1
X_4651_ _4651_/Y _4625_/A _4651_/B vddd vssd sg13cmos5l_nand2b_1
X_3602_ _3602_/Y _3602_/A vddd vssd sg13cmos5l_inv_1
XFILLER_15_1675 vddd vssd sg13cmos5l_decap_4
X_4582_ _4582_/Y _4582_/A _4582_/B vddd vssd sg13cmos5l_xnor2_1
X_7370_ _7370_/Q _7404_/CLK _7370_/D _6884_/Y vddd vssd sg13cmos5l_dfrbpq_1
Xhold826 _5943_/B _5942_/Y vddd vssd sg13cmos5l_dlygate4sd3_1
Xhold815 hold815/X hold815/A vddd vssd sg13cmos5l_dlygate4sd3_1
Xhold837 hold837/X _7132_/Q vddd vssd sg13cmos5l_dlygate4sd3_1
Xhold804 hold804/X _7135_/Q vddd vssd sg13cmos5l_dlygate4sd3_1
X_6321_ _6321_/Y _6732_/A _6321_/B vddd vssd sg13cmos5l_nand2_1
X_3533_ _3533_/Y _3533_/A vddd vssd sg13cmos5l_inv_1
X_6252_ _6252_/X _6072_/A _6251_/A _5251_/D vddd vssd sg13cmos5l_a21o_1
Xhold848 _4338_/B _4337_/Y vddd vssd sg13cmos5l_dlygate4sd3_1
Xhold859 _4305_/A _7373_/Q vddd vssd sg13cmos5l_dlygate4sd3_1
X_5203_ _6175_/B _7270_/Q _7271_/Q _5257_/B vddd vssd sg13cmos5l_nor3_1
X_6183_ _6183_/Y _6144_/A _5195_/Y _6181_/Y _6182_/Y _5216_/B vddd vssd sg13cmos5l_a221oi_1
XFILLER_26_2472 vddd vssd sg13cmos5l_decap_8
X_5134_ _5135_/B _6082_/B _5134_/B _5134_/C _5134_/D vddd vssd sg13cmos5l_nor4_1
XFILLER_6_2522 vddd vssd sg13cmos5l_decap_8
Xoutbuffers\[56\] voltgen_value[0] _7054_/Q vddd vssd sg13cmos5l_buf_16
XFILLER_22_1602 vddd vssd sg13cmos5l_decap_8
Xhold1504 hold1504/X _7308_/Q vddd vssd sg13cmos5l_dlygate4sd3_1
Xhold1515 hold1515/X _7384_/Q vddd vssd sg13cmos5l_dlygate4sd3_1
Xclkbuf_3_2_0_clk_regs clkbuf_3_2_0_clk_regs/X clkbuf_0_clk_regs/X vddd vssd sg13cmos5l_buf_8
X_5065_ _5167_/A _5065_/A _7243_/Q vddd vssd sg13cmos5l_nand2_1
XFILLER_6_2599 vddd vssd sg13cmos5l_decap_8
XFILLER_26_914 vddd vssd sg13cmos5l_decap_8
Xclkbuf_leaf_9_SCK_regs _7071_/CLK clkload4/A vddd vssd sg13cmos5l_buf_8
X_4016_ _4016_/Y _7264_/Q _6609_/A vddd vssd sg13cmos5l_nor2_1
XFILLER_25_446 vddd vssd sg13cmos5l_decap_8
XFILLER_20_1392 vddd vssd sg13cmos5l_decap_4
XFILLER_20_1381 vddd vssd sg13cmos5l_decap_8
X_5967_ _5969_/B _5967_/A _5974_/B _5968_/C vddd vssd sg13cmos5l_nand3_1
XFILLER_12_107 vddd vssd sg13cmos5l_decap_8
X_4918_ _4961_/B _4900_/B _4892_/B _4916_/B _4912_/A vddd vssd sg13cmos5l_a22oi_1
XFILLER_32_14 vddd vssd sg13cmos5l_decap_8
X_5898_ _5898_/Y _5898_/A1 _5895_/Y _5897_/Y vddd vssd sg13cmos5l_a21oi_1
XFILLER_21_696 vddd vssd sg13cmos5l_decap_4
X_4849_ _4849_/Y hold845/A sram_odata[4] _4848_/Y vddd vssd sg13cmos5l_a21oi_1
XFILLER_4_339 vddd vssd sg13cmos5l_decap_8
X_6519_ _6519_/X _6692_/A _6519_/A1 _6520_/B vddd vssd sg13cmos5l_mux2_1
XFILLER_10_1038 vddd vssd sg13cmos5l_decap_8
XFILLER_7_1618 vddd vssd sg13cmos5l_decap_8
XFILLER_9_2190 vddd vssd sg13cmos5l_decap_4
XFILLER_5_1342 vddd vssd sg13cmos5l_decap_8
XFILLER_17_925 vddd vssd sg13cmos5l_decap_8
XFILLER_16_424 vddd vssd sg13cmos5l_decap_8
XFILLER_32_906 vddd vssd sg13cmos5l_decap_8
XFILLER_17_958 vddd vssd sg13cmos5l_decap_8
XFILLER_24_490 vddd vssd sg13cmos5l_decap_8
XFILLER_16_1951 vddd vssd sg13cmos5l_decap_8
XFILLER_7_100 vddd vssd sg13cmos5l_decap_8
XFILLER_12_2549 vddd vssd sg13cmos5l_decap_8
XFILLER_8_678 vddd vssd sg13cmos5l_decap_8
XFILLER_22_91 vddd vssd sg13cmos5l_decap_4
XFILLER_23_2601 vddd vssd sg13cmos5l_decap_4
XFILLER_1_2496 vddd vssd sg13cmos5l_decap_8
X_6870_ _6870_/Y _6870_/A _6870_/B_N vddd vssd sg13cmos5l_nor2b_1
X_5821_ _5821_/Y _5586_/A _5816_/A _5820_/Y vddd vssd sg13cmos5l_o21ai_1
XFILLER_17_1715 vddd vssd sg13cmos5l_decap_8
XFILLER_15_490 vddd vssd sg13cmos5l_decap_4
X_5752_ _5752_/Y _5752_/A _5752_/B vddd vssd sg13cmos5l_nand2_1
XFILLER_15_2140 vddd vssd sg13cmos5l_decap_8
X_4703_ _4703_/Y _4702_/Y _4703_/B vddd vssd sg13cmos5l_nand2b_1
X_5683_ _5706_/A _7202_/Q _7203_/Q _5705_/B vddd vssd sg13cmos5l_nor3_1
X_4634_ _4634_/Y _4622_/Y _4631_/Y _4746_/B1 vddd vssd sg13cmos5l_o21ai_1
XFILLER_15_1472 vddd vssd sg13cmos5l_decap_8
X_4565_ _4565_/Y _4563_/Y _4564_/Y _4554_/Y vddd vssd sg13cmos5l_o21ai_1
X_7353_ _7353_/Q _7355_/CLK _7353_/D _6867_/Y vddd vssd sg13cmos5l_dfrbpq_1
Xhold601 _7377_/D _4289_/Y vddd vssd sg13cmos5l_dlygate4sd3_1
Xhold612 _7327_/D _4855_/Y vddd vssd sg13cmos5l_dlygate4sd3_1
X_6304_ _6304_/Y _6304_/A _6805_/B vddd vssd sg13cmos5l_nor2_1
Xhold623 hold623/X _6805_/Y vddd vssd sg13cmos5l_dlygate4sd3_1
X_3516_ _5245_/B _3516_/A vddd vssd sg13cmos5l_inv_1
Xhold634 hold634/X _6355_/Y vddd vssd sg13cmos5l_dlygate4sd3_1
XFILLER_11_1369 vddd vssd sg13cmos5l_decap_8
Xhold645 _6361_/A _7127_/Q vddd vssd sg13cmos5l_dlygate4sd3_1
X_7284_ _7284_/Q _7286_/CLK _7284_/D fanout385/X vddd vssd sg13cmos5l_dfrbpq_1
XFILLER_28_2545 vddd vssd sg13cmos5l_decap_8
X_4496_ _4496_/Y _4496_/A _4551_/B vddd vssd sg13cmos5l_nor2_1
Xhold678 _7141_/D _6385_/Y vddd vssd sg13cmos5l_dlygate4sd3_1
Xhold656 hold656/X _6351_/Y vddd vssd sg13cmos5l_dlygate4sd3_1
Xhold667 _6374_/A _7136_/Q vddd vssd sg13cmos5l_dlygate4sd3_1
Xhold689 _6792_/A _7089_/Q vddd vssd sg13cmos5l_dlygate4sd3_1
X_6235_ _6235_/Y _6235_/A _7237_/Q _6235_/C vddd vssd sg13cmos5l_nor3_1
XFILLER_28_1877 vddd vssd sg13cmos5l_decap_4
XFILLER_22_2100 vddd vssd sg13cmos5l_decap_8
X_6166_ wire12/A _6164_/Y _6165_/Y _6143_/Y vddd vssd sg13cmos5l_o21ai_1
Xhold1312 _7027_/D _6694_/X vddd vssd sg13cmos5l_dlygate4sd3_1
Xhold1301 _6752_/A1 _7066_/Q vddd vssd sg13cmos5l_dlygate4sd3_1
Xhold1323 _6399_/A1 _5294_/B vddd vssd sg13cmos5l_dlygate4sd3_1
Xhold1334 _6715_/A0 _7042_/Q vddd vssd sg13cmos5l_dlygate4sd3_1
X_6097_ _6099_/B _5131_/A _6095_/Y _6096_/Y vddd vssd sg13cmos5l_o21ai_1
X_5117_ _5173_/B _5209_/B _5208_/A vddd vssd sg13cmos5l_nand2b_1
X_5048_ _5249_/A _7278_/Q _7279_/Q vddd vssd sg13cmos5l_nand2b_1
XFILLER_27_14 vddd vssd sg13cmos5l_decap_8
Xhold1367 hold1367/X _7186_/Q vddd vssd sg13cmos5l_dlygate4sd3_1
Xhold1356 _3587_/A _7318_/Q vddd vssd sg13cmos5l_dlygate4sd3_1
Xhold1345 _6660_/A1 _5133_/A vddd vssd sg13cmos5l_dlygate4sd3_1
Xhold1378 _6584_/A _5130_/A vddd vssd sg13cmos5l_dlygate4sd3_1
XFILLER_2_1548 vddd vssd sg13cmos5l_decap_8
Xhold1389 _7155_/D _6413_/X vddd vssd sg13cmos5l_dlygate4sd3_1
XFILLER_14_906 vddd vssd sg13cmos5l_decap_8
XFILLER_13_416 vddd vssd sg13cmos5l_decap_8
X_6999_ _6999_/Q _7346_/CLK _6999_/D _6946_/Y vddd vssd sg13cmos5l_dfrbpq_1
XFILLER_25_287 vddd vssd sg13cmos5l_decap_8
XFILLER_9_409 vddd vssd sg13cmos5l_decap_8
XFILLER_21_460 vddd vssd sg13cmos5l_decap_8
XFILLER_4_103 vddd vssd sg13cmos5l_decap_8
XFILLER_0_364 vddd vssd sg13cmos5l_decap_8
XFILLER_29_560 vddd vssd sg13cmos5l_decap_8
XFILLER_16_210 vddd vssd sg13cmos5l_decap_8
XFILLER_17_91 vddd vssd sg13cmos5l_decap_8
XFILLER_12_2313 vddd vssd sg13cmos5l_decap_8
XFILLER_12_1623 vddd vssd sg13cmos5l_decap_8
XFILLER_32_1060 vddd vssd sg13cmos5l_decap_8
X_4350_ _4350_/Y _4357_/A _4357_/B vddd vssd sg13cmos5l_nand2_1
X_4281_ _4284_/B _4315_/A _4305_/A _4281_/C vddd vssd sg13cmos5l_nand3b_1
X_6020_ _6020_/Y _6177_/A _5032_/C _5042_/D vddd vssd sg13cmos5l_a21oi_1
XFILLER_3_2525 vddd vssd sg13cmos5l_decap_8
XFILLER_23_2475 vddd vssd sg13cmos5l_decap_8
XFILLER_3_2558 vddd vssd sg13cmos5l_decap_8
X_6922_ _6922_/Y _6923_/A _6923_/B_N vddd vssd sg13cmos5l_nor2b_1
Xoutbuffers\[19\] voltgen_source[0] _7073_/Q vddd vssd sg13cmos5l_buf_16
X_6853_ _6853_/Y _6962_/A _6957_/B_N vddd vssd sg13cmos5l_nor2b_1
XFILLER_23_725 vddd vssd sg13cmos5l_decap_8
X_5804_ _5804_/Y _5816_/A _5803_/Y _7220_/Q vddd vssd sg13cmos5l_o21ai_1
Xfanout39 _6338_/B _6344_/B vddd vssd sg13cmos5l_buf_1
X_6784_ _6784_/Y _6784_/A _6784_/B vddd vssd sg13cmos5l_nand2_1
X_3996_ _3996_/Y mask_rev_in[3] _4172_/B1 _3994_/Y vddd vssd sg13cmos5l_a21oi_1
XFILLER_30_2413 vddd vssd sg13cmos5l_decap_8
X_5735_ _5735_/Y _5729_/Y _5731_/Y _5734_/Y vddd vssd sg13cmos5l_a21oi_1
XFILLER_17_1567 vddd vssd sg13cmos5l_decap_4
X_5666_ _5666_/Y _5752_/A _5666_/B vddd vssd sg13cmos5l_nand2_1
XFILLER_13_49 vddd vssd sg13cmos5l_decap_8
X_4617_ _4617_/Y _4617_/A _4617_/B vddd vssd sg13cmos5l_nand2_1
X_5597_ _5614_/C _7190_/Q _7191_/Q vddd vssd sg13cmos5l_nand2b_1
XFILLER_11_1133 vddd vssd sg13cmos5l_decap_8
X_4548_ _4548_/X _4548_/A1 _4810_/B _4547_/Y vddd vssd sg13cmos5l_a21o_1
X_7336_ _7336_/Q _7336_/CLK _7336_/D _6850_/Y vddd vssd sg13cmos5l_dfrbpq_1
X_4479_ _4479_/Y _4815_/A _4479_/B vddd vssd sg13cmos5l_nand2_1
X_7267_ _7267_/Q _7297_/CLK _7267_/D fanout381/X vddd vssd sg13cmos5l_dfrbpq_1
Xhold486 _4961_/A hold915/X vddd vssd sg13cmos5l_dlygate4sd3_1
Xhold497 _4795_/B hold497/A vddd vssd sg13cmos5l_dlygate4sd3_1
X_6218_ _6218_/Y _6231_/C _6217_/Y _6235_/A vddd vssd sg13cmos5l_o21ai_1
X_7198_ _7198_/Q _7201_/CLK _7198_/D fanout367/X vddd vssd sg13cmos5l_dfrbpq_1
Xhold1120 _7077_/D _6770_/X vddd vssd sg13cmos5l_dlygate4sd3_1
Xhold1131 _7036_/D _6707_/X vddd vssd sg13cmos5l_dlygate4sd3_1
X_6149_ _6149_/Y _6148_/Y _6149_/B vddd vssd sg13cmos5l_nand2b_1
Xclkbuf_1_0__f_SCK clkload2/A clkbuf_0_SCK/X vddd vssd sg13cmos5l_buf_8
Xhold1142 _3584_/A _7221_/Q vddd vssd sg13cmos5l_dlygate4sd3_1
Xhold1175 _7285_/D _6645_/X vddd vssd sg13cmos5l_dlygate4sd3_1
Xhold1153 _7035_/D _6706_/X vddd vssd sg13cmos5l_dlygate4sd3_1
XFILLER_22_1240 vddd vssd sg13cmos5l_decap_4
Xhold1164 _6626_/A0 _7273_/Q vddd vssd sg13cmos5l_dlygate4sd3_1
XFILLER_22_1295 vddd vssd sg13cmos5l_decap_8
Xhold1186 _6602_/A0 _7257_/Q vddd vssd sg13cmos5l_dlygate4sd3_1
Xhold1197 _6535_/A1 _5812_/C vddd vssd sg13cmos5l_dlygate4sd3_1
XFILLER_26_574 vddd vssd sg13cmos5l_decap_8
XFILLER_26_552 vddd vssd sg13cmos5l_decap_8
XFILLER_13_1976 vddd vssd sg13cmos5l_decap_8
XFILLER_29_1405 vddd vssd sg13cmos5l_decap_8
Xtiedowns\[55\] mask_rev_in[11] vddd vssd sg13cmos5l_antennanp
XFILLER_1_695 vddd vssd sg13cmos5l_decap_4
XFILLER_18_2500 vddd vssd sg13cmos5l_decap_8
XFILLER_17_563 vddd vssd sg13cmos5l_decap_8
XFILLER_18_2577 vddd vssd sg13cmos5l_decap_8
XFILLER_18_1843 vddd vssd sg13cmos5l_decap_4
X_3850_ _3850_/Y wire21/X _3844_/Y _3849_/Y vddd vssd sg13cmos5l_a21oi_1
Xoutbuffers\[109\] dbus_out[12] _5650_/Y vddd vssd sg13cmos5l_buf_16
X_3781_ _3781_/Y _3778_/Y _3781_/B _3781_/C vddd vssd sg13cmos5l_nand3b_1
Xclkbuf_leaf_23_SCK_regs _7273_/CLK clkload6/A vddd vssd sg13cmos5l_buf_8
XFILLER_9_740 vddd vssd sg13cmos5l_decap_8
X_5520_ _5520_/Y _5529_/B _5523_/B _5519_/Y _5527_/B _5511_/Y vddd vssd sg13cmos5l_a221oi_1
X_5451_ _5453_/A _5566_/A _7170_/Q _7171_/Q vddd vssd sg13cmos5l_nor3_1
XFILLER_8_283 vddd vssd sg13cmos5l_decap_8
XFILLER_12_1442 vddd vssd sg13cmos5l_decap_8
X_5382_ _5382_/Y _5380_/Y _5381_/Y _5389_/C vddd vssd sg13cmos5l_o21ai_1
X_4402_ _4415_/B _4414_/A _4417_/B vddd vssd sg13cmos5l_and2_1
X_4333_ _4333_/Y _4333_/A _4355_/B vddd vssd sg13cmos5l_nand2_1
X_7121_ _7121_/Q _7263_/CLK _7121_/D _6954_/B_N vddd vssd sg13cmos5l_dfrbpq_1
XFILLER_29_1961 vddd vssd sg13cmos5l_decap_8
X_7052_ _7052_/Q _7300_/CLK _7052_/D fanout377/X vddd vssd sg13cmos5l_dfrbpq_1
Xfanout207 _6782_/A fanout208/X vddd vssd sg13cmos5l_buf_1
Xfanout229 _6299_/A _4179_/A1 vddd vssd sg13cmos5l_buf_1
X_4264_ wire2/A _4262_/Y _4263_/Y wire76/X vddd vssd sg13cmos5l_o21ai_1
Xfanout218 _6952_/A _6951_/A vddd vssd sg13cmos5l_buf_1
XFILLER_25_2559 vddd vssd sg13cmos5l_decap_8
X_6003_ _6003_/Y _6272_/A _5008_/B _5010_/B vddd vssd sg13cmos5l_a21oi_1
X_4195_ _4195_/Y _3896_/A _3718_/Y wire90/X _7266_/Q vddd vssd sg13cmos5l_a22oi_1
XFILLER_7_2480 vddd vssd sg13cmos5l_decap_8
XFILLER_3_2355 vddd vssd sg13cmos5l_decap_4
XFILLER_3_1665 vddd vssd sg13cmos5l_decap_8
X_6836_ _6836_/Y _6914_/A _6914_/B_N vddd vssd sg13cmos5l_nor2b_1
X_6767_ _6767_/Y _6767_/A wire49/X vddd vssd sg13cmos5l_nand2_1
X_3979_ _3979_/Y _7048_/Q _6718_/A _6711_/A vddd vssd sg13cmos5l_o21ai_1
X_5718_ _5718_/Y _5718_/A _5718_/B vddd vssd sg13cmos5l_nand2_1
XFILLER_10_249 vddd vssd sg13cmos5l_decap_4
X_6698_ _7029_/D _6704_/A1 _6709_/S hold943/X vddd vssd sg13cmos5l_a21oi_1
X_5649_ _5649_/Y _5649_/A _5649_/B _5649_/C _5649_/D vddd vssd sg13cmos5l_nor4_1
X_7319_ _7319_/Q _7328_/CLK _7319_/D _7319_/RESET_B vddd vssd sg13cmos5l_dfrbpq_1
XFILLER_8_2211 vddd vssd sg13cmos5l_decap_4
XFILLER_8_2255 vddd vssd sg13cmos5l_decap_8
XFILLER_24_2025 vddd vssd sg13cmos5l_decap_8
XFILLER_8_1532 vddd vssd sg13cmos5l_decap_8
XFILLER_24_2058 vddd vssd sg13cmos5l_decap_8
XFILLER_26_371 vddd vssd sg13cmos5l_decap_8
XFILLER_14_70 vddd vssd sg13cmos5l_decap_8
XFILLER_13_2485 vddd vssd sg13cmos5l_decap_8
XFILLER_6_787 vddd vssd sg13cmos5l_decap_8
XFILLER_29_1279 vddd vssd sg13cmos5l_decap_8
XFILLER_0_2517 vddd vssd sg13cmos5l_decap_8
XFILLER_4_1941 vddd vssd sg13cmos5l_decap_8
XFILLER_0_1827 vddd vssd sg13cmos5l_decap_8
XFILLER_4_1996 vddd vssd sg13cmos5l_decap_8
XFILLER_20_1777 vddd vssd sg13cmos5l_decap_4
X_4951_ _4951_/Y _4952_/A _4954_/B vddd vssd sg13cmos5l_nand2_1
X_4882_ _4890_/D _4894_/B _4882_/B vddd vssd sg13cmos5l_or2_1
X_3902_ _6568_/A _3902_/A _3902_/B _3924_/A vddd vssd sg13cmos5l_nor3_1
XFILLER_32_352 vddd vssd sg13cmos5l_decap_8
X_3833_ _3833_/Y _3624_/Y _4244_/A2 _3828_/Y _3829_/Y _3831_/X vddd vssd sg13cmos5l_a221oi_1
XFILLER_20_503 vddd vssd sg13cmos5l_decap_4
X_6621_ _6626_/S _6621_/A _6736_/B vddd vssd sg13cmos5l_nor2_1
XFILLER_20_536 vddd vssd sg13cmos5l_decap_8
XFILLER_18_1673 vddd vssd sg13cmos5l_decap_8
XFILLER_31_2541 vddd vssd sg13cmos5l_decap_8
XFILLER_14_1559 vddd vssd sg13cmos5l_decap_8
X_3764_ _3764_/Y _3791_/A _4267_/B _3763_/Y vddd vssd sg13cmos5l_o21ai_1
X_6552_ _6552_/Y _6552_/A _6552_/B vddd vssd sg13cmos5l_nor2_1
X_6483_ _6489_/S _6483_/A _6545_/B vddd vssd sg13cmos5l_nand2_1
X_3695_ _4206_/A _3981_/A _3925_/A vddd vssd sg13cmos5l_nand2_1
X_5503_ _5503_/Y _5495_/D _5502_/Y _5480_/Y vddd vssd sg13cmos5l_a21oi_1
X_5434_ _5434_/X _5464_/A _5441_/B vddd vssd sg13cmos5l_or2_1
Xoutbuffers\[86\] io_out[1] _6031_/Y vddd vssd sg13cmos5l_buf_16
XFILLER_9_2520 vddd vssd sg13cmos5l_decap_8
X_5365_ _5393_/C _5373_/A _7159_/Q vddd vssd sg13cmos5l_nor2_1
X_7104_ _7104_/Q _7268_/CLK _7104_/D _6957_/B_N vddd vssd sg13cmos5l_dfrbpq_1
XFILLER_29_2492 vddd vssd sg13cmos5l_decap_8
XFILLER_25_2356 vddd vssd sg13cmos5l_decap_8
X_5296_ _5302_/A _7148_/Q _5295_/Y vddd vssd sg13cmos5l_nor2b_1
X_4316_ _4316_/Y _4304_/B _4315_/Y hold591/X vddd vssd sg13cmos5l_a21oi_1
XFILLER_25_1633 vddd vssd sg13cmos5l_decap_8
X_7035_ _7035_/Q _7289_/CLK _7035_/D fanout374/X vddd vssd sg13cmos5l_dfrbpq_1
X_4247_ _4247_/Y _7058_/Q _6739_/A _6390_/A vddd vssd sg13cmos5l_o21ai_1
XFILLER_25_1688 vddd vssd sg13cmos5l_decap_8
XFILLER_21_1508 vddd vssd sg13cmos5l_decap_8
X_4178_ wire3/A _4176_/Y _4177_/Y _3751_/Y vddd vssd sg13cmos5l_o21ai_1
XFILLER_28_647 vddd vssd sg13cmos5l_decap_8
XFILLER_27_124 vddd vssd sg13cmos5l_decap_8
XFILLER_3_1451 vddd vssd sg13cmos5l_decap_4
X_6819_ _6819_/Y _6879_/A _6819_/B_N vddd vssd sg13cmos5l_nor2b_1
XFILLER_32_1604 vddd vssd sg13cmos5l_decap_8
XFILLER_10_2603 vddd vssd sg13cmos5l_decap_4
XFILLER_24_1110 vddd vssd sg13cmos5l_decap_8
XFILLER_8_1351 vddd vssd sg13cmos5l_decap_8
XFILLER_4_1226 vddd vssd sg13cmos5l_decap_8
Xtiedowns\[18\] _5784_/A vddd vssd sg13cmos5l_antennanp
XFILLER_15_2514 vddd vssd sg13cmos5l_decap_8
XFILLER_15_886 vddd vssd sg13cmos5l_decap_4
XFILLER_30_856 vddd vssd sg13cmos5l_decap_4
X_3480_ _3480_/Y _4562_/A vddd vssd sg13cmos5l_inv_1
X_5150_ _5151_/D _5150_/A _5150_/B _5150_/C _6103_/D vddd vssd sg13cmos5l_or4_1
X_4101_ _4101_/Y _7275_/Q wire88/X _4099_/X _4100_/Y wire89/X vddd vssd sg13cmos5l_a221oi_1
X_5081_ _6072_/B _5081_/A vddd vssd sg13cmos5l_inv_1
X_4032_ _4032_/Y _4023_/Y _4030_/Y _4031_/Y vddd vssd sg13cmos5l_o21ai_1
XFILLER_0_1602 vddd vssd sg13cmos5l_decap_8
XFILLER_24_105 vddd vssd sg13cmos5l_decap_8
X_5983_ _5983_/X _5983_/A0 _3928_/A _5991_/S vddd vssd sg13cmos5l_mux2_1
XFILLER_0_1646 vddd vssd sg13cmos5l_decap_8
X_4934_ _4934_/Y _4934_/A _4934_/B vddd vssd sg13cmos5l_nand2_1
XFILLER_21_801 vddd vssd sg13cmos5l_decap_8
XFILLER_32_182 vddd vssd sg13cmos5l_decap_8
XANTENNA_23 _7051_/Q vddd vssd sg13cmos5l_antennanp
XANTENNA_12 SDI vddd vssd sg13cmos5l_antennanp
X_4865_ _4865_/Y _4832_/Y _4864_/Y hold736/X vddd vssd sg13cmos5l_o21ai_1
XANTENNA_45 _7057_/Q vddd vssd sg13cmos5l_antennanp
XFILLER_21_867 vddd vssd sg13cmos5l_decap_8
X_3816_ _3816_/Y _3860_/A _4267_/B _7023_/D vddd vssd sg13cmos5l_o21ai_1
X_4796_ _4796_/Y _4812_/B _3594_/Y _4487_/Y _4803_/B vddd vssd sg13cmos5l_a22oi_1
X_6604_ _6604_/Y _6604_/A _6608_/S vddd vssd sg13cmos5l_nor2_1
XANTENNA_34 _6803_/A vddd vssd sg13cmos5l_antennanp
X_3747_ _3747_/Y _3679_/Y _3743_/Y _3746_/Y vddd vssd sg13cmos5l_a21oi_1
X_6535_ _6535_/Y _6535_/A1 _6536_/B _6534_/Y vddd vssd sg13cmos5l_a21oi_1
XFILLER_14_1334 vddd vssd sg13cmos5l_decap_8
XFILLER_21_49 vddd vssd sg13cmos5l_decap_8
XFILLER_10_1209 vddd vssd sg13cmos5l_decap_8
X_6466_ _6466_/X _6472_/A hold881/X _6467_/S vddd vssd sg13cmos5l_mux2_1
X_3678_ wire85/A _6301_/A _3955_/A vddd vssd sg13cmos5l_nor2_1
XFILLER_27_2429 vddd vssd sg13cmos5l_decap_8
X_6397_ _7146_/D _6748_/A1 _6401_/S hold990/X vddd vssd sg13cmos5l_a21oi_1
X_5417_ _5417_/Y _5417_/A _5416_/Y vddd vssd sg13cmos5l_nor2b_1
Xclkbuf_3_7_0_SCK_regs clkload9/A clkbuf_0_SCK_regs/X vddd vssd sg13cmos5l_buf_8
X_5348_ _5348_/Y _5544_/A _5348_/B _5348_/C vddd vssd sg13cmos5l_nand3b_1
XFILLER_25_2164 vddd vssd sg13cmos5l_decap_8
XFILLER_9_2372 vddd vssd sg13cmos5l_decap_8
X_7018_ _7018_/Q _7020_/CLK _7018_/D _6965_/Y vddd vssd sg13cmos5l_dfrbpq_1
XFILLER_5_1524 vddd vssd sg13cmos5l_decap_8
X_5279_ _5279_/Y _5279_/A _5279_/B vddd vssd sg13cmos5l_nand2_1
XFILLER_29_978 vddd vssd sg13cmos5l_decap_8
XFILLER_28_499 vddd vssd sg13cmos5l_decap_8
XFILLER_19_1212 vddd vssd sg13cmos5l_decap_8
XFILLER_23_182 vddd vssd sg13cmos5l_decap_8
XFILLER_32_1401 vddd vssd sg13cmos5l_decap_8
XFILLER_32_1478 vddd vssd sg13cmos5l_decap_4
XFILLER_10_2477 vddd vssd sg13cmos5l_decap_8
XFILLER_30_1191 vddd vssd sg13cmos5l_decap_4
XFILLER_2_0 vddd vssd sg13cmos5l_decap_8
XFILLER_10_1787 vddd vssd sg13cmos5l_decap_8
Xfanout390 fanout390/X fanout392/X vddd vssd sg13cmos5l_buf_1
XFILLER_19_422 vddd vssd sg13cmos5l_decap_8
XFILLER_21_2584 vddd vssd sg13cmos5l_decap_8
X_4650_ _4650_/Y _4650_/A _4650_/B vddd vssd sg13cmos5l_nor2_1
X_3601_ _3601_/Y _7112_/Q vddd vssd sg13cmos5l_inv_1
X_4581_ _4581_/Y _4581_/A _4581_/B vddd vssd sg13cmos5l_nor2_1
XFILLER_13_2090 vddd vssd sg13cmos5l_decap_8
X_6320_ _6320_/Y hold831/X _6321_/B _6319_/Y vddd vssd sg13cmos5l_o21ai_1
Xhold827 _6977_/D _5943_/Y vddd vssd sg13cmos5l_dlygate4sd3_1
Xhold816 hold816/X _4934_/A vddd vssd sg13cmos5l_dlygate4sd3_1
Xhold805 _7135_/D _6372_/X vddd vssd sg13cmos5l_dlygate4sd3_1
X_3532_ _3532_/Y _3532_/A vddd vssd sg13cmos5l_inv_1
XFILLER_7_893 vddd vssd sg13cmos5l_decap_4
Xhold838 _7132_/D _6369_/X vddd vssd sg13cmos5l_dlygate4sd3_1
Xhold849 _7364_/D _4338_/X vddd vssd sg13cmos5l_dlygate4sd3_1
X_6251_ _6251_/Y _6251_/A _6251_/B _6251_/C vddd vssd sg13cmos5l_nor3_1
X_5202_ _5257_/B _7272_/Q _7273_/Q vddd vssd sg13cmos5l_nand2b_1
X_6182_ _6182_/Y _5217_/A _6180_/Y _5195_/Y vddd vssd sg13cmos5l_a21oi_1
XFILLER_6_2501 vddd vssd sg13cmos5l_decap_8
XFILLER_26_2451 vddd vssd sg13cmos5l_decap_8
X_5133_ _5134_/D _5133_/A _5271_/A _5133_/C _5133_/D vddd vssd sg13cmos5l_nand4_1
Xhold1505 hold892/A _7306_/Q vddd vssd sg13cmos5l_dlygate4sd3_1
Xhold1516 _3659_/A0 _7364_/Q vddd vssd sg13cmos5l_dlygate4sd3_1
XFILLER_6_2578 vddd vssd sg13cmos5l_decap_8
Xoutbuffers\[49\] bandgap_trim[10] _6295_/Y vddd vssd sg13cmos5l_buf_16
XFILLER_26_1783 vddd vssd sg13cmos5l_decap_8
X_5064_ _6037_/B _7276_/Q _7277_/Q _5240_/A vddd vssd sg13cmos5l_or3_1
X_4015_ _4015_/Y _4015_/A _4015_/B _4015_/C vddd vssd sg13cmos5l_nor3_1
XFILLER_22_1669 vddd vssd sg13cmos5l_decap_8
XFILLER_0_2100 vddd vssd sg13cmos5l_decap_8
XFILLER_20_1360 vddd vssd sg13cmos5l_decap_8
XFILLER_16_49 vddd vssd sg13cmos5l_decap_8
X_5966_ _5969_/A _5966_/A _5966_/B _5966_/C vddd vssd sg13cmos5l_nand3_1
X_5897_ _5897_/Y _7230_/Q _7231_/Q _5897_/C vddd vssd sg13cmos5l_nor3_1
X_4917_ _4917_/Y hold910/X _4916_/C _4916_/Y vddd vssd sg13cmos5l_o21ai_1
X_4848_ _4848_/Y _3647_/C _4847_/Y _4867_/A vddd vssd sg13cmos5l_a21oi_1
XFILLER_21_675 vddd vssd sg13cmos5l_decap_8
X_4779_ _4784_/A _4798_/A _4778_/Y _4507_/A vddd vssd sg13cmos5l_o21ai_1
X_6518_ _7211_/D hold994/X _6520_/B _6517_/Y vddd vssd sg13cmos5l_a21oi_1
X_6449_ _7175_/D _6449_/A1 _6451_/B _6448_/Y vddd vssd sg13cmos5l_a21oi_1
XFILLER_27_1536 vddd vssd sg13cmos5l_decap_8
XFILLER_0_546 vddd vssd sg13cmos5l_decap_8
XFILLER_5_2044 vddd vssd sg13cmos5l_decap_8
XFILLER_29_742 vddd vssd sg13cmos5l_decap_4
XFILLER_5_1398 vddd vssd sg13cmos5l_decap_8
XFILLER_16_436 vddd vssd sg13cmos5l_decap_8
XFILLER_16_1930 vddd vssd sg13cmos5l_decap_4
XFILLER_12_664 vddd vssd sg13cmos5l_decap_8
XFILLER_12_675 vddd vssd sg13cmos5l_decap_4
XFILLER_12_2528 vddd vssd sg13cmos5l_decap_8
XFILLER_22_70 vddd vssd sg13cmos5l_decap_8
XFILLER_16_1985 vddd vssd sg13cmos5l_decap_8
XFILLER_8_657 vddd vssd sg13cmos5l_decap_8
XFILLER_32_1275 vddd vssd sg13cmos5l_decap_8
XFILLER_4_841 vddd vssd sg13cmos5l_decap_4
XFILLER_4_885 vddd vssd sg13cmos5l_decap_4
XFILLER_10_1573 vddd vssd sg13cmos5l_decap_4
XFILLER_3_373 vddd vssd sg13cmos5l_decap_4
XFILLER_21_1691 vddd vssd sg13cmos5l_decap_8
X_5820_ _5820_/Y _5875_/A _5813_/D _5806_/Y _5733_/A vddd vssd sg13cmos5l_a22oi_1
X_5751_ _5758_/B _7213_/Q _5762_/A vddd vssd sg13cmos5l_nor2b_1
XFILLER_17_1749 vddd vssd sg13cmos5l_decap_8
X_4702_ _4702_/Y _4656_/A _4701_/X _4746_/B1 vddd vssd sg13cmos5l_o21ai_1
X_5682_ _5705_/B _5682_/A vddd vssd sg13cmos5l_inv_1
X_4633_ _4633_/Y _4656_/A _4633_/B vddd vssd sg13cmos5l_nor2_1
X_4564_ _4564_/Y _4553_/Y _4561_/Y _4804_/B1 vddd vssd sg13cmos5l_o21ai_1
X_7352_ _7352_/Q _7355_/CLK _7352_/D _6866_/Y vddd vssd sg13cmos5l_dfrbpq_1
Xhold602 _4847_/A _7328_/Q vddd vssd sg13cmos5l_dlygate4sd3_1
XFILLER_28_2524 vddd vssd sg13cmos5l_decap_8
X_7283_ _7283_/Q _7285_/CLK _7283_/D fanout379/X vddd vssd sg13cmos5l_dfrbpq_1
Xhold624 _3495_/A _7348_/Q vddd vssd sg13cmos5l_dlygate4sd3_1
X_6303_ _6303_/Y _6782_/A _6805_/B hold701/X vddd vssd sg13cmos5l_a21oi_1
X_3515_ _5247_/B _3515_/A vddd vssd sg13cmos5l_inv_1
Xhold613 _4836_/B _7330_/Q vddd vssd sg13cmos5l_dlygate4sd3_1
Xhold635 _7124_/D _6356_/Y vddd vssd sg13cmos5l_dlygate4sd3_1
X_4495_ _4495_/Y _4496_/A _4511_/C vddd vssd sg13cmos5l_xnor2_1
Xhold646 hold646/X _6361_/Y vddd vssd sg13cmos5l_dlygate4sd3_1
X_6234_ _6234_/Y _6229_/Y _6230_/X _6233_/Y vddd vssd sg13cmos5l_o21ai_1
Xhold657 _6349_/A _7121_/Q vddd vssd sg13cmos5l_dlygate4sd3_1
Xhold679 _4828_/A _7399_/Q vddd vssd sg13cmos5l_dlygate4sd3_1
Xhold668 hold668/X _6374_/Y vddd vssd sg13cmos5l_dlygate4sd3_1
X_6165_ _6165_/Y _3521_/Y _7322_/Q _6278_/A1 vddd vssd sg13cmos5l_o21ai_1
Xhold1302 _7066_/D _6752_/X vddd vssd sg13cmos5l_dlygate4sd3_1
X_5116_ _5132_/C _7278_/Q _7279_/Q _5174_/B vddd vssd sg13cmos5l_nor3_1
Xhold1324 _6717_/A0 _7044_/Q vddd vssd sg13cmos5l_dlygate4sd3_1
X_6096_ _6096_/Y _6276_/A _5131_/A _7294_/Q vddd vssd sg13cmos5l_a21oi_1
Xhold1313 _3623_/A _7241_/Q vddd vssd sg13cmos5l_dlygate4sd3_1
Xhold1335 _7042_/D _6715_/X vddd vssd sg13cmos5l_dlygate4sd3_1
X_5047_ _5069_/A _5212_/A _5212_/B _5096_/C vddd vssd sg13cmos5l_nand3b_1
Xhold1368 _6469_/A _5581_/A vddd vssd sg13cmos5l_dlygate4sd3_1
Xhold1357 _6681_/A1 _5830_/B vddd vssd sg13cmos5l_dlygate4sd3_1
Xhold1346 _7294_/D _6660_/Y vddd vssd sg13cmos5l_dlygate4sd3_1
Xhold1379 _6683_/A0 _7320_/Q vddd vssd sg13cmos5l_dlygate4sd3_1
X_6998_ _6998_/Q _7020_/CLK _6998_/D _6945_/Y vddd vssd sg13cmos5l_dfrbpq_1
X_5949_ _5977_/A _7238_/Q _7239_/Q _5972_/A _7241_/Q vddd vssd sg13cmos5l_nor4_1
XFILLER_16_1237 vddd vssd sg13cmos5l_decap_8
XFILLER_32_704 vddd vssd sg13cmos5l_decap_8
XFILLER_17_70 vddd vssd sg13cmos5l_decap_8
XFILLER_1_1059 vddd vssd sg13cmos5l_decap_8
XFILLER_32_759 vddd vssd sg13cmos5l_decap_8
XFILLER_12_450 vddd vssd sg13cmos5l_decap_8
XFILLER_16_1760 vddd vssd sg13cmos5l_decap_4
XFILLER_12_483 vddd vssd sg13cmos5l_decap_8
XFILLER_12_1613 vddd vssd sg13cmos5l_decap_4
XFILLER_12_2358 vddd vssd sg13cmos5l_decap_8
XFILLER_8_498 vddd vssd sg13cmos5l_decap_8
XFILLER_12_2369 vddd vssd sg13cmos5l_decap_4
XFILLER_12_1679 vddd vssd sg13cmos5l_decap_8
XFILLER_10_2093 vddd vssd sg13cmos5l_decap_8
XFILLER_28_1119 vddd vssd sg13cmos5l_decap_8
X_4280_ _7381_/D _6713_/A1 _4279_/B _4279_/Y vddd vssd sg13cmos5l_o21ai_1
XFILLER_27_2590 vddd vssd sg13cmos5l_decap_8
XFILLER_23_2454 vddd vssd sg13cmos5l_decap_8
XFILLER_23_1764 vddd vssd sg13cmos5l_decap_4
X_6921_ _6921_/Y _6923_/A _6923_/B_N vddd vssd sg13cmos5l_nor2b_1
X_6852_ _6852_/Y _6956_/A _6956_/B_N vddd vssd sg13cmos5l_nor2b_1
XFILLER_17_2214 vddd vssd sg13cmos5l_decap_8
X_5803_ _5803_/Y _5813_/C _7317_/Q vddd vssd sg13cmos5l_nor2_1
XFILLER_17_1502 vddd vssd sg13cmos5l_decap_8
X_6783_ _7084_/D _4533_/A _6784_/B _6782_/Y vddd vssd sg13cmos5l_a21oi_1
X_3995_ _3995_/Y mask_rev_in[11] wire85/X _4262_/A2 vddd vssd sg13cmos5l_a21oi_1
X_5734_ _5734_/Y _5734_/A _5734_/B vddd vssd sg13cmos5l_nand2_1
XFILLER_13_28 vddd vssd sg13cmos5l_decap_8
X_5665_ _5669_/B _5677_/C _5670_/C vddd vssd sg13cmos5l_nor2_1
XFILLER_30_2469 vddd vssd sg13cmos5l_decap_8
X_4616_ _4616_/Y _4616_/A _4732_/B vddd vssd sg13cmos5l_nand2_1
XFILLER_15_1281 vddd vssd sg13cmos5l_decap_8
X_7404_ _7404_/Q _7404_/CLK _7404_/D _6917_/Y vddd vssd sg13cmos5l_dfrbpq_1
XFILLER_11_1112 vddd vssd sg13cmos5l_decap_8
X_5596_ _5609_/A _5613_/A _5596_/B vddd vssd sg13cmos5l_nor2_1
X_7335_ _7335_/Q _7335_/CLK _7335_/D _6849_/Y vddd vssd sg13cmos5l_dfrbpq_1
X_4547_ _4547_/Y _4547_/A _4547_/B _4547_/C vddd vssd sg13cmos5l_nor3_1
Xhold476 _4934_/A hold815/X vddd vssd sg13cmos5l_dlygate4sd3_1
X_4478_ _4478_/Y _4461_/B _4477_/Y _4456_/Y vddd vssd sg13cmos5l_a21oi_1
Xhold487 sram_addr[0] _5979_/X vddd vssd sg13cmos5l_dlygate4sd3_1
X_7266_ _7266_/Q _7297_/CLK _7266_/D fanout381/X vddd vssd sg13cmos5l_dfrbpq_1
XFILLER_28_2398 vddd vssd sg13cmos5l_decap_8
XFILLER_28_1642 vddd vssd sg13cmos5l_decap_8
X_7197_ _7197_/Q _7201_/CLK _7197_/D fanout367/X vddd vssd sg13cmos5l_dfrbpq_1
Xhold498 _4733_/B hold498/A vddd vssd sg13cmos5l_dlygate4sd3_1
X_6217_ _6217_/Y _7321_/Q _6232_/B vddd vssd sg13cmos5l_nor2b_1
XFILLER_8_1714 vddd vssd sg13cmos5l_decap_8
XFILLER_8_2459 vddd vssd sg13cmos5l_decap_8
XFILLER_28_1675 vddd vssd sg13cmos5l_decap_4
XFILLER_24_1528 vddd vssd sg13cmos5l_decap_8
X_6148_ _6148_/Y _4114_/X _6147_/A _5186_/A vddd vssd sg13cmos5l_o21ai_1
XFILLER_8_1758 vddd vssd sg13cmos5l_decap_8
Xhold1110 _6658_/A0 _7293_/Q vddd vssd sg13cmos5l_dlygate4sd3_1
Xhold1132 _3580_/A _7215_/Q vddd vssd sg13cmos5l_dlygate4sd3_1
Xhold1121 _3520_/A _7295_/Q vddd vssd sg13cmos5l_dlygate4sd3_1
Xhold1154 _6644_/A0 _7284_/Q vddd vssd sg13cmos5l_dlygate4sd3_1
Xhold1165 _7273_/D _6626_/X vddd vssd sg13cmos5l_dlygate4sd3_1
Xhold1176 _6511_/A0 _7208_/Q vddd vssd sg13cmos5l_dlygate4sd3_1
X_6079_ _6079_/Y _6278_/A1 _6058_/Y _6078_/Y vddd vssd sg13cmos5l_o21ai_1
Xhold1143 _6537_/A1 _5813_/C vddd vssd sg13cmos5l_dlygate4sd3_1
XFILLER_26_531 vddd vssd sg13cmos5l_decap_8
Xhold1187 _7257_/D _6602_/X vddd vssd sg13cmos5l_dlygate4sd3_1
Xhold1198 _7220_/D _6535_/Y vddd vssd sg13cmos5l_dlygate4sd3_1
XFILLER_2_1379 vddd vssd sg13cmos5l_decap_8
XFILLER_13_214 vddd vssd sg13cmos5l_decap_8
XFILLER_13_269 vddd vssd sg13cmos5l_decap_8
XFILLER_16_1067 vddd vssd sg13cmos5l_decap_8
XFILLER_13_1944 vddd vssd sg13cmos5l_decap_8
XFILLER_10_976 vddd vssd sg13cmos5l_decap_8
XFILLER_29_2129 vddd vssd sg13cmos5l_decap_8
Xtiedowns\[48\] mask_rev_in[4] vddd vssd sg13cmos5l_antennanp
XFILLER_20_1915 vddd vssd sg13cmos5l_decap_8
XFILLER_20_1948 vddd vssd sg13cmos5l_decap_8
XFILLER_18_2556 vddd vssd sg13cmos5l_decap_8
XFILLER_32_589 vddd vssd sg13cmos5l_decap_8
X_3780_ _3781_/C _7110_/Q _4253_/A _4172_/A2 _7094_/Q vddd vssd sg13cmos5l_a22oi_1
X_5450_ _5475_/C _7170_/Q _5459_/B vddd vssd sg13cmos5l_nand2_1
XFILLER_9_774 vddd vssd sg13cmos5l_decap_8
XFILLER_12_2166 vddd vssd sg13cmos5l_decap_8
X_4401_ _4417_/B _4416_/A _4419_/B vddd vssd sg13cmos5l_and2_1
X_5381_ _5381_/Y _5319_/A _5374_/B _5379_/Y vddd vssd sg13cmos5l_o21ai_1
X_4332_ _4332_/Y hold719/X _4326_/Y _4327_/Y vddd vssd sg13cmos5l_a21oi_1
X_7120_ _7120_/Q _7264_/CLK _7120_/D _6954_/B_N vddd vssd sg13cmos5l_dfrbpq_1
XFILLER_29_1940 vddd vssd sg13cmos5l_decap_8
X_7051_ _7051_/Q _7300_/CLK _7051_/D fanout377/X vddd vssd sg13cmos5l_dfrbpq_1
XFILLER_25_2538 vddd vssd sg13cmos5l_decap_8
Xfanout219 _6965_/A _6966_/A vddd vssd sg13cmos5l_buf_1
X_4263_ _4263_/Y mask_rev_in[24] _4263_/B vddd vssd sg13cmos5l_nor2_1
XFILLER_5_84 vddd vssd sg13cmos5l_decap_8
Xfanout208 fanout208/X hold1390/X vddd vssd sg13cmos5l_buf_1
X_6002_ _6002_/Y _5999_/Y _6000_/Y _6001_/Y vddd vssd sg13cmos5l_o21ai_1
X_4194_ _4194_/Y _7270_/Q _6621_/A vddd vssd sg13cmos5l_nor2_1
XFILLER_3_2301 vddd vssd sg13cmos5l_decap_8
Xoutbuffers\[31\] bandgap_sink2[1] _7066_/Q vddd vssd sg13cmos5l_buf_16
XFILLER_3_1644 vddd vssd sg13cmos5l_decap_8
XFILLER_24_49 vddd vssd sg13cmos5l_decap_8
X_6835_ _6835_/Y _6835_/A _6835_/B_N vddd vssd sg13cmos5l_nor2b_1
XFILLER_32_2509 vddd vssd sg13cmos5l_decap_8
X_6766_ _6766_/Y hold984/X wire49/X _6765_/Y vddd vssd sg13cmos5l_o21ai_1
X_3978_ _3978_/Y _7053_/Q _4244_/A2 _3976_/Y _3977_/Y _3831_/X vddd vssd sg13cmos5l_a221oi_1
XFILLER_17_1343 vddd vssd sg13cmos5l_decap_8
XFILLER_11_718 vddd vssd sg13cmos5l_decap_4
XFILLER_10_217 vddd vssd sg13cmos5l_decap_8
X_5717_ _5718_/B _5721_/A _7207_/Q _5713_/B _5807_/A1 _5715_/Y vddd vssd sg13cmos5l_a221oi_1
X_6697_ _6697_/Y _6697_/A _6709_/S vddd vssd sg13cmos5l_nor2_1
XFILLER_30_1532 vddd vssd sg13cmos5l_decap_4
X_5648_ _5649_/D _5730_/A _5648_/B vddd vssd sg13cmos5l_and2_1
X_5579_ _5579_/Y _5579_/A _5581_/C vddd vssd sg13cmos5l_nor2_1
XFILLER_3_928 vddd vssd sg13cmos5l_decap_8
XFILLER_6_7 vddd vssd sg13cmos5l_decap_4
X_7318_ _7318_/Q _7398_/CLK _7318_/D _7318_/RESET_B vddd vssd sg13cmos5l_dfrbpq_1
XFILLER_24_2004 vddd vssd sg13cmos5l_decap_8
X_7249_ _7249_/Q _7291_/CLK _7249_/D fanout380/X vddd vssd sg13cmos5l_dfrbpq_1
XFILLER_8_1511 vddd vssd sg13cmos5l_decap_8
XFILLER_24_1325 vddd vssd sg13cmos5l_decap_8
XFILLER_8_1599 vddd vssd sg13cmos5l_decap_8
XFILLER_22_1071 vddd vssd sg13cmos5l_decap_8
XFILLER_14_556 vddd vssd sg13cmos5l_decap_4
XFILLER_13_2464 vddd vssd sg13cmos5l_decap_8
XFILLER_6_711 vddd vssd sg13cmos5l_decap_8
XFILLER_6_733 vddd vssd sg13cmos5l_decap_8
XFILLER_6_766 vddd vssd sg13cmos5l_decap_8
XFILLER_29_1247 vddd vssd sg13cmos5l_decap_8
XFILLER_24_2593 vddd vssd sg13cmos5l_decap_8
XFILLER_20_1723 vddd vssd sg13cmos5l_decap_8
XFILLER_20_2479 vddd vssd sg13cmos5l_decap_8
XFILLER_20_1756 vddd vssd sg13cmos5l_decap_8
XFILLER_18_851 vddd vssd sg13cmos5l_decap_8
X_4950_ _7308_/D _4925_/A _4954_/B _4949_/Y vddd vssd sg13cmos5l_a21o_1
XFILLER_32_331 vddd vssd sg13cmos5l_decap_8
X_3901_ _3901_/X dbus_in_left[3] dbus_in_right[3] vddd vssd sg13cmos5l_or2_1
X_4881_ _4882_/B _4955_/A _7138_/Q _4894_/A vddd vssd sg13cmos5l_o21ai_1
X_3832_ _6718_/A _3984_/B _3944_/A vddd vssd sg13cmos5l_nand2_1
X_6620_ _6620_/X hold687/X _6336_/A _6620_/S vddd vssd sg13cmos5l_mux2_1
XFILLER_31_2520 vddd vssd sg13cmos5l_decap_8
XFILLER_14_1516 vddd vssd sg13cmos5l_decap_8
X_6551_ _7228_/D _6551_/A1 _6552_/B _6550_/Y vddd vssd sg13cmos5l_a21oi_1
X_3763_ _3763_/Y wire15/X wire29/X _3762_/Y vddd vssd sg13cmos5l_o21ai_1
X_5502_ _5502_/Y _5502_/A _7176_/Q _7177_/Q vddd vssd sg13cmos5l_nor3_1
XFILLER_31_2597 vddd vssd sg13cmos5l_decap_8
X_6482_ _6482_/Y _6482_/A1 _6481_/B _6481_/Y vddd vssd sg13cmos5l_a21oi_1
X_3694_ _3694_/Y _3980_/A _3924_/A vddd vssd sg13cmos5l_nor2_1
X_5433_ _5437_/B _5445_/C _5438_/C vddd vssd sg13cmos5l_nor2_1
X_5364_ _5394_/A _7158_/Q _7159_/Q _5386_/A _5374_/B vddd vssd sg13cmos5l_nor4_1
XFILLER_29_2471 vddd vssd sg13cmos5l_decap_8
X_7103_ _7103_/Q _7135_/CLK _7103_/D _6969_/B_N vddd vssd sg13cmos5l_dfrbpq_1
Xoutbuffers\[79\] io_oe[6] wire28/X vddd vssd sg13cmos5l_buf_16
X_4315_ _4315_/Y _4315_/A _4315_/B vddd vssd sg13cmos5l_nand2_1
XFILLER_25_2335 vddd vssd sg13cmos5l_decap_8
X_5295_ _5295_/Y _3539_/A _5306_/A _5294_/Y vddd vssd sg13cmos5l_o21ai_1
XFILLER_9_2576 vddd vssd sg13cmos5l_decap_8
XFILLER_29_1781 vddd vssd sg13cmos5l_decap_8
X_7034_ _7034_/Q _7289_/CLK _7034_/D fanout374/X vddd vssd sg13cmos5l_dfrbpq_1
X_4246_ _4246_/Y _7040_/Q _3836_/Y _4159_/B vddd vssd sg13cmos5l_a21oi_1
XFILLER_5_1706 vddd vssd sg13cmos5l_decap_8
XFILLER_19_49 vddd vssd sg13cmos5l_decap_8
X_4177_ _4177_/Y mask_rev_in[25] _3749_/Y _3786_/Y vddd vssd sg13cmos5l_o21ai_1
XFILLER_27_103 vddd vssd sg13cmos5l_decap_8
X_6818_ _6818_/Y _6879_/A _6819_/B_N vddd vssd sg13cmos5l_nor2b_1
X_6749_ _6749_/X _6405_/A _6749_/A1 _6752_/S vddd vssd sg13cmos5l_mux2_1
XFILLER_17_1195 vddd vssd sg13cmos5l_decap_8
XFILLER_30_1351 vddd vssd sg13cmos5l_decap_8
XFILLER_8_1330 vddd vssd sg13cmos5l_decap_8
XFILLER_24_1144 vddd vssd sg13cmos5l_decap_8
XFILLER_19_637 vddd vssd sg13cmos5l_decap_8
XFILLER_15_865 vddd vssd sg13cmos5l_decap_8
XFILLER_31_1104 vddd vssd sg13cmos5l_decap_4
XFILLER_19_1994 vddd vssd sg13cmos5l_decap_8
XFILLER_29_1033 vddd vssd sg13cmos5l_decap_8
XFILLER_9_1105 vddd vssd sg13cmos5l_decap_8
X_4100_ _4100_/Y _5020_/B wire91/X wire88/X vddd vssd sg13cmos5l_a21oi_1
X_5080_ _5081_/A _5245_/A _7251_/Q _5080_/C vddd vssd sg13cmos5l_nand3_1
X_4031_ _4031_/Y _6235_/A _6561_/A vddd vssd sg13cmos5l_nand2b_1
XFILLER_4_2462 vddd vssd sg13cmos5l_decap_8
XFILLER_20_2265 vddd vssd sg13cmos5l_decap_8
XFILLER_4_1772 vddd vssd sg13cmos5l_decap_8
X_5982_ _5982_/X hold907/X _3753_/A _5991_/S vddd vssd sg13cmos5l_mux2_1
X_4933_ _4934_/B _4935_/A _4943_/B _4931_/B vddd vssd sg13cmos5l_o21ai_1
XFILLER_32_161 vddd vssd sg13cmos5l_decap_8
XANTENNA_13 SDI vddd vssd sg13cmos5l_antennanp
X_4864_ _4864_/Y _4867_/A sram_odata[1] _4863_/Y vddd vssd sg13cmos5l_a21oi_1
XANTENNA_24 _7051_/Q vddd vssd sg13cmos5l_antennanp
XANTENNA_46 _7335_/Q vddd vssd sg13cmos5l_antennanp
X_4795_ _4803_/B _6808_/A _4795_/B vddd vssd sg13cmos5l_xor2_1
X_3815_ _3815_/Y _4179_/A1 sram_odata[5] _3756_/X wire22/X _4300_/B vddd vssd sg13cmos5l_a221oi_1
X_6603_ _6608_/S _6603_/A _6736_/B vddd vssd sg13cmos5l_nor2_1
XANTENNA_35 _6801_/A vddd vssd sg13cmos5l_antennanp
XFILLER_14_1302 vddd vssd sg13cmos5l_decap_8
XFILLER_21_28 vddd vssd sg13cmos5l_decap_8
X_3746_ _3746_/Y mask_rev_in[15] _3679_/Y _3745_/Y vddd vssd sg13cmos5l_o21ai_1
X_6534_ _6534_/Y _6558_/A _6536_/B vddd vssd sg13cmos5l_nor2_1
XFILLER_31_2394 vddd vssd sg13cmos5l_decap_8
X_6465_ _7183_/D _6465_/A1 _6467_/S _6464_/Y vddd vssd sg13cmos5l_a21oi_1
XFILLER_27_2408 vddd vssd sg13cmos5l_decap_8
X_5416_ _5416_/Y _5416_/A _5416_/B _5416_/C vddd vssd sg13cmos5l_nand3_1
X_3677_ _3955_/A _3874_/B _3874_/C vddd vssd sg13cmos5l_or2_1
X_6396_ _6396_/Y _6396_/A _6401_/S vddd vssd sg13cmos5l_nor2_1
X_5347_ _5347_/Y _4781_/A _5340_/B _5346_/X vddd vssd sg13cmos5l_o21ai_1
XFILLER_25_2132 vddd vssd sg13cmos5l_decap_8
X_5278_ _5278_/Y _5278_/A vddd vssd sg13cmos5l_inv_1
X_7017_ _7017_/Q _7346_/CLK _7017_/D _6964_/Y vddd vssd sg13cmos5l_dfrbpq_1
XFILLER_21_2007 vddd vssd sg13cmos5l_decap_8
X_4229_ _4229_/Y _4225_/Y _4227_/Y _4228_/Y vddd vssd sg13cmos5l_o21ai_1
XFILLER_29_957 vddd vssd sg13cmos5l_decap_8
XFILLER_28_423 vddd vssd sg13cmos5l_decap_8
XFILLER_12_813 vddd vssd sg13cmos5l_decap_4
XFILLER_32_2103 vddd vssd sg13cmos5l_decap_4
XFILLER_23_161 vddd vssd sg13cmos5l_decap_8
XFILLER_32_2136 vddd vssd sg13cmos5l_decap_8
XFILLER_32_1457 vddd vssd sg13cmos5l_decap_8
XFILLER_10_1711 vddd vssd sg13cmos5l_decap_4
XFILLER_10_2456 vddd vssd sg13cmos5l_decap_8
XFILLER_26_1228 vddd vssd sg13cmos5l_decap_4
Xtiedowns\[30\] dbus_in_left[10] vddd vssd sg13cmos5l_antennanp
Xfanout391 _6958_/B_N fanout392/X vddd vssd sg13cmos5l_buf_1
Xfanout380 fanout380/X fanout410/X vddd vssd sg13cmos5l_buf_1
XFILLER_8_1171 vddd vssd sg13cmos5l_decap_8
XFILLER_21_2563 vddd vssd sg13cmos5l_decap_8
XFILLER_4_1035 vddd vssd sg13cmos5l_decap_8
XFILLER_15_673 vddd vssd sg13cmos5l_decap_8
XFILLER_19_2492 vddd vssd sg13cmos5l_decap_8
XFILLER_14_161 vddd vssd sg13cmos5l_decap_8
X_4580_ _4581_/B _4533_/A _4556_/Y _4461_/B vddd vssd sg13cmos5l_o21ai_1
X_3600_ _3600_/Y _3600_/A vddd vssd sg13cmos5l_inv_1
XFILLER_15_1655 vddd vssd sg13cmos5l_decap_8
XFILLER_11_890 vddd vssd sg13cmos5l_decap_8
X_3531_ _3531_/Y _3531_/A vddd vssd sg13cmos5l_inv_1
Xhold817 _7313_/D _4936_/Y vddd vssd sg13cmos5l_dlygate4sd3_1
Xhold828 _6515_/A _7210_/Q vddd vssd sg13cmos5l_dlygate4sd3_1
XFILLER_6_371 vddd vssd sg13cmos5l_decap_4
Xhold806 _3594_/A _7105_/Q vddd vssd sg13cmos5l_dlygate4sd3_1
Xhold839 hold839/X _7200_/Q vddd vssd sg13cmos5l_dlygate4sd3_1
X_6250_ _6251_/C _6272_/A _6250_/B vddd vssd sg13cmos5l_nor2_1
XFILLER_26_2430 vddd vssd sg13cmos5l_decap_8
X_5201_ _5216_/C _7278_/Q _7279_/Q _5262_/B vddd vssd sg13cmos5l_nor3_1
X_6181_ _6181_/Y _6272_/A _6181_/B _6181_/C vddd vssd sg13cmos5l_nand3_1
Xclkbuf_1_0__f_clk clkload0/A clkbuf_0_clk/X vddd vssd sg13cmos5l_buf_8
X_5132_ _5133_/D _5132_/A _5132_/B _5132_/C _5132_/D vddd vssd sg13cmos5l_nor4_1
XFILLER_28_0 vddd vssd sg13cmos5l_decap_8
Xhold1506 hold906/A _7307_/Q vddd vssd sg13cmos5l_dlygate4sd3_1
XFILLER_6_2557 vddd vssd sg13cmos5l_decap_8
X_5063_ _5240_/A _7274_/Q _7275_/Q vddd vssd sg13cmos5l_nand2b_1
X_4014_ _4015_/C _5211_/A _6646_/A _4012_/Y _4013_/Y _3865_/Y vddd vssd sg13cmos5l_a221oi_1
XFILLER_22_1637 vddd vssd sg13cmos5l_decap_8
XFILLER_20_2095 vddd vssd sg13cmos5l_decap_8
XFILLER_20_2073 vddd vssd sg13cmos5l_decap_8
XFILLER_16_28 vddd vssd sg13cmos5l_decap_8
XFILLER_0_1433 vddd vssd sg13cmos5l_decap_8
X_5965_ _5966_/C _5974_/B _5968_/C _5953_/Y vddd vssd sg13cmos5l_a21oi_1
X_4916_ _4916_/Y _4916_/A _4916_/B _4916_/C vddd vssd sg13cmos5l_nand3_1
X_5896_ _5896_/Y _5896_/A _5896_/B vddd vssd sg13cmos5l_nand2_1
XFILLER_21_643 vddd vssd sg13cmos5l_decap_4
X_4847_ _4847_/Y _4847_/A _4853_/B vddd vssd sg13cmos5l_nand2_1
XFILLER_32_49 vddd vssd sg13cmos5l_decap_8
X_4778_ _4778_/Y _4778_/A _4780_/B vddd vssd sg13cmos5l_xnor2_1
XFILLER_10_1007 vddd vssd sg13cmos5l_decap_8
X_3729_ _6329_/A _3734_/A wire96/X vddd vssd sg13cmos5l_nand2_1
X_6517_ _6517_/Y _6532_/A _6520_/B vddd vssd sg13cmos5l_nor2_1
X_6448_ _6448_/Y _6464_/A _6451_/B vddd vssd sg13cmos5l_nor2_1
X_6379_ _6379_/Y _6722_/A _6382_/B hold733/X vddd vssd sg13cmos5l_o21ai_1
XFILLER_0_525 vddd vssd sg13cmos5l_decap_8
XFILLER_5_2023 vddd vssd sg13cmos5l_decap_8
XFILLER_5_2056 vddd vssd sg13cmos5l_decap_8
XFILLER_29_754 vddd vssd sg13cmos5l_decap_8
Xwire90 wire90/X wire90/A vddd vssd sg13cmos5l_buf_2
XFILLER_19_1043 vddd vssd sg13cmos5l_decap_8
XFILLER_12_621 vddd vssd sg13cmos5l_decap_4
XFILLER_12_632 vddd vssd sg13cmos5l_decap_8
XFILLER_12_2507 vddd vssd sg13cmos5l_decap_8
XFILLER_32_1221 vddd vssd sg13cmos5l_decap_8
XFILLER_8_614 vddd vssd sg13cmos5l_decap_8
XFILLER_12_687 vddd vssd sg13cmos5l_decap_8
XFILLER_32_1254 vddd vssd sg13cmos5l_decap_8
XFILLER_11_186 vddd vssd sg13cmos5l_decap_8
Xtiedowns\[78\] clkload2/A vddd vssd sg13cmos5l_antennanp
XFILLER_10_1552 vddd vssd sg13cmos5l_decap_8
XFILLER_10_1596 vddd vssd sg13cmos5l_decap_4
XFILLER_26_1047 vddd vssd sg13cmos5l_decap_8
XFILLER_21_7 vddd vssd sg13cmos5l_decap_8
XFILLER_1_2410 vddd vssd sg13cmos5l_decap_8
XFILLER_21_2393 vddd vssd sg13cmos5l_decap_4
XFILLER_1_2454 vddd vssd sg13cmos5l_decap_8
Xclkbuf_leaf_17_SCK_regs _7289_/CLK clkload9/A vddd vssd sg13cmos5l_buf_8
X_5750_ _5756_/A _5748_/Y _5749_/Y _5762_/C vddd vssd sg13cmos5l_o21ai_1
X_5681_ _5682_/A _7204_/Q _7205_/Q vddd vssd sg13cmos5l_nor2_1
X_4701_ _4701_/X _6812_/A _7010_/D vddd vssd sg13cmos5l_xor2_1
X_4632_ _4633_/B _4632_/A _7013_/D vddd vssd sg13cmos5l_xor2_1
XFILLER_15_2164 vddd vssd sg13cmos5l_decap_8
XFILLER_15_1430 vddd vssd sg13cmos5l_decap_8
XFILLER_8_84 vddd vssd sg13cmos5l_decap_8
X_4563_ _4563_/Y _4803_/A _4563_/B vddd vssd sg13cmos5l_nor2_1
X_7351_ _7351_/Q _7357_/CLK _7351_/D _6865_/Y vddd vssd sg13cmos5l_dfrbpq_1
Xhold603 hold603/X _4846_/Y vddd vssd sg13cmos5l_dlygate4sd3_1
X_7282_ _7282_/Q _7286_/CLK _7282_/D fanout385/X vddd vssd sg13cmos5l_dfrbpq_1
XFILLER_28_2503 vddd vssd sg13cmos5l_decap_8
X_4494_ _4494_/X _4508_/C _4810_/B _4493_/Y vddd vssd sg13cmos5l_a21o_1
Xhold625 _7348_/D _4439_/X vddd vssd sg13cmos5l_dlygate4sd3_1
X_6302_ _6302_/Y _6302_/A _6805_/B vddd vssd sg13cmos5l_nor2_1
Xhold614 hold614/X _4836_/Y vddd vssd sg13cmos5l_dlygate4sd3_1
Xhold636 hold636/X _7401_/Q vddd vssd sg13cmos5l_dlygate4sd3_1
X_3514_ _5204_/B _3514_/A vddd vssd sg13cmos5l_inv_1
X_6233_ _6233_/Y _5871_/A _6231_/Y _6232_/Y vddd vssd sg13cmos5l_a21oi_1
Xhold658 hold658/X _6349_/Y vddd vssd sg13cmos5l_dlygate4sd3_1
Xhold669 _6353_/A _7123_/Q vddd vssd sg13cmos5l_dlygate4sd3_1
Xhold647 _7127_/D _6362_/Y vddd vssd sg13cmos5l_dlygate4sd3_1
Xoutbuffers\[61\] voltgen_ena[1] _7051_/Q vddd vssd sg13cmos5l_buf_16
X_6164_ _6164_/Y _6164_/A _6164_/B vddd vssd sg13cmos5l_nor2_1
X_5115_ _5174_/B _5224_/A _5223_/A vddd vssd sg13cmos5l_nand2b_1
Xhold1325 _7044_/D _6717_/X vddd vssd sg13cmos5l_dlygate4sd3_1
Xhold1303 _6695_/A1 _7028_/Q vddd vssd sg13cmos5l_dlygate4sd3_1
XFILLER_22_2146 vddd vssd sg13cmos5l_decap_8
X_6095_ _6095_/Y _6049_/A _5134_/C _6094_/Y vddd vssd sg13cmos5l_a21oi_1
Xhold1314 _6575_/A1 _5956_/A vddd vssd sg13cmos5l_dlygate4sd3_1
Xhold1347 _3570_/A _7201_/Q vddd vssd sg13cmos5l_dlygate4sd3_1
X_5046_ _6123_/B _5212_/A _5212_/B vddd vssd sg13cmos5l_nand2b_1
Xhold1336 _3589_/A _7227_/Q vddd vssd sg13cmos5l_dlygate4sd3_1
Xhold1358 hold1358/X _7230_/Q vddd vssd sg13cmos5l_dlygate4sd3_1
XFILLER_27_49 vddd vssd sg13cmos5l_decap_8
XFILLER_22_1478 vddd vssd sg13cmos5l_decap_8
Xhold1369 hold1369/X _7369_/Q vddd vssd sg13cmos5l_dlygate4sd3_1
XFILLER_26_735 vddd vssd sg13cmos5l_decap_8
XFILLER_25_201 vddd vssd sg13cmos5l_decap_8
X_6997_ _6997_/Q _7020_/CLK _6997_/D _6944_/Y vddd vssd sg13cmos5l_dfrbpq_1
X_5948_ _5974_/A _5972_/A _7241_/Q vddd vssd sg13cmos5l_nor2_1
X_5879_ _5895_/A _5901_/B _5901_/A vddd vssd sg13cmos5l_nand2b_1
XFILLER_21_484 vddd vssd sg13cmos5l_decap_4
XFILLER_11_2584 vddd vssd sg13cmos5l_decap_8
XFILLER_7_2129 vddd vssd sg13cmos5l_decap_8
XFILLER_27_1323 vddd vssd sg13cmos5l_decap_8
XFILLER_0_333 vddd vssd sg13cmos5l_decap_8
XFILLER_1_878 vddd vssd sg13cmos5l_decap_8
XFILLER_0_399 vddd vssd sg13cmos5l_decap_8
XFILLER_29_573 vddd vssd sg13cmos5l_decap_8
XFILLER_5_1152 vddd vssd sg13cmos5l_decap_4
XFILLER_32_738 vddd vssd sg13cmos5l_decap_8
XFILLER_31_226 vddd vssd sg13cmos5l_decap_8
Xclkbuf_4_9__f_clk_regs _7343_/CLK clkbuf_3_4_0_clk_regs/X vddd vssd sg13cmos5l_buf_8
XFILLER_16_2484 vddd vssd sg13cmos5l_decap_8
XFILLER_9_934 vddd vssd sg13cmos5l_decap_8
XFILLER_9_978 vddd vssd sg13cmos5l_decap_8
XFILLER_9_967 vddd vssd sg13cmos5l_decap_4
XFILLER_32_1095 vddd vssd sg13cmos5l_decap_8
XFILLER_10_2072 vddd vssd sg13cmos5l_decap_8
XFILLER_23_2433 vddd vssd sg13cmos5l_decap_8
XFILLER_23_1743 vddd vssd sg13cmos5l_decap_8
XFILLER_3_1826 vddd vssd sg13cmos5l_decap_4
X_6920_ _6920_/Y _6923_/A _6923_/B_N vddd vssd sg13cmos5l_nor2b_1
XFILLER_3_1859 vddd vssd sg13cmos5l_decap_8
XFILLER_1_1561 vddd vssd sg13cmos5l_decap_8
X_6851_ _6851_/Y _6956_/A _6956_/B_N vddd vssd sg13cmos5l_nor2b_1
Xfanout19 _4685_/A _4492_/X vddd vssd sg13cmos5l_buf_1
X_5802_ _5816_/A _7218_/Q _7219_/Q vddd vssd sg13cmos5l_nand2_1
X_6782_ _6782_/Y _6782_/A _6784_/B vddd vssd sg13cmos5l_nor2_1
XFILLER_17_1525 vddd vssd sg13cmos5l_decap_8
X_3994_ _3994_/Y _3533_/Y _4259_/B _3992_/X _3993_/Y _4172_/B1 vddd vssd sg13cmos5l_a221oi_1
Xoutbuffers\[5\] analog_bus_ena[3] _7039_/Q vddd vssd sg13cmos5l_buf_16
X_5733_ _5734_/B _5733_/A _5733_/B _5733_/C vddd vssd sg13cmos5l_nand3_1
XFILLER_30_2448 vddd vssd sg13cmos5l_decap_8
X_5664_ _5670_/C _5673_/A _5666_/B vddd vssd sg13cmos5l_nand2_1
X_4615_ _4617_/A _4684_/A _4613_/Y _4614_/Y vddd vssd sg13cmos5l_o21ai_1
X_5595_ _5596_/B _5595_/A _5595_/B vddd vssd sg13cmos5l_nor2_1
X_7403_ _7403_/Q _7403_/CLK _7403_/D _6916_/Y vddd vssd sg13cmos5l_dfrbpq_1
X_4546_ _4547_/C _4546_/A _4546_/B vddd vssd sg13cmos5l_nor2_1
XFILLER_15_1293 vddd vssd sg13cmos5l_decap_8
X_7334_ _7334_/Q _7336_/CLK _7334_/D _6848_/Y vddd vssd sg13cmos5l_dfrbpq_1
Xhold477 sram_addr[9] _5991_/X vddd vssd sg13cmos5l_dlygate4sd3_1
X_4477_ _4477_/Y _4806_/A _4476_/Y _4528_/A vddd vssd sg13cmos5l_o21ai_1
XFILLER_1_119 vddd vssd sg13cmos5l_decap_8
X_7265_ _7265_/Q _7297_/CLK _7265_/D fanout381/X vddd vssd sg13cmos5l_dfrbpq_1
XFILLER_8_2405 vddd vssd sg13cmos5l_decap_8
Xhold499 _7016_/D hold499/A vddd vssd sg13cmos5l_dlygate4sd3_1
XFILLER_28_2377 vddd vssd sg13cmos5l_decap_8
X_7196_ _7196_/Q _7199_/CLK _7196_/D fanout364/X vddd vssd sg13cmos5l_dfrbpq_1
Xhold488 _4946_/A hold949/X vddd vssd sg13cmos5l_dlygate4sd3_1
X_6216_ _6231_/C _7234_/Q _7235_/Q vddd vssd sg13cmos5l_nand2_1
Xhold1100 _3569_/A _7199_/Q vddd vssd sg13cmos5l_dlygate4sd3_1
X_6147_ _6149_/B _6147_/A _6147_/B _6147_/C vddd vssd sg13cmos5l_nand3_1
Xhold1111 _7293_/D _6658_/X vddd vssd sg13cmos5l_dlygate4sd3_1
XFILLER_2_2015 vddd vssd sg13cmos5l_decap_8
Xhold1133 _6526_/A1 _5778_/B vddd vssd sg13cmos5l_dlygate4sd3_1
Xhold1122 _6662_/A1 _3520_/Y vddd vssd sg13cmos5l_dlygate4sd3_1
Xhold1155 _7284_/D _6644_/X vddd vssd sg13cmos5l_dlygate4sd3_1
XFILLER_22_1231 vddd vssd sg13cmos5l_decap_4
Xhold1166 _6589_/A0 _7249_/Q vddd vssd sg13cmos5l_dlygate4sd3_1
X_6078_ _6078_/Y _7293_/Q _6076_/Y _6077_/Y vddd vssd sg13cmos5l_o21ai_1
XFILLER_6_2195 vddd vssd sg13cmos5l_decap_4
Xhold1144 _7221_/D _6537_/Y vddd vssd sg13cmos5l_dlygate4sd3_1
Xhold1188 _6400_/A0 _7148_/Q vddd vssd sg13cmos5l_dlygate4sd3_1
XFILLER_22_1286 vddd vssd sg13cmos5l_decap_4
XFILLER_22_1264 vddd vssd sg13cmos5l_decap_8
X_5029_ _5032_/B _7252_/Q _7253_/Q _5226_/A vddd vssd sg13cmos5l_nor3_1
Xhold1199 _3555_/A _7167_/Q vddd vssd sg13cmos5l_dlygate4sd3_1
Xhold1177 _7208_/D _6511_/X vddd vssd sg13cmos5l_dlygate4sd3_1
XFILLER_14_749 vddd vssd sg13cmos5l_decap_8
XFILLER_16_1046 vddd vssd sg13cmos5l_decap_4
XFILLER_10_955 vddd vssd sg13cmos5l_decap_8
XFILLER_13_1956 vddd vssd sg13cmos5l_decap_4
XFILLER_11_1691 vddd vssd sg13cmos5l_decap_8
XFILLER_27_1120 vddd vssd sg13cmos5l_decap_8
XFILLER_0_141 vddd vssd sg13cmos5l_decap_4
XFILLER_7_1236 vddd vssd sg13cmos5l_decap_8
XFILLER_23_1006 vddd vssd sg13cmos5l_decap_8
XFILLER_28_92 vddd vssd sg13cmos5l_decap_8
XFILLER_18_2535 vddd vssd sg13cmos5l_decap_8
X_4400_ _4419_/B _5926_/A _4400_/B _4421_/A vddd vssd sg13cmos5l_and3_1
XFILLER_8_274 vddd vssd sg13cmos5l_decap_4
X_5380_ _5380_/Y _5544_/A _5380_/B _5386_/A vddd vssd sg13cmos5l_nor3_1
X_4331_ _4331_/Y _3492_/Y _4330_/Y hold594/X vddd vssd sg13cmos5l_o21ai_1
XFILLER_5_63 vddd vssd sg13cmos5l_decap_8
XFILLER_5_992 vddd vssd sg13cmos5l_decap_8
X_7050_ _7050_/Q _7286_/CLK _7050_/D fanout374/X vddd vssd sg13cmos5l_dfrbpq_1
XFILLER_25_2517 vddd vssd sg13cmos5l_decap_8
Xfanout209 _4293_/C _4290_/A vddd vssd sg13cmos5l_buf_1
X_4262_ _4262_/Y mask_rev_in[16] _4262_/A2 _4258_/Y _4259_/Y _4261_/Y vddd vssd sg13cmos5l_a221oi_1
XFILLER_4_491 vddd vssd sg13cmos5l_decap_8
X_6001_ _6001_/Y _6156_/A _5009_/A _5008_/B vddd vssd sg13cmos5l_a21oi_1
X_4193_ _4193_/X _4193_/A _4193_/B _4193_/C _4193_/D vddd vssd sg13cmos5l_and4_1
Xclkbuf_leaf_32_SCK_regs _7292_/CLK clkload8/A vddd vssd sg13cmos5l_buf_8
XFILLER_28_808 vddd vssd sg13cmos5l_decap_8
XFILLER_23_1540 vddd vssd sg13cmos5l_decap_4
XFILLER_10_0 vddd vssd sg13cmos5l_decap_8
XFILLER_23_1562 vddd vssd sg13cmos5l_decap_8
Xoutbuffers\[24\] voltgen_sink2[0] _7070_/Q vddd vssd sg13cmos5l_buf_16
XFILLER_24_28 vddd vssd sg13cmos5l_decap_8
X_6834_ _6834_/Y _6835_/A _6835_/B_N vddd vssd sg13cmos5l_nor2b_1
XFILLER_17_2045 vddd vssd sg13cmos5l_decap_8
XFILLER_17_2034 vddd vssd sg13cmos5l_decap_8
X_6765_ _6765_/Y _6765_/A wire49/X vddd vssd sg13cmos5l_nand2_1
X_3977_ _3977_/Y _7080_/Q wire70/X vddd vssd sg13cmos5l_nand2b_1
X_5716_ _5733_/C _7206_/Q _5716_/B vddd vssd sg13cmos5l_nor2_1
X_6696_ _6710_/S _6696_/A _6702_/B vddd vssd sg13cmos5l_and2_1
X_5647_ _5649_/C _7196_/Q _5647_/B _5647_/C vddd vssd sg13cmos5l_nor3_1
X_5578_ _5581_/C _5583_/B _7188_/Q vddd vssd sg13cmos5l_nand2b_1
XFILLER_30_1599 vddd vssd sg13cmos5l_decap_8
X_4529_ _4529_/Y _4525_/Y _4528_/Y _4806_/A vddd vssd sg13cmos5l_o21ai_1
X_7317_ _7317_/Q _7338_/CLK _7317_/D _7317_/RESET_B vddd vssd sg13cmos5l_dfrbpq_1
X_7248_ _7248_/Q _7291_/CLK _7248_/D fanout376/X vddd vssd sg13cmos5l_dfrbpq_1
X_7179_ _7179_/Q _7214_/CLK _7179_/D fanout362/X vddd vssd sg13cmos5l_dfrbpq_1
XFILLER_24_1359 vddd vssd sg13cmos5l_decap_4
XFILLER_22_1050 vddd vssd sg13cmos5l_decap_8
XFILLER_14_535 vddd vssd sg13cmos5l_decap_8
XFILLER_17_2590 vddd vssd sg13cmos5l_decap_8
XFILLER_13_2443 vddd vssd sg13cmos5l_decap_8
XFILLER_10_763 vddd vssd sg13cmos5l_decap_4
XFILLER_10_785 vddd vssd sg13cmos5l_decap_8
Xtiedowns\[60\] mask_rev_in[16] vddd vssd sg13cmos5l_antennanp
XFILLER_30_93 vddd vssd sg13cmos5l_decap_8
XFILLER_24_2572 vddd vssd sg13cmos5l_decap_8
XFILLER_20_2458 vddd vssd sg13cmos5l_decap_8
XFILLER_7_1088 vddd vssd sg13cmos5l_decap_4
XFILLER_32_310 vddd vssd sg13cmos5l_decap_8
Xoutbuffers\[114\] dbus_out[17] _5797_/Y vddd vssd sg13cmos5l_buf_16
X_3900_ _6272_/A dbus_in_left[3] dbus_in_right[3] vddd vssd sg13cmos5l_nor2_1
X_4880_ _4894_/B _4952_/A _7139_/Q vddd vssd sg13cmos5l_nor2_1
X_3831_ _3831_/X _3984_/B _3944_/A vddd vssd sg13cmos5l_and2_1
XFILLER_18_1620 vddd vssd sg13cmos5l_decap_8
XFILLER_32_387 vddd vssd sg13cmos5l_decap_8
XFILLER_20_516 vddd vssd sg13cmos5l_decap_4
XFILLER_18_1653 vddd vssd sg13cmos5l_decap_4
X_3762_ _3762_/Y _4179_/A1 sram_odata[7] _4300_/B vddd vssd sg13cmos5l_a21oi_1
X_6550_ _6550_/Y _6550_/A _6552_/B vddd vssd sg13cmos5l_nor2_1
X_5501_ _5501_/Y _5501_/A _5501_/B _5501_/C vddd vssd sg13cmos5l_nand3_1
XFILLER_31_2576 vddd vssd sg13cmos5l_decap_8
X_6481_ _6481_/Y _6520_/A _6481_/B vddd vssd sg13cmos5l_nor2_1
X_3693_ _3919_/A _3693_/A _3693_/B _3928_/A vddd vssd sg13cmos5l_nand3_1
X_5432_ _5438_/C _7169_/Q _7168_/Q vddd vssd sg13cmos5l_nand2b_1
XFILLER_12_1252 vddd vssd sg13cmos5l_decap_8
X_5363_ _5393_/B _5386_/A _5374_/B vddd vssd sg13cmos5l_nor2_1
XFILLER_29_2450 vddd vssd sg13cmos5l_decap_8
X_7102_ _7102_/Q _7111_/CLK _7102_/D fanout404/X vddd vssd sg13cmos5l_dfrbpq_1
X_4314_ _4314_/Y _7375_/Q _4304_/B hold590/X vddd vssd sg13cmos5l_a21oi_1
XFILLER_29_1760 vddd vssd sg13cmos5l_decap_8
X_5294_ _5294_/Y _5294_/A _5294_/B _5294_/C vddd vssd sg13cmos5l_nand3_1
XFILLER_9_2555 vddd vssd sg13cmos5l_decap_8
X_7033_ _7033_/Q _7201_/CLK _7033_/D fanout369/X vddd vssd sg13cmos5l_dfrbpq_1
X_4245_ _4245_/Y _7045_/Q _3831_/X _4244_/Y vddd vssd sg13cmos5l_a21oi_1
XFILLER_19_28 vddd vssd sg13cmos5l_decap_8
XFILLER_9_2588 vddd vssd sg13cmos5l_decap_8
X_4176_ _4176_/Y mask_rev_in[17] _3744_/Y _4174_/X _4175_/Y _3748_/Y vddd vssd sg13cmos5l_a221oi_1
XFILLER_27_159 vddd vssd sg13cmos5l_decap_8
XFILLER_24_822 vddd vssd sg13cmos5l_decap_8
XFILLER_32_2307 vddd vssd sg13cmos5l_decap_4
X_6817_ _6817_/Y _6879_/A _6819_/B_N vddd vssd sg13cmos5l_nor2b_1
XFILLER_11_549 vddd vssd sg13cmos5l_decap_4
XFILLER_32_1639 vddd vssd sg13cmos5l_decap_8
X_6748_ _7062_/D _6748_/A1 _6752_/S _6748_/B1 vddd vssd sg13cmos5l_o21ai_1
XFILLER_13_1005 vddd vssd sg13cmos5l_decap_4
X_6679_ _7317_/D _6679_/A1 _6686_/S _6678_/Y vddd vssd sg13cmos5l_o21ai_1
XFILLER_3_715 vddd vssd sg13cmos5l_decap_8
XFILLER_19_616 vddd vssd sg13cmos5l_decap_8
XFILLER_18_126 vddd vssd sg13cmos5l_decap_8
XFILLER_26_181 vddd vssd sg13cmos5l_decap_8
XFILLER_25_93 vddd vssd sg13cmos5l_decap_8
XFILLER_15_2549 vddd vssd sg13cmos5l_decap_8
XFILLER_13_1550 vddd vssd sg13cmos5l_decap_8
XFILLER_10_593 vddd vssd sg13cmos5l_decap_4
XFILLER_6_564 vddd vssd sg13cmos5l_decap_8
XFILLER_29_1012 vddd vssd sg13cmos5l_decap_8
XFILLER_26_1933 vddd vssd sg13cmos5l_decap_4
XFILLER_2_42 vddd vssd sg13cmos5l_decap_8
XFILLER_4_2441 vddd vssd sg13cmos5l_decap_8
X_4030_ _4030_/Y _4030_/A _4030_/B vddd vssd sg13cmos5l_nand2_1
XFILLER_4_2474 vddd vssd sg13cmos5l_decap_4
XFILLER_20_2288 vddd vssd sg13cmos5l_decap_8
XFILLER_20_1554 vddd vssd sg13cmos5l_decap_8
X_5981_ _5981_/X hold893/X _3753_/B _5991_/S vddd vssd sg13cmos5l_mux2_1
XFILLER_20_1598 vddd vssd sg13cmos5l_decap_8
X_4932_ _4943_/B _4932_/A _4935_/B vddd vssd sg13cmos5l_nand2_1
XFILLER_32_140 vddd vssd sg13cmos5l_decap_8
XFILLER_21_825 vddd vssd sg13cmos5l_decap_8
XANTENNA_14 _3507_/Y vddd vssd sg13cmos5l_antennanp
XFILLER_18_1450 vddd vssd sg13cmos5l_decap_4
XFILLER_14_2026 vddd vssd sg13cmos5l_decap_4
X_6602_ _6602_/X _6602_/A0 _6645_/A1 _6602_/S vddd vssd sg13cmos5l_mux2_1
X_4863_ _4863_/Y _4867_/A _4863_/B vddd vssd sg13cmos5l_nor2_1
X_3814_ wire23/A _3812_/Y _3813_/Y _3751_/Y vddd vssd sg13cmos5l_o21ai_1
XANTENNA_25 sram_odata[7] vddd vssd sg13cmos5l_antennanp
X_4794_ _7334_/D _4547_/A _4794_/A2 _4774_/Y vddd vssd sg13cmos5l_o21ai_1
XANTENNA_47 wire5/X vddd vssd sg13cmos5l_antennanp
XANTENNA_36 _6801_/A vddd vssd sg13cmos5l_antennanp
XFILLER_31_2373 vddd vssd sg13cmos5l_decap_8
X_3745_ _3745_/Y _3786_/A _3962_/A vddd vssd sg13cmos5l_nand2_1
X_6533_ _6533_/Y _6533_/A1 _6536_/B _6532_/Y vddd vssd sg13cmos5l_a21oi_1
X_6464_ _6464_/Y _6464_/A _6467_/S vddd vssd sg13cmos5l_nor2_1
Xoutbuffers\[91\] io_out[6] wire13/X vddd vssd sg13cmos5l_buf_16
XFILLER_9_391 vddd vssd sg13cmos5l_decap_8
X_5415_ _5415_/Y _5530_/A _5414_/B _5414_/Y vddd vssd sg13cmos5l_o21ai_1
X_3676_ _3908_/A _3874_/B _3874_/C vddd vssd sg13cmos5l_nor2_1
X_6395_ _6401_/S _6395_/A _6395_/B _6762_/C vddd vssd sg13cmos5l_nor3_1
XFILLER_25_2100 vddd vssd sg13cmos5l_decap_8
X_5346_ _5346_/X _7154_/Q _5348_/B vddd vssd sg13cmos5l_and2_1
X_5277_ _5277_/Y _7398_/Q _3641_/Y _4912_/B hold636/X vddd vssd sg13cmos5l_a22oi_1
X_7016_ _7016_/Q _7020_/CLK _7016_/D _6963_/Y vddd vssd sg13cmos5l_dfrbpq_1
XFILLER_29_1590 vddd vssd sg13cmos5l_decap_8
XFILLER_25_1454 vddd vssd sg13cmos5l_decap_8
XFILLER_9_1673 vddd vssd sg13cmos5l_decap_8
X_4228_ _4228_/Y _5498_/A _6445_/A _3955_/Y vddd vssd sg13cmos5l_a21oi_1
XFILLER_25_1498 vddd vssd sg13cmos5l_decap_8
X_4159_ _4159_/Y _7059_/Q _4159_/B vddd vssd sg13cmos5l_nand2b_1
XFILLER_23_140 vddd vssd sg13cmos5l_decap_8
XFILLER_24_685 vddd vssd sg13cmos5l_decap_8
XFILLER_32_1436 vddd vssd sg13cmos5l_decap_8
XFILLER_14_2582 vddd vssd sg13cmos5l_decap_8
XFILLER_10_1756 vddd vssd sg13cmos5l_decap_8
XFILLER_3_567 vddd vssd sg13cmos5l_decap_4
Xfanout392 fanout392/X fanout409/X vddd vssd sg13cmos5l_buf_1
Xtiedowns\[23\] dbus_in_left[3] vddd vssd sg13cmos5l_antennanp
Xfanout370 fanout370/X fanout371/X vddd vssd sg13cmos5l_buf_1
XFILLER_21_2542 vddd vssd sg13cmos5l_decap_8
Xfanout381 fanout381/X fanout382/X vddd vssd sg13cmos5l_buf_1
XFILLER_19_2471 vddd vssd sg13cmos5l_decap_8
XFILLER_30_644 vddd vssd sg13cmos5l_decap_8
XFILLER_19_1770 vddd vssd sg13cmos5l_decap_8
XFILLER_15_1623 vddd vssd sg13cmos5l_decap_8
XFILLER_30_677 vddd vssd sg13cmos5l_decap_8
X_3530_ _3530_/Y _3530_/A vddd vssd sg13cmos5l_inv_1
XFILLER_7_840 vddd vssd sg13cmos5l_decap_8
Xhold818 _3593_/A _7103_/Q vddd vssd sg13cmos5l_dlygate4sd3_1
Xhold807 hold807/X _3594_/Y vddd vssd sg13cmos5l_dlygate4sd3_1
Xhold829 hold829/X _6515_/Y vddd vssd sg13cmos5l_dlygate4sd3_1
X_5200_ _5262_/B _5223_/A _5224_/A vddd vssd sg13cmos5l_nand2b_1
X_6180_ _6180_/Y _6156_/A _5214_/C _6179_/Y vddd vssd sg13cmos5l_a21oi_1
X_5131_ _5135_/A _5131_/A _6088_/B _5131_/C _5131_/D vddd vssd sg13cmos5l_nor4_1
XFILLER_26_2486 vddd vssd sg13cmos5l_decap_8
XFILLER_6_1813 vddd vssd sg13cmos5l_decap_8
XFILLER_6_2536 vddd vssd sg13cmos5l_decap_8
X_5062_ _5068_/C _5062_/A _5243_/A vddd vssd sg13cmos5l_nand2_1
Xhold1507 hold915/A _7304_/Q vddd vssd sg13cmos5l_dlygate4sd3_1
X_4013_ _4013_/Y _7292_/Q _4189_/B1 _6702_/A _7035_/Q _6646_/A vddd vssd sg13cmos5l_a221oi_1
XFILLER_22_1616 vddd vssd sg13cmos5l_decap_8
XFILLER_20_2052 vddd vssd sg13cmos5l_decap_8
XFILLER_0_2135 vddd vssd sg13cmos5l_decap_8
XFILLER_0_1412 vddd vssd sg13cmos5l_decap_8
XFILLER_19_980 vddd vssd sg13cmos5l_decap_8
X_5964_ _5966_/B _5972_/C _5964_/B vddd vssd sg13cmos5l_nand2b_1
XFILLER_21_622 vddd vssd sg13cmos5l_decap_8
X_4915_ _4916_/C _4828_/A _4912_/B _4960_/B vddd vssd sg13cmos5l_a21oi_1
X_5895_ _5895_/Y _5895_/A _5897_/C vddd vssd sg13cmos5l_nor2_1
XFILLER_32_28 vddd vssd sg13cmos5l_decap_8
X_4846_ _4846_/Y _4830_/Y _4847_/A vddd vssd sg13cmos5l_nand2b_1
Xtiedowns\[7\] sram_odata[7] vddd vssd sg13cmos5l_antennanp
XFILLER_18_1280 vddd vssd sg13cmos5l_decap_8
XFILLER_14_1111 vddd vssd sg13cmos5l_decap_8
X_6516_ _7210_/D _6540_/A1 _6520_/B hold829/X vddd vssd sg13cmos5l_o21ai_1
X_4777_ _4780_/B _5315_/A _6009_/A _4781_/A vddd vssd sg13cmos5l_o21ai_1
XFILLER_14_1166 vddd vssd sg13cmos5l_decap_8
X_3728_ _3863_/B _3846_/A _6597_/B vddd vssd sg13cmos5l_nor2_1
XFILLER_31_1491 vddd vssd sg13cmos5l_decap_8
X_3659_ _3705_/B _3659_/A0 _4325_/A _3672_/S vddd vssd sg13cmos5l_mux2_1
X_6447_ _7174_/D _6447_/A1 _6451_/B _6446_/Y vddd vssd sg13cmos5l_a21oi_1
XFILLER_27_2239 vddd vssd sg13cmos5l_decap_8
XFILLER_27_1505 vddd vssd sg13cmos5l_decap_4
X_6378_ _6378_/Y _6378_/A _6382_/B vddd vssd sg13cmos5l_nand2_1
XFILLER_0_504 vddd vssd sg13cmos5l_decap_8
X_5329_ _5331_/B _7152_/Q _7153_/Q vddd vssd sg13cmos5l_nor2_1
XFILLER_9_1481 vddd vssd sg13cmos5l_decap_8
XFILLER_28_221 vddd vssd sg13cmos5l_decap_8
XFILLER_5_1367 vddd vssd sg13cmos5l_decap_4
XFILLER_28_265 vddd vssd sg13cmos5l_decap_8
Xwire91 wire91/X wire91/A vddd vssd sg13cmos5l_buf_2
XFILLER_19_1022 vddd vssd sg13cmos5l_decap_8
Xclkbuf_4_8__f_clk_regs _7348_/CLK clkbuf_3_4_0_clk_regs/X vddd vssd sg13cmos5l_buf_8
XFILLER_32_1200 vddd vssd sg13cmos5l_decap_8
XFILLER_16_1965 vddd vssd sg13cmos5l_decap_8
XFILLER_7_114 vddd vssd sg13cmos5l_decap_8
XFILLER_26_1015 vddd vssd sg13cmos5l_decap_8
XFILLER_14_7 vddd vssd sg13cmos5l_decap_8
XFILLER_21_1682 vddd vssd sg13cmos5l_decap_4
X_5680_ _5680_/Y _6238_/A1 _5651_/Y _5679_/Y vddd vssd sg13cmos5l_a21oi_1
XFILLER_17_1729 vddd vssd sg13cmos5l_decap_4
X_4700_ _4703_/B _4745_/A1 _4699_/Y _4697_/Y vddd vssd sg13cmos5l_o21ai_1
X_4631_ _4631_/Y _4628_/X _4629_/Y _4630_/Y _4460_/B _4627_/Y vddd vssd sg13cmos5l_a221oi_1
XFILLER_8_63 vddd vssd sg13cmos5l_decap_8
XFILLER_11_2029 vddd vssd sg13cmos5l_decap_8
X_4562_ _4563_/B _4562_/A _7016_/D vddd vssd sg13cmos5l_xor2_1
XFILLER_15_1486 vddd vssd sg13cmos5l_decap_4
X_7350_ _7350_/Q _7357_/CLK _7350_/D _6864_/Y vddd vssd sg13cmos5l_dfrbpq_1
X_7281_ _7281_/Q _7285_/CLK _7281_/D fanout385/X vddd vssd sg13cmos5l_dfrbpq_1
X_4493_ _4493_/Y _4493_/A _4493_/B _4547_/A vddd vssd sg13cmos5l_nor3_1
X_6301_ _6301_/Y _6301_/A _6762_/A _6789_/B vddd vssd sg13cmos5l_nor3_1
Xhold626 hold626/X _7332_/Q vddd vssd sg13cmos5l_dlygate4sd3_1
Xhold615 _7330_/D _4840_/Y vddd vssd sg13cmos5l_dlygate4sd3_1
Xhold604 _7328_/D _4850_/Y vddd vssd sg13cmos5l_dlygate4sd3_1
XFILLER_7_692 vddd vssd sg13cmos5l_decap_8
X_3513_ _5065_/A _3513_/A vddd vssd sg13cmos5l_inv_1
Xhold648 _4582_/A _7344_/Q vddd vssd sg13cmos5l_dlygate4sd3_1
X_6232_ _6232_/Y _6235_/A _6232_/B _6232_/C vddd vssd sg13cmos5l_nor3_1
Xhold637 _5278_/A _5277_/Y vddd vssd sg13cmos5l_dlygate4sd3_1
Xhold659 hold659/X _7357_/Q vddd vssd sg13cmos5l_dlygate4sd3_1
XFILLER_28_2559 vddd vssd sg13cmos5l_decap_8
X_6163_ _6164_/B _6185_/C _5184_/C _3521_/Y vddd vssd sg13cmos5l_o21ai_1
Xoutbuffers\[54\] bandgap_trim[15] _6824_/X vddd vssd sg13cmos5l_buf_16
Xhold1315 _3620_/A _7047_/Q vddd vssd sg13cmos5l_dlygate4sd3_1
Xhold1304 _7028_/D _6695_/X vddd vssd sg13cmos5l_dlygate4sd3_1
XFILLER_22_2125 vddd vssd sg13cmos5l_decap_8
X_5114_ _5132_/B _7274_/Q _7275_/Q _5177_/B vddd vssd sg13cmos5l_nor3_1
XFILLER_6_1632 vddd vssd sg13cmos5l_decap_8
X_6094_ _6094_/Y _6072_/A _5132_/A _6092_/Y _6093_/Y _5134_/C vddd vssd sg13cmos5l_a221oi_1
Xhold1348 _6497_/A1 _5666_/B vddd vssd sg13cmos5l_dlygate4sd3_1
X_5045_ _5071_/A _7284_/Q _7285_/Q _5248_/A vddd vssd sg13cmos5l_or3_1
Xhold1326 _3564_/A _7188_/Q vddd vssd sg13cmos5l_dlygate4sd3_1
Xhold1337 _6549_/A1 _5861_/B vddd vssd sg13cmos5l_dlygate4sd3_1
XFILLER_6_2388 vddd vssd sg13cmos5l_decap_8
Xhold1359 _6555_/A _5901_/A vddd vssd sg13cmos5l_dlygate4sd3_1
XFILLER_27_28 vddd vssd sg13cmos5l_decap_8
X_6996_ _6996_/Q _7346_/CLK _6996_/D _6943_/Y vddd vssd sg13cmos5l_dfrbpq_1
XFILLER_26_769 vddd vssd sg13cmos5l_decap_8
XFILLER_26_758 vddd vssd sg13cmos5l_decap_8
X_5947_ _5947_/X _6979_/D _5947_/B vddd vssd sg13cmos5l_and2_1
X_5878_ _5878_/Y _5901_/B _5901_/A vddd vssd sg13cmos5l_nor2b_1
X_4829_ _4829_/Y _4853_/A _5985_/S vddd vssd sg13cmos5l_nor2_1
XFILLER_11_2563 vddd vssd sg13cmos5l_decap_8
XFILLER_0_312 vddd vssd sg13cmos5l_decap_8
XFILLER_7_1407 vddd vssd sg13cmos5l_decap_8
XFILLER_0_378 vddd vssd sg13cmos5l_decap_8
XFILLER_31_205 vddd vssd sg13cmos5l_decap_8
XFILLER_13_931 vddd vssd sg13cmos5l_decap_4
XFILLER_13_953 vddd vssd sg13cmos5l_decap_8
XFILLER_16_2463 vddd vssd sg13cmos5l_decap_8
XFILLER_8_412 vddd vssd sg13cmos5l_decap_8
Xclkbuf_3_1_0_clk_regs clkbuf_3_1_0_clk_regs/X clkbuf_0_clk_regs/X vddd vssd sg13cmos5l_buf_8
XFILLER_32_1074 vddd vssd sg13cmos5l_decap_8
XFILLER_10_2051 vddd vssd sg13cmos5l_decap_8
XFILLER_4_684 vddd vssd sg13cmos5l_decap_8
XFILLER_23_2412 vddd vssd sg13cmos5l_decap_8
XFILLER_23_1733 vddd vssd sg13cmos5l_decap_4
XFILLER_7_1952 vddd vssd sg13cmos5l_decap_8
XFILLER_23_2489 vddd vssd sg13cmos5l_decap_8
X_6850_ _6850_/Y _6962_/A _6957_/B_N vddd vssd sg13cmos5l_nor2b_1
XFILLER_23_739 vddd vssd sg13cmos5l_decap_8
X_6781_ _7083_/D _6727_/A _6784_/B hold969/X vddd vssd sg13cmos5l_o21ai_1
XFILLER_1_1595 vddd vssd sg13cmos5l_decap_8
X_5801_ _5811_/A _7220_/Q _5801_/B vddd vssd sg13cmos5l_nor2_1
X_5732_ _5734_/A _5733_/B _5732_/B vddd vssd sg13cmos5l_nand2_1
X_3993_ _3993_/Y _7099_/Q _4256_/B _4172_/A2 vddd vssd sg13cmos5l_a21oi_1
XFILLER_30_2427 vddd vssd sg13cmos5l_decap_8
X_5663_ _5663_/Y _5661_/Y _5662_/Y _5674_/C vddd vssd sg13cmos5l_o21ai_1
X_4614_ _4614_/Y _4684_/A _4612_/Y _4685_/A vddd vssd sg13cmos5l_a21oi_1
X_5594_ _5595_/B _6212_/A1 _5617_/C _7193_/Q vddd vssd sg13cmos5l_o21ai_1
X_7402_ _7402_/Q _7404_/CLK _7402_/D _6915_/Y vddd vssd sg13cmos5l_dfrbpq_1
X_4545_ _4546_/B _4566_/A1 _3606_/Y _4488_/A _4541_/B vddd vssd sg13cmos5l_a22oi_1
X_7333_ _7333_/Q _7357_/CLK _7333_/D _6847_/Y vddd vssd sg13cmos5l_dfrbpq_1
XFILLER_11_1147 vddd vssd sg13cmos5l_decap_8
XFILLER_28_2356 vddd vssd sg13cmos5l_decap_8
Xhold478 _4925_/A hold478/A vddd vssd sg13cmos5l_dlygate4sd3_1
X_4476_ _4476_/Y _4508_/C _4503_/A vddd vssd sg13cmos5l_xnor2_1
X_7264_ _7264_/Q _7264_/CLK _7264_/D _6954_/B_N vddd vssd sg13cmos5l_dfrbpq_1
X_7195_ _7195_/Q _7199_/CLK _7195_/D fanout363/X vddd vssd sg13cmos5l_dfrbpq_1
XFILLER_24_2209 vddd vssd sg13cmos5l_decap_8
Xhold489 sram_addr[5] _5984_/X vddd vssd sg13cmos5l_dlygate4sd3_1
X_6215_ _6232_/C _6215_/A _7235_/Q vddd vssd sg13cmos5l_nand2_1
X_6146_ _6147_/C _6146_/A _6146_/B vddd vssd sg13cmos5l_nand2_1
Xhold1112 _6652_/A0 _7289_/Q vddd vssd sg13cmos5l_dlygate4sd3_1
Xhold1101 _6494_/A1 _5661_/B vddd vssd sg13cmos5l_dlygate4sd3_1
XFILLER_22_1210 vddd vssd sg13cmos5l_decap_8
Xhold1123 _6601_/A0 _7256_/Q vddd vssd sg13cmos5l_dlygate4sd3_1
XFILLER_6_2174 vddd vssd sg13cmos5l_decap_8
Xhold1156 _6632_/A0 _7277_/Q vddd vssd sg13cmos5l_dlygate4sd3_1
Xhold1145 _6710_/A0 _7039_/Q vddd vssd sg13cmos5l_dlygate4sd3_1
Xhold1134 _4670_/B _7339_/Q vddd vssd sg13cmos5l_dlygate4sd3_1
Xhold1167 _7249_/D _6589_/X vddd vssd sg13cmos5l_dlygate4sd3_1
X_6077_ _6077_/Y _7293_/Q _5830_/B _5193_/B vddd vssd sg13cmos5l_a21oi_1
XFILLER_6_1462 vddd vssd sg13cmos5l_decap_8
Xhold1189 _7148_/D _6400_/X vddd vssd sg13cmos5l_dlygate4sd3_1
Xhold1178 _3523_/A _7299_/Q vddd vssd sg13cmos5l_dlygate4sd3_1
X_5028_ _5226_/A _5245_/A _5245_/B vddd vssd sg13cmos5l_nand2_1
XFILLER_0_1061 vddd vssd sg13cmos5l_decap_8
X_6979_ _6979_/Q _6981_/CLK _6979_/D _6926_/Y vddd vssd sg13cmos5l_dfrbpq_1
XFILLER_16_1003 vddd vssd sg13cmos5l_decap_8
Xclkbuf_leaf_2_SCK_regs _7386_/CLK clkload4/A vddd vssd sg13cmos5l_buf_8
XFILLER_11_1670 vddd vssd sg13cmos5l_decap_8
Xhold990 hold990/X _6396_/Y vddd vssd sg13cmos5l_dlygate4sd3_1
XFILLER_0_120 vddd vssd sg13cmos5l_decap_8
XFILLER_27_1143 vddd vssd sg13cmos5l_decap_8
XFILLER_7_1204 vddd vssd sg13cmos5l_decap_8
XFILLER_7_1226 vddd vssd sg13cmos5l_decap_4
XFILLER_27_1165 vddd vssd sg13cmos5l_decap_4
XFILLER_7_1248 vddd vssd sg13cmos5l_decap_4
XFILLER_2_2550 vddd vssd sg13cmos5l_decap_8
XFILLER_2_1860 vddd vssd sg13cmos5l_decap_8
XFILLER_18_2514 vddd vssd sg13cmos5l_decap_8
XFILLER_8_253 vddd vssd sg13cmos5l_decap_8
XFILLER_12_282 vddd vssd sg13cmos5l_decap_8
XFILLER_16_1592 vddd vssd sg13cmos5l_decap_8
XFILLER_12_1456 vddd vssd sg13cmos5l_decap_4
X_4330_ _4330_/Y _4326_/Y _4330_/B vddd vssd sg13cmos5l_nand2b_1
XFILLER_4_470 vddd vssd sg13cmos5l_decap_8
XFILLER_5_42 vddd vssd sg13cmos5l_decap_8
X_4261_ _4261_/Y _4263_/B _4261_/B vddd vssd sg13cmos5l_nand2_1
X_6000_ _6000_/Y _3797_/X _5011_/B _4990_/Y vddd vssd sg13cmos5l_o21ai_1
X_4192_ _4193_/D _7278_/Q wire91/X wire88/X _7274_/Q wire89/X vddd vssd sg13cmos5l_a221oi_1
XFILLER_3_2325 vddd vssd sg13cmos5l_decap_4
XFILLER_7_2494 vddd vssd sg13cmos5l_decap_8
XFILLER_3_1679 vddd vssd sg13cmos5l_decap_8
Xoutbuffers\[17\] proj_sel[4] _7028_/Q vddd vssd sg13cmos5l_buf_16
XFILLER_23_514 vddd vssd sg13cmos5l_decap_8
X_6833_ _6833_/Y _6840_/A _6840_/B_N vddd vssd sg13cmos5l_nor2b_1
X_6764_ _7073_/D _6764_/A1 wire49/X hold926/X vddd vssd sg13cmos5l_a21oi_1
X_3976_ _3976_/Y _3976_/A _3976_/B vddd vssd sg13cmos5l_nand2_1
X_6695_ _6695_/X _6770_/A1 _6695_/A1 _6695_/S vddd vssd sg13cmos5l_mux2_1
X_5715_ _5715_/Y _5861_/A _5716_/B _7208_/Q vddd vssd sg13cmos5l_nor3_1
X_5646_ _5647_/C _5530_/A _5638_/A _5629_/Y _5875_/A vddd vssd sg13cmos5l_a22oi_1
XFILLER_13_1209 vddd vssd sg13cmos5l_decap_8
X_5577_ _5580_/B _5575_/Y _5576_/Y _5574_/Y vddd vssd sg13cmos5l_o21ai_1
X_4528_ _4528_/Y _4528_/A _4528_/B vddd vssd sg13cmos5l_nor2_1
X_7316_ _7316_/Q _7338_/CLK _7316_/D _7316_/RESET_B vddd vssd sg13cmos5l_dfrbpq_1
XFILLER_28_2142 vddd vssd sg13cmos5l_decap_8
X_7247_ _7247_/Q _7291_/CLK _7247_/D fanout376/X vddd vssd sg13cmos5l_dfrbpq_1
X_4459_ _4512_/A _7083_/Q _4459_/B vddd vssd sg13cmos5l_nand2_1
X_7178_ _7178_/Q _7214_/CLK _7178_/D fanout362/X vddd vssd sg13cmos5l_dfrbpq_1
XFILLER_8_1546 vddd vssd sg13cmos5l_decap_8
X_6129_ _6129_/Y _6177_/A _5159_/C _5168_/C vddd vssd sg13cmos5l_a21oi_1
XFILLER_18_319 vddd vssd sg13cmos5l_decap_8
XFILLER_2_1145 vddd vssd sg13cmos5l_decap_8
XFILLER_13_2422 vddd vssd sg13cmos5l_decap_8
XFILLER_10_753 vddd vssd sg13cmos5l_decap_4
XFILLER_13_2499 vddd vssd sg13cmos5l_decap_8
XFILLER_13_1732 vddd vssd sg13cmos5l_decap_8
XFILLER_30_72 vddd vssd sg13cmos5l_decap_8
Xtiedowns\[53\] mask_rev_in[9] vddd vssd sg13cmos5l_antennanp
XFILLER_24_2551 vddd vssd sg13cmos5l_decap_8
XFILLER_4_2601 vddd vssd sg13cmos5l_decap_4
XFILLER_20_2437 vddd vssd sg13cmos5l_decap_8
XFILLER_20_1703 vddd vssd sg13cmos5l_decap_4
XFILLER_18_2333 vddd vssd sg13cmos5l_decap_4
XFILLER_32_366 vddd vssd sg13cmos5l_decap_8
X_3830_ _3944_/A _3874_/C _3940_/B vddd vssd sg13cmos5l_nor2_1
Xoutbuffers\[107\] dbus_out[10] _5590_/Y vddd vssd sg13cmos5l_buf_16
XFILLER_14_2219 vddd vssd sg13cmos5l_decap_8
X_3761_ _4300_/B _7373_/Q _4293_/C _7371_/Q vddd vssd sg13cmos5l_or3_1
XFILLER_31_2555 vddd vssd sg13cmos5l_decap_8
X_5500_ _5501_/C _5479_/Y _5497_/X _5499_/Y _5727_/A vddd vssd sg13cmos5l_a22oi_1
X_6480_ _6480_/X _6692_/A hold853/X _6481_/B vddd vssd sg13cmos5l_mux2_1
X_3692_ _3925_/A _3928_/B _3928_/A vddd vssd sg13cmos5l_nor2b_1
X_5431_ _5431_/Y _5429_/Y _5430_/Y _5442_/C vddd vssd sg13cmos5l_o21ai_1
X_5362_ _5362_/X io_in[0] _5361_/A _5361_/Y vddd vssd sg13cmos5l_a21o_1
X_7101_ _7101_/Q _7111_/CLK _7101_/D fanout404/X vddd vssd sg13cmos5l_dfrbpq_1
X_4313_ _4313_/X _4979_/B _4968_/A vddd vssd sg13cmos5l_or2_1
XFILLER_9_2534 vddd vssd sg13cmos5l_decap_8
X_7032_ _7032_/Q _7286_/CLK _7032_/D fanout374/X vddd vssd sg13cmos5l_dfrbpq_1
XFILLER_25_1603 vddd vssd sg13cmos5l_decap_4
X_5293_ _5306_/A _7146_/Q _5294_/B vddd vssd sg13cmos5l_nand2_1
X_4244_ _4244_/Y _3612_/Y _4244_/A2 _4242_/Y _4243_/Y vddd vssd sg13cmos5l_a22oi_1
XFILLER_25_1647 vddd vssd sg13cmos5l_decap_4
X_4175_ _4175_/Y _3613_/Y wire85/X _3744_/Y vddd vssd sg13cmos5l_a21oi_1
XFILLER_27_138 vddd vssd sg13cmos5l_decap_8
XFILLER_3_1465 vddd vssd sg13cmos5l_decap_8
XFILLER_24_889 vddd vssd sg13cmos5l_decap_8
X_6816_ _6816_/Y _6879_/A _6819_/B_N vddd vssd sg13cmos5l_nor2b_1
X_6747_ _6747_/Y _6747_/A _6752_/S vddd vssd sg13cmos5l_nand2_1
XFILLER_32_1618 vddd vssd sg13cmos5l_decap_8
XFILLER_17_1153 vddd vssd sg13cmos5l_decap_8
X_3959_ _6424_/A _3959_/A _3961_/B vddd vssd sg13cmos5l_nor2_1
X_6678_ _6678_/Y sram_odata[2] _6683_/S vddd vssd sg13cmos5l_nand2_1
X_5629_ _5629_/Y _5629_/A _5633_/B vddd vssd sg13cmos5l_nor2b_1
XFILLER_10_1905 vddd vssd sg13cmos5l_decap_4
XFILLER_2_237 vddd vssd sg13cmos5l_decap_8
XFILLER_8_2011 vddd vssd sg13cmos5l_decap_8
XFILLER_8_2033 vddd vssd sg13cmos5l_decap_8
XFILLER_8_2077 vddd vssd sg13cmos5l_decap_4
XFILLER_24_1124 vddd vssd sg13cmos5l_decap_8
XFILLER_8_1365 vddd vssd sg13cmos5l_decap_8
XFILLER_18_105 vddd vssd sg13cmos5l_decap_8
XFILLER_27_672 vddd vssd sg13cmos5l_decap_8
XFILLER_26_160 vddd vssd sg13cmos5l_decap_8
XFILLER_25_72 vddd vssd sg13cmos5l_decap_8
XFILLER_15_2528 vddd vssd sg13cmos5l_decap_8
XFILLER_14_388 vddd vssd sg13cmos5l_decap_8
XFILLER_13_2263 vddd vssd sg13cmos5l_decap_8
XFILLER_6_521 vddd vssd sg13cmos5l_decap_8
XFILLER_26_1912 vddd vssd sg13cmos5l_decap_8
XFILLER_2_21 vddd vssd sg13cmos5l_decap_8
XFILLER_4_2420 vddd vssd sg13cmos5l_decap_8
XFILLER_2_76 vddd vssd sg13cmos5l_decap_8
XFILLER_24_1691 vddd vssd sg13cmos5l_decap_8
XFILLER_0_2317 vddd vssd sg13cmos5l_decap_8
XFILLER_4_2486 vddd vssd sg13cmos5l_decap_8
X_5980_ _5980_/X hold938/X _3753_/C _5991_/S vddd vssd sg13cmos5l_mux2_1
XFILLER_0_1616 vddd vssd sg13cmos5l_decap_8
XFILLER_24_119 vddd vssd sg13cmos5l_decap_8
XFILLER_18_683 vddd vssd sg13cmos5l_decap_8
X_4931_ _4949_/B _5988_/A _4931_/B vddd vssd sg13cmos5l_nand2_1
X_4862_ _4863_/B _4862_/A _4867_/B vddd vssd sg13cmos5l_xor2_1
X_6601_ _6601_/X _6601_/A0 _6650_/A _6602_/S vddd vssd sg13cmos5l_mux2_1
X_3813_ _3813_/Y mask_rev_in[29] _4263_/B _3786_/Y vddd vssd sg13cmos5l_o21ai_1
XFILLER_32_196 vddd vssd sg13cmos5l_decap_8
XANTENNA_37 _6801_/A vddd vssd sg13cmos5l_antennanp
XFILLER_18_1484 vddd vssd sg13cmos5l_decap_8
XANTENNA_48 wire7/X vddd vssd sg13cmos5l_antennanp
X_4793_ _4793_/Y _4792_/A _4776_/Y _4792_/Y vddd vssd sg13cmos5l_o21ai_1
XANTENNA_26 wire21/X vddd vssd sg13cmos5l_antennanp
XANTENNA_15 _3984_/A vddd vssd sg13cmos5l_antennanp
X_3744_ _3744_/Y _6301_/A _3961_/A vddd vssd sg13cmos5l_nor2_1
X_6532_ _6532_/Y _6532_/A _6536_/B vddd vssd sg13cmos5l_nor2_1
X_6463_ _7182_/D _6492_/A1 _6467_/S _6463_/B1 vddd vssd sg13cmos5l_o21ai_1
X_3675_ _4009_/A _3753_/D _3753_/C vddd vssd sg13cmos5l_nand2b_1
XFILLER_14_1359 vddd vssd sg13cmos5l_decap_8
Xoutbuffers\[84\] io_oe[11] _5271_/Y vddd vssd sg13cmos5l_buf_16
X_5414_ _5414_/Y _5414_/A _5414_/B _5414_/C _5414_/D vddd vssd sg13cmos5l_nand4_1
X_6394_ _6394_/Y _6405_/A _6393_/B hold711/X vddd vssd sg13cmos5l_a21oi_1
XFILLER_9_2342 vddd vssd sg13cmos5l_decap_8
X_5345_ _5345_/Y _7154_/Q _5348_/B vddd vssd sg13cmos5l_nor2b_1
XFILLER_25_1411 vddd vssd sg13cmos5l_decap_4
XFILLER_9_2386 vddd vssd sg13cmos5l_decap_8
X_5276_ _5276_/Y _4912_/A _3655_/A _4913_/B vddd vssd sg13cmos5l_o21ai_1
X_7015_ _7015_/Q _7348_/CLK _7015_/D _6962_/Y vddd vssd sg13cmos5l_dfrbpq_1
XFILLER_25_2178 vddd vssd sg13cmos5l_decap_4
X_4227_ _4227_/Y _4227_/A vddd vssd sg13cmos5l_inv_1
XFILLER_5_1538 vddd vssd sg13cmos5l_decap_8
X_4158_ _4158_/Y _4155_/Y _4156_/Y _4157_/Y vddd vssd sg13cmos5l_o21ai_1
X_4089_ _4089_/Y _4089_/A _4182_/B vddd vssd sg13cmos5l_nand2_1
XFILLER_24_664 vddd vssd sg13cmos5l_decap_8
XFILLER_19_1226 vddd vssd sg13cmos5l_decap_8
Xclkbuf_4_7__f_clk_regs _7401_/CLK clkbuf_3_3_0_clk_regs/X vddd vssd sg13cmos5l_buf_8
XFILLER_19_1259 vddd vssd sg13cmos5l_decap_8
XFILLER_12_837 vddd vssd sg13cmos5l_decap_8
XFILLER_23_196 vddd vssd sg13cmos5l_decap_8
XFILLER_32_1415 vddd vssd sg13cmos5l_decap_8
XFILLER_14_2561 vddd vssd sg13cmos5l_decap_8
XFILLER_11_63 vddd vssd sg13cmos5l_decap_8
Xfanout371 fanout371/X fanout372/X vddd vssd sg13cmos5l_buf_1
Xfanout360 fanout360/X fanout361/X vddd vssd sg13cmos5l_buf_1
XFILLER_21_2521 vddd vssd sg13cmos5l_decap_8
Xfanout393 _6957_/B_N fanout396/X vddd vssd sg13cmos5l_buf_1
Xfanout382 fanout382/X fanout384/X vddd vssd sg13cmos5l_buf_1
Xtiedowns\[16\] _5593_/A vddd vssd sg13cmos5l_antennanp
XFILLER_21_2598 vddd vssd sg13cmos5l_decap_8
XFILLER_19_2450 vddd vssd sg13cmos5l_decap_8
XFILLER_15_631 vddd vssd sg13cmos5l_decap_4
XFILLER_15_697 vddd vssd sg13cmos5l_decap_8
XFILLER_15_1602 vddd vssd sg13cmos5l_decap_8
XFILLER_10_380 vddd vssd sg13cmos5l_decap_8
XFILLER_32_1993 vddd vssd sg13cmos5l_decap_8
Xhold819 hold819/X _3593_/Y vddd vssd sg13cmos5l_dlygate4sd3_1
Xhold808 _7105_/D _6316_/Y vddd vssd sg13cmos5l_dlygate4sd3_1
XFILLER_6_2515 vddd vssd sg13cmos5l_decap_8
X_5130_ _5134_/C _5130_/A _7247_/Q _5144_/B vddd vssd sg13cmos5l_nor3_1
XFILLER_26_2465 vddd vssd sg13cmos5l_decap_8
X_5061_ _5243_/A _7254_/Q _7255_/Q vddd vssd sg13cmos5l_nor2b_1
Xhold1508 hold1508/X _7310_/Q vddd vssd sg13cmos5l_dlygate4sd3_1
X_4012_ _4012_/Y _7032_/Q _3706_/Y wire92/X _6207_/S _4010_/Y vddd vssd sg13cmos5l_a221oi_1
XFILLER_26_1797 vddd vssd sg13cmos5l_decap_8
XFILLER_20_2031 vddd vssd sg13cmos5l_decap_4
XFILLER_0_2114 vddd vssd sg13cmos5l_decap_4
XFILLER_4_2283 vddd vssd sg13cmos5l_decap_4
XFILLER_26_907 vddd vssd sg13cmos5l_decap_8
XFILLER_25_439 vddd vssd sg13cmos5l_decap_8
XFILLER_20_1374 vddd vssd sg13cmos5l_decap_8
X_5963_ _5964_/B _6225_/A _7240_/Q _5962_/X vddd vssd sg13cmos5l_o21ai_1
XFILLER_4_1582 vddd vssd sg13cmos5l_decap_8
X_4914_ _4931_/B _4954_/B vddd vssd sg13cmos5l_inv_1
X_5894_ _5897_/C _5901_/D _7232_/Q vddd vssd sg13cmos5l_nand2b_1
X_4845_ _4845_/Y _4832_/Y _4844_/Y hold730/X vddd vssd sg13cmos5l_o21ai_1
XFILLER_21_689 vddd vssd sg13cmos5l_decap_8
X_4776_ _4776_/Y _4812_/B _4786_/B _4488_/A _4775_/X vddd vssd sg13cmos5l_a22oi_1
X_3727_ _6597_/B _3940_/A _3727_/B vddd vssd sg13cmos5l_nand2b_1
X_6515_ _6515_/Y _6515_/A _6520_/B vddd vssd sg13cmos5l_nand2_1
X_6446_ _6446_/Y _6754_/A _6451_/B vddd vssd sg13cmos5l_nor2_1
X_3658_ _4267_/A _4182_/B vddd vssd sg13cmos5l_inv_1
X_3589_ _5861_/B _3589_/A vddd vssd sg13cmos5l_inv_1
X_6377_ _7137_/D _6405_/A _6382_/B _6377_/B1 vddd vssd sg13cmos5l_o21ai_1
X_5328_ _5328_/Y _5328_/A _5328_/B _5328_/C vddd vssd sg13cmos5l_nand3_1
XFILLER_5_2003 vddd vssd sg13cmos5l_decap_8
XFILLER_9_2183 vddd vssd sg13cmos5l_decap_8
XFILLER_29_712 vddd vssd sg13cmos5l_decap_8
X_5259_ _5260_/D _5259_/A _5241_/B vddd vssd sg13cmos5l_nor2b_1
XFILLER_28_200 vddd vssd sg13cmos5l_decap_8
XFILLER_17_918 vddd vssd sg13cmos5l_decap_8
XFILLER_16_417 vddd vssd sg13cmos5l_decap_8
X_7317__463 _7317_/RESET_B vddd vssd sg13cmos5l_tiehi
Xwire70 wire70/X wire70/A vddd vssd sg13cmos5l_buf_4
XFILLER_19_1001 vddd vssd sg13cmos5l_decap_8
Xwire81 wire81/X wire81/A vddd vssd sg13cmos5l_buf_4
Xwire92 wire92/X wire92/A vddd vssd sg13cmos5l_buf_2
XFILLER_24_483 vddd vssd sg13cmos5l_decap_8
XFILLER_16_1900 vddd vssd sg13cmos5l_decap_4
XFILLER_11_100 vddd vssd sg13cmos5l_decap_8
XFILLER_16_1944 vddd vssd sg13cmos5l_decap_8
XFILLER_16_1999 vddd vssd sg13cmos5l_decap_4
XFILLER_22_84 vddd vssd sg13cmos5l_decap_8
XFILLER_10_2233 vddd vssd sg13cmos5l_decap_8
XFILLER_0_0 vddd vssd sg13cmos5l_decap_8
Xfanout190 _6767_/A fanout198/X vddd vssd sg13cmos5l_buf_1
XFILLER_1_2489 vddd vssd sg13cmos5l_decap_8
XFILLER_17_1708 vddd vssd sg13cmos5l_decap_8
Xclkbuf_3_6_0_SCK_regs clkload8/A clkbuf_0_SCK_regs/X vddd vssd sg13cmos5l_buf_8
X_4630_ _4630_/Y _4630_/A _4630_/B vddd vssd sg13cmos5l_xnor2_1
XFILLER_8_42 vddd vssd sg13cmos5l_decap_8
XFILLER_15_1465 vddd vssd sg13cmos5l_decap_8
X_4561_ _4561_/Y _4461_/B _4557_/Y _4560_/Y _4507_/X _4559_/Y vddd vssd sg13cmos5l_a221oi_1
Xclkbuf_leaf_26_SCK_regs _7111_/CLK clkload7/A vddd vssd sg13cmos5l_buf_8
X_6300_ _6300_/Y _6299_/A _7388_/Q vddd vssd sg13cmos5l_nand2b_1
X_7280_ _7280_/Q _7285_/CLK _7280_/D fanout383/X vddd vssd sg13cmos5l_dfrbpq_1
Xhold605 _6330_/A _7112_/Q vddd vssd sg13cmos5l_dlygate4sd3_1
Xhold627 _7332_/D _4825_/X vddd vssd sg13cmos5l_dlygate4sd3_1
Xhold616 _4831_/B _7331_/Q vddd vssd sg13cmos5l_dlygate4sd3_1
X_3512_ _4303_/A _4272_/A vddd vssd sg13cmos5l_inv_1
X_4492_ _4492_/X _4492_/A _4810_/B vddd vssd sg13cmos5l_or2_1
XFILLER_28_2538 vddd vssd sg13cmos5l_decap_8
Xhold649 _4570_/B _4569_/Y vddd vssd sg13cmos5l_dlygate4sd3_1
X_6231_ _6231_/Y _6235_/A _6232_/B _6231_/C vddd vssd sg13cmos5l_nor3_1
Xhold638 _7398_/D _5278_/Y vddd vssd sg13cmos5l_dlygate4sd3_1
X_6162_ _6164_/A _5186_/B _6160_/Y _6161_/Y vddd vssd sg13cmos5l_a21oi_1
X_5113_ _5177_/B _7277_/Q _7276_/Q vddd vssd sg13cmos5l_nand2b_1
Xhold1316 _6723_/A1 _3620_/Y vddd vssd sg13cmos5l_dlygate4sd3_1
Xhold1305 _3578_/A _7213_/Q vddd vssd sg13cmos5l_dlygate4sd3_1
X_6093_ _6093_/Y _3901_/X _5131_/C _5132_/A vddd vssd sg13cmos5l_a21oi_1
Xoutbuffers\[47\] bandgap_trim[8] _6292_/Y vddd vssd sg13cmos5l_buf_16
Xhold1349 _7201_/D _6497_/Y vddd vssd sg13cmos5l_dlygate4sd3_1
X_5044_ _5248_/A _7282_/Q _7283_/Q vddd vssd sg13cmos5l_nand2b_1
Xhold1327 _6473_/A1 _3564_/Y vddd vssd sg13cmos5l_dlygate4sd3_1
Xhold1338 _7227_/D _6549_/Y vddd vssd sg13cmos5l_dlygate4sd3_1
X_6995_ _6995_/Q _7020_/CLK _6995_/D _6942_/Y vddd vssd sg13cmos5l_dfrbpq_1
XFILLER_0_1243 vddd vssd sg13cmos5l_decap_8
XFILLER_4_1390 vddd vssd sg13cmos5l_decap_8
X_5946_ _5946_/X _6979_/D _5946_/B vddd vssd sg13cmos5l_and2_1
X_5877_ _5877_/X _5876_/Y io_in[0] _5877_/S vddd vssd sg13cmos5l_mux2_1
XFILLER_21_453 vddd vssd sg13cmos5l_decap_8
X_4828_ _4903_/A _4828_/A _4911_/A vddd vssd sg13cmos5l_or2_1
X_4759_ _4759_/Y _4465_/B _4754_/Y _4758_/Y vddd vssd sg13cmos5l_o21ai_1
XFILLER_11_2542 vddd vssd sg13cmos5l_decap_8
X_6429_ _7164_/D hold871/X _6430_/S _6428_/Y vddd vssd sg13cmos5l_a21oi_1
XFILLER_29_553 vddd vssd sg13cmos5l_decap_8
XFILLER_22_1970 vddd vssd sg13cmos5l_decap_4
XFILLER_16_203 vddd vssd sg13cmos5l_decap_8
XFILLER_17_84 vddd vssd sg13cmos5l_decap_8
XFILLER_13_910 vddd vssd sg13cmos5l_decap_8
XFILLER_16_2442 vddd vssd sg13cmos5l_decap_8
XFILLER_12_464 vddd vssd sg13cmos5l_decap_8
XFILLER_13_998 vddd vssd sg13cmos5l_decap_8
XFILLER_32_1053 vddd vssd sg13cmos5l_decap_8
XFILLER_23_2468 vddd vssd sg13cmos5l_decap_8
XFILLER_23_1712 vddd vssd sg13cmos5l_decap_8
XFILLER_3_2518 vddd vssd sg13cmos5l_decap_8
XFILLER_21_2192 vddd vssd sg13cmos5l_decap_8
XFILLER_23_718 vddd vssd sg13cmos5l_decap_8
X_6780_ _6780_/Y _6780_/A _6784_/B vddd vssd sg13cmos5l_nand2_1
X_3992_ _3992_/X _6312_/A _3990_/Y _3991_/Y vddd vssd sg13cmos5l_a21o_1
X_5800_ _5801_/B _5294_/C _5819_/A _5813_/D _5828_/B2 _5813_/C vddd vssd sg13cmos5l_a221oi_1
X_5731_ _5731_/Y _5733_/B _5733_/C _5730_/Y vddd vssd sg13cmos5l_a21oi_1
XFILLER_30_2406 vddd vssd sg13cmos5l_decap_8
X_5662_ _5662_/Y _5779_/A1 _7201_/Q _5660_/Y vddd vssd sg13cmos5l_o21ai_1
X_4613_ _4613_/Y _4771_/A1 _3603_/Y _4771_/B1 _4610_/B vddd vssd sg13cmos5l_a22oi_1
X_5593_ _5595_/A _5593_/A _7190_/Q _7191_/Q vddd vssd sg13cmos5l_nor3_1
X_7401_ _7401_/Q _7401_/CLK _7401_/D _6914_/Y vddd vssd sg13cmos5l_dfrbpq_1
X_4544_ _4547_/B _4792_/A _4544_/B vddd vssd sg13cmos5l_and2_1
X_7332_ _7332_/Q _7348_/CLK _7332_/D _6846_/Y vddd vssd sg13cmos5l_dfrbpq_1
Xmax_cap110 _3877_/A _3984_/A vddd vssd sg13cmos5l_buf_4
X_7263_ _7263_/Q _7263_/CLK _7263_/D _6954_/B_N vddd vssd sg13cmos5l_dfrbpq_1
X_4475_ _4503_/A _4531_/A _4534_/A vddd vssd sg13cmos5l_nor2_1
X_6214_ _6227_/A _7236_/Q _6214_/B vddd vssd sg13cmos5l_nor2_1
X_7194_ _7194_/Q _7199_/CLK _7194_/D fanout363/X vddd vssd sg13cmos5l_dfrbpq_1
Xhold479 sram_addr[4] _5983_/X vddd vssd sg13cmos5l_dlygate4sd3_1
X_6145_ _6147_/B _6239_/A _6145_/B _6145_/C _6146_/B vddd vssd sg13cmos5l_or4_1
Xhold1113 _7289_/D _6652_/X vddd vssd sg13cmos5l_dlygate4sd3_1
XFILLER_22_1200 vddd vssd sg13cmos5l_decap_8
Xhold1124 _7256_/D _6601_/X vddd vssd sg13cmos5l_dlygate4sd3_1
Xhold1102 _6456_/A1 _7179_/Q vddd vssd sg13cmos5l_dlygate4sd3_1
X_6076_ _6076_/Y _6185_/C _6075_/A _6073_/Y _6075_/Y vddd vssd sg13cmos5l_a22oi_1
Xhold1157 _7277_/D _6632_/X vddd vssd sg13cmos5l_dlygate4sd3_1
X_5027_ _5032_/A _7276_/Q _7277_/Q _5218_/A vddd vssd sg13cmos5l_nor3_1
Xhold1146 _7039_/D _6710_/X vddd vssd sg13cmos5l_dlygate4sd3_1
Xhold1135 _7339_/D _4686_/X vddd vssd sg13cmos5l_dlygate4sd3_1
Xhold1179 _6669_/A1 _5234_/A vddd vssd sg13cmos5l_dlygate4sd3_1
Xhold1168 _6624_/A0 _7271_/Q vddd vssd sg13cmos5l_dlygate4sd3_1
XFILLER_0_1040 vddd vssd sg13cmos5l_decap_8
X_6978_ _6978_/Q _6981_/CLK _6978_/D _6925_/Y vddd vssd sg13cmos5l_dfrbpq_1
XFILLER_13_228 vddd vssd sg13cmos5l_decap_4
X_5929_ _5933_/B _5930_/A _5930_/B vddd vssd sg13cmos5l_and2_1
XFILLER_1_611 vddd vssd sg13cmos5l_decap_8
Xhold991 _3604_/A _7115_/Q vddd vssd sg13cmos5l_dlygate4sd3_1
Xhold980 _5927_/A _6971_/Q vddd vssd sg13cmos5l_dlygate4sd3_1
X_7321__459 _7321_/RESET_B vddd vssd sg13cmos5l_tiehi
XFILLER_27_1199 vddd vssd sg13cmos5l_decap_4
XFILLER_29_350 vddd vssd sg13cmos5l_decap_8
XFILLER_20_1929 vddd vssd sg13cmos5l_decap_4
XFILLER_17_545 vddd vssd sg13cmos5l_decap_8
XFILLER_9_733 vddd vssd sg13cmos5l_decap_8
XFILLER_9_788 vddd vssd sg13cmos5l_decap_8
XFILLER_12_1435 vddd vssd sg13cmos5l_decap_8
XFILLER_5_21 vddd vssd sg13cmos5l_decap_8
XFILLER_5_950 vddd vssd sg13cmos5l_decap_8
XFILLER_29_1954 vddd vssd sg13cmos5l_decap_8
X_4260_ _4261_/B mask_rev_in[8] wire85/X _3682_/X mask_rev_in[0] vddd vssd sg13cmos5l_a22oi_1
XFILLER_5_98 vddd vssd sg13cmos5l_decap_8
X_4191_ _4193_/C _7290_/Q _6653_/A _6646_/A _5212_/A vddd vssd sg13cmos5l_a22oi_1
XFILLER_7_2473 vddd vssd sg13cmos5l_decap_8
X_6901_ _6901_/Y _6901_/A _6901_/B_N vddd vssd sg13cmos5l_nor2b_1
XFILLER_3_1658 vddd vssd sg13cmos5l_decap_8
X_6832_ _6832_/Y _6840_/A _6893_/B_N vddd vssd sg13cmos5l_nor2b_1
X_6763_ _6763_/Y _6763_/A wire49/X vddd vssd sg13cmos5l_nor2_1
X_3975_ _3976_/B _7065_/Q _6746_/A wire70/X vddd vssd sg13cmos5l_a21oi_1
X_6694_ _6694_/X _6520_/A _6694_/A1 _6695_/S vddd vssd sg13cmos5l_mux2_1
X_5714_ _5718_/A _5712_/Y _5713_/Y _7208_/Q vddd vssd sg13cmos5l_o21ai_1
X_5645_ _5649_/B _6230_/A _5642_/Y _5643_/Y _5641_/X _5648_/B vddd vssd sg13cmos5l_a221oi_1
XFILLER_15_1081 vddd vssd sg13cmos5l_decap_8
X_5576_ _5576_/Y _5627_/A _7188_/Q _5572_/Y vddd vssd sg13cmos5l_o21ai_1
X_4527_ _4528_/B _4551_/B _3606_/Y _4526_/Y vddd vssd sg13cmos5l_a21oi_1
X_7315_ _7315_/Q _7328_/CLK _7315_/D _7315_/RESET_B vddd vssd sg13cmos5l_dfrbpq_1
XFILLER_12_1991 vddd vssd sg13cmos5l_decap_8
X_4458_ _4458_/Y _4458_/A _4458_/B _4533_/A vddd vssd sg13cmos5l_nor3_1
X_7246_ _7246_/Q _7291_/CLK _7246_/D fanout376/X vddd vssd sg13cmos5l_dfrbpq_1
XFILLER_8_2204 vddd vssd sg13cmos5l_decap_8
XFILLER_24_2018 vddd vssd sg13cmos5l_decap_8
X_7177_ _7177_/Q _7214_/CLK _7177_/D fanout361/X vddd vssd sg13cmos5l_dfrbpq_1
XFILLER_8_2248 vddd vssd sg13cmos5l_decap_8
X_6128_ _6128_/Y _6267_/A1 _5168_/B _6127_/Y vddd vssd sg13cmos5l_a21oi_1
X_4389_ _4391_/C _7336_/Q _7124_/Q vddd vssd sg13cmos5l_xnor2_1
XFILLER_27_821 vddd vssd sg13cmos5l_decap_4
X_6059_ _6059_/Y _3901_/X _5101_/A _6072_/B vddd vssd sg13cmos5l_a21oi_1
XFILLER_27_854 vddd vssd sg13cmos5l_decap_4
XFILLER_22_1096 vddd vssd sg13cmos5l_decap_8
XFILLER_14_63 vddd vssd sg13cmos5l_decap_8
XFILLER_10_732 vddd vssd sg13cmos5l_decap_8
XFILLER_13_2478 vddd vssd sg13cmos5l_decap_8
XFILLER_5_202 vddd vssd sg13cmos5l_decap_8
XFILLER_10_798 vddd vssd sg13cmos5l_decap_8
XFILLER_30_51 vddd vssd sg13cmos5l_decap_8
Xtiedowns\[46\] mask_rev_in[2] vddd vssd sg13cmos5l_antennanp
XFILLER_24_2530 vddd vssd sg13cmos5l_decap_8
XFILLER_7_1013 vddd vssd sg13cmos5l_decap_4
XFILLER_4_1934 vddd vssd sg13cmos5l_decap_8
XFILLER_20_1737 vddd vssd sg13cmos5l_decap_8
X_6902__467 _7389_/CLK _7164_/CLK vddd vssd sg13cmos5l_inv_1
XFILLER_4_1989 vddd vssd sg13cmos5l_decap_8
XFILLER_32_345 vddd vssd sg13cmos5l_decap_8
XFILLER_18_1611 vddd vssd sg13cmos5l_decap_4
XFILLER_14_2209 vddd vssd sg13cmos5l_decap_8
XFILLER_20_529 vddd vssd sg13cmos5l_decap_8
X_3760_ _3760_/Y _7373_/Q _4293_/C _7371_/Q vddd vssd sg13cmos5l_nor3_1
XFILLER_31_2534 vddd vssd sg13cmos5l_decap_8
X_3691_ _3928_/B _3693_/A _3693_/B vddd vssd sg13cmos5l_nand2_1
X_5430_ _5430_/Y _5319_/A _5441_/B _5428_/Y vddd vssd sg13cmos5l_o21ai_1
X_5361_ _5361_/Y _5361_/A _5361_/B _5361_/C vddd vssd sg13cmos5l_nor3_1
X_5292_ _5292_/Y _5287_/Y _5288_/Y _5291_/Y vddd vssd sg13cmos5l_o21ai_1
X_7100_ _7100_/Q _7111_/CLK _7100_/D fanout404/X vddd vssd sg13cmos5l_dfrbpq_1
X_4312_ _4968_/A _4312_/A _4312_/B vddd vssd sg13cmos5l_nand2_1
XFILLER_5_780 vddd vssd sg13cmos5l_decap_4
XFILLER_9_2513 vddd vssd sg13cmos5l_decap_8
XFILLER_29_2485 vddd vssd sg13cmos5l_decap_8
X_7031_ _7031_/Q _7286_/CLK _7031_/D fanout374/X vddd vssd sg13cmos5l_dfrbpq_1
X_4243_ _4243_/Y _7057_/Q wire70/X _4244_/A2 vddd vssd sg13cmos5l_a21oi_1
XFILLER_29_1795 vddd vssd sg13cmos5l_decap_8
XFILLER_25_2349 vddd vssd sg13cmos5l_decap_8
XFILLER_23_2051 vddd vssd sg13cmos5l_decap_8
X_4174_ _4174_/X _4171_/Y _4172_/Y _4173_/X vddd vssd sg13cmos5l_a21o_1
XFILLER_27_117 vddd vssd sg13cmos5l_decap_8
Xclkbuf_4_6__f_clk_regs _7398_/CLK clkbuf_3_3_0_clk_regs/X vddd vssd sg13cmos5l_buf_8
X_6815_ _6815_/Y _6898_/A _6916_/B_N vddd vssd sg13cmos5l_nor2b_1
X_6746_ _6752_/S _6746_/A _6753_/B vddd vssd sg13cmos5l_nand2_1
X_3958_ _3958_/Y _5472_/B _6438_/A _3957_/Y _3954_/Y vddd vssd sg13cmos5l_a22oi_1
X_6677_ _7316_/D _6677_/A1 _6683_/S _6676_/Y vddd vssd sg13cmos5l_o21ai_1
X_3889_ _6590_/A _3889_/A wire95/X vddd vssd sg13cmos5l_nand2_1
X_5628_ _5628_/Y _5783_/A _5647_/B vddd vssd sg13cmos5l_nor2_1
XFILLER_30_1365 vddd vssd sg13cmos5l_decap_4
X_5559_ _5559_/Y _5554_/Y _5555_/X _5558_/Y vddd vssd sg13cmos5l_o21ai_1
XFILLER_30_1398 vddd vssd sg13cmos5l_decap_8
XFILLER_4_7 vddd vssd sg13cmos5l_decap_4
XFILLER_24_1103 vddd vssd sg13cmos5l_decap_8
X_7229_ _7229_/Q _7229_/CLK _7229_/D fanout368/X vddd vssd sg13cmos5l_dfrbpq_1
XFILLER_8_1344 vddd vssd sg13cmos5l_decap_8
XFILLER_6_1090 vddd vssd sg13cmos5l_decap_4
XFILLER_15_802 vddd vssd sg13cmos5l_decap_8
XFILLER_25_51 vddd vssd sg13cmos5l_decap_8
XFILLER_15_2507 vddd vssd sg13cmos5l_decap_8
XFILLER_15_879 vddd vssd sg13cmos5l_decap_8
XFILLER_19_1964 vddd vssd sg13cmos5l_decap_8
XFILLER_30_849 vddd vssd sg13cmos5l_decap_8
XFILLER_6_500 vddd vssd sg13cmos5l_decap_8
XFILLER_10_540 vddd vssd sg13cmos5l_decap_8
XFILLER_6_577 vddd vssd sg13cmos5l_decap_4
XFILLER_2_761 vddd vssd sg13cmos5l_decap_8
XFILLER_24_2382 vddd vssd sg13cmos5l_decap_8
XFILLER_20_2213 vddd vssd sg13cmos5l_decap_4
XFILLER_24_1670 vddd vssd sg13cmos5l_decap_8
XFILLER_20_1523 vddd vssd sg13cmos5l_decap_8
XFILLER_18_662 vddd vssd sg13cmos5l_decap_8
XFILLER_4_1786 vddd vssd sg13cmos5l_decap_8
X_4930_ _4935_/B _5985_/S _4954_/B vddd vssd sg13cmos5l_nor2_1
XFILLER_0_1639 vddd vssd sg13cmos5l_decap_8
X_4861_ _4861_/Y _4832_/B _4862_/A vddd vssd sg13cmos5l_nand2b_1
X_6600_ _6600_/X _6600_/A0 _6788_/A1 _6602_/S vddd vssd sg13cmos5l_mux2_1
X_3812_ _3812_/Y mask_rev_in[21] _4262_/A2 _3810_/Y _3811_/Y _3748_/Y vddd vssd sg13cmos5l_a221oi_1
XFILLER_32_175 vddd vssd sg13cmos5l_decap_8
XANTENNA_38 _6777_/A vddd vssd sg13cmos5l_antennanp
XANTENNA_27 wire81/X vddd vssd sg13cmos5l_antennanp
X_4792_ _4792_/Y _4792_/A _4792_/B _4792_/C _4792_/D vddd vssd sg13cmos5l_nand4_1
XANTENNA_16 _3984_/A vddd vssd sg13cmos5l_antennanp
XANTENNA_49 _6344_/A vddd vssd sg13cmos5l_antennanp
X_3743_ _3743_/Y mask_rev_in[7] _4081_/B _3742_/Y vddd vssd sg13cmos5l_o21ai_1
X_6531_ _6531_/Y _6540_/A1 _6536_/B hold901/X vddd vssd sg13cmos5l_o21ai_1
XFILLER_14_1327 vddd vssd sg13cmos5l_decap_8
X_6462_ _6462_/Y _6462_/A _6467_/S vddd vssd sg13cmos5l_nand2_1
X_3674_ _3753_/D _4357_/A _4972_/A _3674_/S vddd vssd sg13cmos5l_mux2_1
X_6393_ _6393_/Y _6393_/A _6393_/B vddd vssd sg13cmos5l_nor2_1
X_5413_ _5414_/D _5413_/A _7165_/Q _5413_/C _5413_/D vddd vssd sg13cmos5l_nand4_1
X_5344_ _5344_/Y _5342_/Y _5343_/Y _5348_/C vddd vssd sg13cmos5l_o21ai_1
Xoutbuffers\[77\] io_oe[4] _5135_/Y vddd vssd sg13cmos5l_buf_16
XFILLER_25_2146 vddd vssd sg13cmos5l_decap_4
X_5275_ _7400_/D _5275_/A vddd vssd sg13cmos5l_inv_1
X_7014_ _7014_/Q _7343_/CLK _7014_/D _6961_/Y vddd vssd sg13cmos5l_dfrbpq_1
X_4226_ _4227_/A _7182_/Q _6461_/A _6453_/A _7178_/Q _6445_/A vddd vssd sg13cmos5l_a221oi_1
XFILLER_29_927 vddd vssd sg13cmos5l_decap_4
X_4157_ _4157_/Y _7041_/Q _3836_/Y _4159_/B vddd vssd sg13cmos5l_a21oi_1
XFILLER_21_1309 vddd vssd sg13cmos5l_decap_8
XFILLER_9_1697 vddd vssd sg13cmos5l_decap_8
X_4088_ _4088_/Y _4091_/A _4267_/B _7023_/D vddd vssd sg13cmos5l_o21ai_1
XFILLER_24_621 vddd vssd sg13cmos5l_decap_8
XFILLER_19_1205 vddd vssd sg13cmos5l_decap_8
XFILLER_23_175 vddd vssd sg13cmos5l_decap_8
XFILLER_14_2540 vddd vssd sg13cmos5l_decap_8
X_6729_ _6729_/X _6668_/A _6729_/A1 _6735_/S vddd vssd sg13cmos5l_mux2_1
XFILLER_14_1861 vddd vssd sg13cmos5l_decap_8
XFILLER_30_1140 vddd vssd sg13cmos5l_decap_8
XFILLER_11_42 vddd vssd sg13cmos5l_decap_8
XFILLER_30_1184 vddd vssd sg13cmos5l_decap_8
Xfanout350 fanout350/X fanout353/X vddd vssd sg13cmos5l_buf_1
XFILLER_21_2500 vddd vssd sg13cmos5l_decap_8
Xfanout361 fanout361/X fanout372/X vddd vssd sg13cmos5l_buf_1
Xfanout372 fanout372/X fanout411/X vddd vssd sg13cmos5l_buf_1
XFILLER_28_1091 vddd vssd sg13cmos5l_decap_8
Xfanout383 fanout383/X fanout384/X vddd vssd sg13cmos5l_buf_1
XFILLER_8_1185 vddd vssd sg13cmos5l_decap_4
Xfanout394 _6960_/B_N fanout396/X vddd vssd sg13cmos5l_buf_1
XFILLER_19_415 vddd vssd sg13cmos5l_decap_8
XFILLER_8_1196 vddd vssd sg13cmos5l_decap_8
XFILLER_28_971 vddd vssd sg13cmos5l_decap_8
XFILLER_21_2577 vddd vssd sg13cmos5l_decap_8
XFILLER_21_1876 vddd vssd sg13cmos5l_decap_4
XFILLER_13_2083 vddd vssd sg13cmos5l_decap_8
XFILLER_32_1972 vddd vssd sg13cmos5l_decap_8
Xhold809 _3608_/A _7119_/Q vddd vssd sg13cmos5l_dlygate4sd3_1
XFILLER_7_886 vddd vssd sg13cmos5l_decap_8
XFILLER_26_2444 vddd vssd sg13cmos5l_decap_8
XFILLER_26_1721 vddd vssd sg13cmos5l_decap_8
X_5060_ _5068_/B _5080_/C _5157_/A vddd vssd sg13cmos5l_nand2_1
X_6908__473 _7395_/CLK _7164_/CLK vddd vssd sg13cmos5l_inv_1
XFILLER_26_1776 vddd vssd sg13cmos5l_decap_8
X_4011_ _4015_/B _7284_/Q _6640_/A vddd vssd sg13cmos5l_and2_1
Xhold1509 hold949/A _7309_/Q vddd vssd sg13cmos5l_dlygate4sd3_1
XFILLER_20_1331 vddd vssd sg13cmos5l_decap_8
X_5962_ _5962_/X _6224_/A _7241_/Q vddd vssd sg13cmos5l_or2_1
X_4913_ _4913_/Y _4913_/A _4913_/B _4913_/C vddd vssd sg13cmos5l_nand3_1
X_5893_ _5896_/B _5891_/Y _5892_/Y _5890_/Y vddd vssd sg13cmos5l_o21ai_1
XFILLER_20_112 vddd vssd sg13cmos5l_decap_4
X_4844_ _4844_/Y _4853_/A sram_odata[5] _4843_/X vddd vssd sg13cmos5l_o21ai_1
XFILLER_21_668 vddd vssd sg13cmos5l_decap_8
X_4775_ _4775_/X _6807_/A _4775_/B vddd vssd sg13cmos5l_xor2_1
X_6514_ _6520_/B _6514_/A _6545_/B vddd vssd sg13cmos5l_nand2_1
X_3726_ wire96/A _3940_/A _4009_/B vddd vssd sg13cmos5l_nor2_1
X_3657_ _4182_/B _7375_/Q _7403_/Q vddd vssd sg13cmos5l_nand2_1
X_6445_ _6451_/B _6445_/A _6475_/B vddd vssd sg13cmos5l_nand2_1
XFILLER_27_2219 vddd vssd sg13cmos5l_decap_8
X_6376_ _6376_/Y _6376_/A _6382_/B vddd vssd sg13cmos5l_nand2_1
X_3588_ _5863_/A _3588_/A vddd vssd sg13cmos5l_inv_1
X_5327_ _5328_/C _5327_/A _5327_/B _5331_/A vddd vssd sg13cmos5l_nand3_1
XFILLER_0_539 vddd vssd sg13cmos5l_decap_8
XFILLER_5_2037 vddd vssd sg13cmos5l_decap_8
X_5258_ _5260_/C _5258_/A _5258_/B vddd vssd sg13cmos5l_nor2_1
XFILLER_29_735 vddd vssd sg13cmos5l_decap_8
X_5189_ _5256_/B _7284_/Q _7285_/Q vddd vssd sg13cmos5l_nand2b_1
X_4209_ _4209_/Y _4202_/Y _4203_/Y _6037_/A _4115_/A _4206_/Y vddd vssd sg13cmos5l_a221oi_1
XFILLER_8_628 vddd vssd sg13cmos5l_decap_4
XFILLER_12_657 vddd vssd sg13cmos5l_decap_8
XFILLER_16_1978 vddd vssd sg13cmos5l_decap_8
XFILLER_10_2212 vddd vssd sg13cmos5l_decap_8
XFILLER_32_1268 vddd vssd sg13cmos5l_decap_8
XFILLER_22_63 vddd vssd sg13cmos5l_decap_8
XFILLER_10_1500 vddd vssd sg13cmos5l_decap_8
XFILLER_14_1691 vddd vssd sg13cmos5l_decap_8
XFILLER_4_834 vddd vssd sg13cmos5l_decap_8
XFILLER_3_322 vddd vssd sg13cmos5l_decap_8
XFILLER_10_1566 vddd vssd sg13cmos5l_decap_8
Xfanout180 _6769_/A1 fanout188/X vddd vssd sg13cmos5l_buf_1
Xfanout191 _6472_/A _6692_/A vddd vssd sg13cmos5l_buf_1
XFILLER_5_2582 vddd vssd sg13cmos5l_decap_8
XFILLER_19_256 vddd vssd sg13cmos5l_decap_8
XFILLER_16_996 vddd vssd sg13cmos5l_decap_8
XFILLER_31_933 vddd vssd sg13cmos5l_decap_8
XFILLER_8_21 vddd vssd sg13cmos5l_decap_8
X_4560_ _4560_/Y _4534_/B _4556_/B _4553_/A vddd vssd sg13cmos5l_o21ai_1
XFILLER_15_2178 vddd vssd sg13cmos5l_decap_8
XFILLER_32_2481 vddd vssd sg13cmos5l_decap_8
XFILLER_8_98 vddd vssd sg13cmos5l_decap_8
Xhold606 hold606/X _6330_/Y vddd vssd sg13cmos5l_dlygate4sd3_1
X_3511_ _4533_/A _4169_/A vddd vssd sg13cmos5l_inv_1
Xhold617 hold617/X _4831_/Y vddd vssd sg13cmos5l_dlygate4sd3_1
X_4491_ _4491_/Y _4808_/A _4437_/B _4437_/A vddd vssd sg13cmos5l_o21ai_1
XFILLER_28_2517 vddd vssd sg13cmos5l_decap_8
X_6230_ _6230_/X _6230_/A _6230_/B vddd vssd sg13cmos5l_and2_1
Xhold628 _4856_/B _7326_/Q vddd vssd sg13cmos5l_dlygate4sd3_1
Xhold639 _4902_/B _7398_/Q vddd vssd sg13cmos5l_dlygate4sd3_1
X_6161_ _6161_/Y _6049_/A _5186_/B _5184_/C vddd vssd sg13cmos5l_o21ai_1
X_5112_ _5134_/B _7270_/Q _7271_/Q _5170_/B vddd vssd sg13cmos5l_nor3_1
XFILLER_26_0 vddd vssd sg13cmos5l_decap_8
Xhold1306 _6521_/A1 _5752_/B vddd vssd sg13cmos5l_dlygate4sd3_1
X_6092_ _6092_/Y _5132_/D _6090_/Y _6091_/Y vddd vssd sg13cmos5l_o21ai_1
Xhold1339 hold1339/X _7160_/Q vddd vssd sg13cmos5l_dlygate4sd3_1
Xhold1328 _6725_/A0 _7049_/Q vddd vssd sg13cmos5l_dlygate4sd3_1
Xhold1317 _7047_/D _6723_/Y vddd vssd sg13cmos5l_dlygate4sd3_1
X_5043_ _5043_/Y _5043_/A _5043_/B _5043_/C vddd vssd sg13cmos5l_nand3_1
XFILLER_4_2070 vddd vssd sg13cmos5l_decap_8
XFILLER_6_1678 vddd vssd sg13cmos5l_decap_4
X_6994_ _6994_/Q _7343_/CLK _6994_/D _6941_/Y vddd vssd sg13cmos5l_dfrbpq_1
XFILLER_26_749 vddd vssd sg13cmos5l_decap_4
XFILLER_0_1222 vddd vssd sg13cmos5l_decap_8
XFILLER_22_911 vddd vssd sg13cmos5l_decap_8
X_5945_ _5945_/Y _5945_/A _5945_/B vddd vssd sg13cmos5l_nor2_1
XFILLER_0_1299 vddd vssd sg13cmos5l_decap_8
X_5876_ _5876_/Y _5874_/Y _5876_/B vddd vssd sg13cmos5l_nand2b_1
X_4827_ _4827_/Y hold845/A hold636/X _3653_/Y _4826_/Y vddd vssd sg13cmos5l_a22oi_1
XFILLER_11_2521 vddd vssd sg13cmos5l_decap_8
X_4758_ _4758_/Y _4501_/B _4737_/Y _4758_/B1 vddd vssd sg13cmos5l_a21oi_1
X_3709_ _3709_/Y _3878_/A _3938_/A _3938_/B _4010_/C vddd vssd sg13cmos5l_nor4_1
X_4689_ _4689_/Y _4468_/B _4694_/B vddd vssd sg13cmos5l_nand2b_1
X_6428_ _6428_/Y _6472_/A _6430_/S vddd vssd sg13cmos5l_nor2_1
XFILLER_11_2598 vddd vssd sg13cmos5l_decap_8
X_6359_ _6359_/Y _6359_/A _6359_/B vddd vssd sg13cmos5l_nand2_1
XFILLER_27_1359 vddd vssd sg13cmos5l_decap_8
XFILLER_29_587 vddd vssd sg13cmos5l_decap_4
XFILLER_17_63 vddd vssd sg13cmos5l_decap_8
XFILLER_16_2421 vddd vssd sg13cmos5l_decap_8
XFILLER_12_443 vddd vssd sg13cmos5l_decap_8
XFILLER_16_2498 vddd vssd sg13cmos5l_decap_8
XFILLER_16_1753 vddd vssd sg13cmos5l_decap_8
XFILLER_32_1032 vddd vssd sg13cmos5l_decap_8
XFILLER_12_1606 vddd vssd sg13cmos5l_decap_8
Xtiedowns\[76\] _6898_/A vddd vssd sg13cmos5l_antennanp
XFILLER_10_2086 vddd vssd sg13cmos5l_decap_8
XFILLER_27_2583 vddd vssd sg13cmos5l_decap_8
XFILLER_23_2447 vddd vssd sg13cmos5l_decap_8
XFILLER_23_1757 vddd vssd sg13cmos5l_decap_8
XFILLER_22_207 vddd vssd sg13cmos5l_decap_8
XFILLER_17_2207 vddd vssd sg13cmos5l_decap_8
X_3991_ _3991_/Y _7107_/Q _6312_/A _3848_/Y vddd vssd sg13cmos5l_o21ai_1
X_5730_ _5730_/Y _5730_/A _5730_/B vddd vssd sg13cmos5l_nor2_1
XFILLER_30_240 vddd vssd sg13cmos5l_decap_4
X_5661_ _5661_/Y _5861_/A _5661_/B _5673_/A vddd vssd sg13cmos5l_nor3_1
X_7400_ _7400_/Q _7400_/CLK _7400_/D _6913_/Y vddd vssd sg13cmos5l_dfrbpq_1
X_5592_ _5617_/C _7190_/Q _5601_/B vddd vssd sg13cmos5l_nand2_1
X_4612_ _4612_/Y _4610_/Y _4611_/Y _4601_/Y vddd vssd sg13cmos5l_o21ai_1
XFILLER_15_1274 vddd vssd sg13cmos5l_decap_8
XFILLER_11_1105 vddd vssd sg13cmos5l_decap_8
X_4543_ _4544_/B _4541_/Y _4542_/Y _4529_/Y vddd vssd sg13cmos5l_o21ai_1
X_7331_ _7331_/Q _7401_/CLK _7331_/D _6845_/Y vddd vssd sg13cmos5l_dfrbpq_1
X_7262_ _7262_/Q _7264_/CLK _7262_/D fanout381/X vddd vssd sg13cmos5l_dfrbpq_1
XFILLER_28_1602 vddd vssd sg13cmos5l_decap_8
X_4474_ _4534_/A _4524_/A _4556_/A vddd vssd sg13cmos5l_nand2_1
X_6213_ _6214_/B _6213_/A _6213_/B vddd vssd sg13cmos5l_nor2_1
XFILLER_28_1635 vddd vssd sg13cmos5l_decap_8
X_7193_ _7193_/Q _7199_/CLK _7193_/D fanout363/X vddd vssd sg13cmos5l_dfrbpq_1
XFILLER_8_1707 vddd vssd sg13cmos5l_decap_8
XFILLER_28_1668 vddd vssd sg13cmos5l_decap_8
XFILLER_6_2132 vddd vssd sg13cmos5l_decap_8
X_6144_ _6144_/X _6144_/A _6144_/B vddd vssd sg13cmos5l_or2_1
Xhold1114 _3586_/A _7225_/Q vddd vssd sg13cmos5l_dlygate4sd3_1
Xhold1103 _7179_/D _6456_/X vddd vssd sg13cmos5l_dlygate4sd3_1
X_6075_ _6075_/Y _6075_/A _6075_/B vddd vssd sg13cmos5l_nor2_1
X_5026_ _5218_/A _7275_/Q _7274_/Q vddd vssd sg13cmos5l_nand2b_1
Xhold1147 _3566_/A _7191_/Q vddd vssd sg13cmos5l_dlygate4sd3_1
Xhold1136 _6625_/A0 _7272_/Q vddd vssd sg13cmos5l_dlygate4sd3_1
Xhold1125 _3616_/A _7235_/Q vddd vssd sg13cmos5l_dlygate4sd3_1
Xhold1158 _3562_/A _7181_/Q vddd vssd sg13cmos5l_dlygate4sd3_1
Xhold1169 _7271_/D _6624_/X vddd vssd sg13cmos5l_dlygate4sd3_1
XFILLER_6_1475 vddd vssd sg13cmos5l_decap_4
XFILLER_26_524 vddd vssd sg13cmos5l_decap_8
X_6977_ _6977_/Q _6981_/CLK _6977_/D _6924_/Y vddd vssd sg13cmos5l_dfrbpq_1
X_5928_ _5928_/Y _5928_/A _5945_/A _5930_/B vddd vssd sg13cmos5l_nor3_1
XFILLER_22_730 vddd vssd sg13cmos5l_decap_8
XFILLER_16_1027 vddd vssd sg13cmos5l_decap_8
XFILLER_13_1904 vddd vssd sg13cmos5l_decap_8
X_5859_ _5859_/Y _5863_/A _5861_/B vddd vssd sg13cmos5l_nor2_1
XFILLER_13_1937 vddd vssd sg13cmos5l_decap_8
XFILLER_10_969 vddd vssd sg13cmos5l_decap_8
Xhold981 hold981/X _5923_/Y vddd vssd sg13cmos5l_dlygate4sd3_1
Xhold970 hold970/X _7261_/Q vddd vssd sg13cmos5l_dlygate4sd3_1
Xhold992 hold992/X _3863_/A vddd vssd sg13cmos5l_dlygate4sd3_1
XFILLER_27_1178 vddd vssd sg13cmos5l_decap_8
XFILLER_0_188 vddd vssd sg13cmos5l_decap_8
XFILLER_2_2530 vddd vssd sg13cmos5l_decap_8
XFILLER_28_51 vddd vssd sg13cmos5l_decap_8
XFILLER_20_1908 vddd vssd sg13cmos5l_decap_8
XFILLER_18_2549 vddd vssd sg13cmos5l_decap_8
XFILLER_9_767 vddd vssd sg13cmos5l_decap_8
XFILLER_29_1933 vddd vssd sg13cmos5l_decap_8
XFILLER_5_77 vddd vssd sg13cmos5l_decap_8
XFILLER_29_1977 vddd vssd sg13cmos5l_decap_4
X_4190_ _4193_/B _4187_/Y _4188_/Y _4189_/X vddd vssd sg13cmos5l_a21o_1
XFILLER_27_2380 vddd vssd sg13cmos5l_decap_8
XFILLER_7_1740 vddd vssd sg13cmos5l_decap_8
XFILLER_7_2452 vddd vssd sg13cmos5l_decap_8
XFILLER_3_1637 vddd vssd sg13cmos5l_decap_8
XFILLER_3_1615 vddd vssd sg13cmos5l_decap_8
X_6900_ _6900_/Y _6901_/A _6901_/B_N vddd vssd sg13cmos5l_nor2b_1
Xclkbuf_4_5__f_clk_regs _7400_/CLK clkbuf_3_2_0_clk_regs/X vddd vssd sg13cmos5l_buf_8
X_6831_ _6831_/Y _6840_/A _6840_/B_N vddd vssd sg13cmos5l_nor2b_1
X_3974_ _3976_/A _7070_/Q _6753_/A _3821_/Y _7076_/Q _3973_/Y vddd vssd sg13cmos5l_a221oi_1
X_6762_ wire49/A _6762_/A _6762_/B _6762_/C vddd vssd sg13cmos5l_nor3_1
XFILLER_17_2059 vddd vssd sg13cmos5l_decap_8
Xoutbuffers\[3\] analog_bus_ena[1] _7037_/Q vddd vssd sg13cmos5l_buf_16
X_6693_ _6693_/Y _6693_/A1 _6695_/S _6692_/Y vddd vssd sg13cmos5l_a21oi_1
XFILLER_17_1336 vddd vssd sg13cmos5l_decap_8
X_5713_ _5713_/Y _5713_/A _5713_/B vddd vssd sg13cmos5l_nor2_1
X_5644_ _5648_/B _7196_/Q _7197_/Q _5644_/C vddd vssd sg13cmos5l_nor3_1
XFILLER_30_1525 vddd vssd sg13cmos5l_decap_8
XFILLER_15_1060 vddd vssd sg13cmos5l_decap_8
Xclkbuf_leaf_10_SCK_regs _7077_/CLK clkload5/A vddd vssd sg13cmos5l_buf_8
X_5575_ _5575_/Y _5783_/A _5583_/B vddd vssd sg13cmos5l_nor2_1
X_7314_ _7314_/Q _7400_/CLK _7314_/D _6836_/Y vddd vssd sg13cmos5l_dfrbpq_1
X_4526_ _4526_/Y _5659_/A _4551_/B vddd vssd sg13cmos5l_nor2_1
XFILLER_12_1970 vddd vssd sg13cmos5l_decap_8
X_7245_ _7245_/Q _7292_/CLK _7245_/D fanout376/X vddd vssd sg13cmos5l_dfrbpq_1
X_4457_ _4460_/A _4501_/B _4536_/A vddd vssd sg13cmos5l_nor2_1
X_7176_ _7176_/Q _7214_/CLK _7176_/D fanout362/X vddd vssd sg13cmos5l_dfrbpq_1
XFILLER_8_1504 vddd vssd sg13cmos5l_decap_8
XFILLER_28_1476 vddd vssd sg13cmos5l_decap_8
XFILLER_24_1318 vddd vssd sg13cmos5l_decap_8
X_6127_ _6127_/Y _6037_/A _5162_/B _6125_/Y _6126_/Y _5168_/B vddd vssd sg13cmos5l_a221oi_1
X_4388_ _4392_/D _7339_/Q _7127_/Q vddd vssd sg13cmos5l_xor2_1
X_7320__460 _7320_/RESET_B vddd vssd sg13cmos5l_tiehi
X_6058_ _6058_/Y _4782_/A _6057_/B _6057_/Y vddd vssd sg13cmos5l_a21oi_1
X_5009_ _5013_/B _5009_/A _5009_/B _5009_/C vddd vssd sg13cmos5l_nor3_1
XFILLER_22_1064 vddd vssd sg13cmos5l_decap_8
XFILLER_14_549 vddd vssd sg13cmos5l_decap_8
XFILLER_22_560 vddd vssd sg13cmos5l_decap_8
XFILLER_14_42 vddd vssd sg13cmos5l_decap_8
XFILLER_13_2457 vddd vssd sg13cmos5l_decap_8
XFILLER_6_726 vddd vssd sg13cmos5l_decap_8
XFILLER_30_30 vddd vssd sg13cmos5l_decap_8
XFILLER_6_759 vddd vssd sg13cmos5l_decap_8
XFILLER_11_2170 vddd vssd sg13cmos5l_decap_8
Xtiedowns\[39\] dbus_in_right[7] vddd vssd sg13cmos5l_antennanp
XFILLER_24_2586 vddd vssd sg13cmos5l_decap_8
XFILLER_20_1716 vddd vssd sg13cmos5l_decap_8
XFILLER_18_844 vddd vssd sg13cmos5l_decap_8
XFILLER_32_324 vddd vssd sg13cmos5l_decap_8
XFILLER_31_2513 vddd vssd sg13cmos5l_decap_8
XFILLER_14_1509 vddd vssd sg13cmos5l_decap_8
X_3690_ _3980_/A _3938_/B _3940_/B vddd vssd sg13cmos5l_or2_1
XFILLER_12_1266 vddd vssd sg13cmos5l_decap_8
X_5360_ _5361_/C _5416_/A _5360_/B _5360_/C vddd vssd sg13cmos5l_nor3_1
XFILLER_29_2464 vddd vssd sg13cmos5l_decap_8
X_5291_ _5291_/Y _5294_/A _5326_/A _5290_/Y vddd vssd sg13cmos5l_o21ai_1
X_4311_ _4311_/Y _3491_/Y hold813/X _4301_/B vddd vssd sg13cmos5l_a21oi_1
X_7030_ _7030_/Q _7201_/CLK _7030_/D fanout370/X vddd vssd sg13cmos5l_dfrbpq_1
X_4242_ _4242_/Y _7062_/Q _3826_/Y _4240_/Y _4241_/Y vddd vssd sg13cmos5l_a22oi_1
XFILLER_25_2328 vddd vssd sg13cmos5l_decap_8
XFILLER_9_2569 vddd vssd sg13cmos5l_decap_8
XFILLER_29_1774 vddd vssd sg13cmos5l_decap_8
X_4173_ _4173_/X mask_rev_in[1] _3682_/X wire85/X vddd vssd sg13cmos5l_a21o_1
XFILLER_7_1570 vddd vssd sg13cmos5l_decap_4
Xoutbuffers\[22\] voltgen_source[3] _7076_/Q vddd vssd sg13cmos5l_buf_16
X_6814_ _6814_/X _6814_/A vddd vssd sg13cmos5l_buf_1
X_6745_ _6745_/X _6745_/A0 _6769_/A1 _6745_/S vddd vssd sg13cmos5l_mux2_1
X_3957_ _3957_/Y _5498_/D _6445_/A _6438_/A vddd vssd sg13cmos5l_a21oi_1
Xclkbuf_0_clk_regs clkbuf_0_clk_regs/X clkbuf_regs_0_clk/X vddd vssd sg13cmos5l_buf_8
XFILLER_17_1188 vddd vssd sg13cmos5l_decap_8
X_6676_ _6676_/Y sram_odata[1] _6683_/S vddd vssd sg13cmos5l_nand2_1
X_3888_ _3894_/B _3889_/A wire95/X vddd vssd sg13cmos5l_and2_1
X_5627_ _5627_/Y _5627_/A _7196_/Q vddd vssd sg13cmos5l_nor2_1
X_5558_ _5558_/Y _5730_/A _5556_/Y _5557_/Y vddd vssd sg13cmos5l_a21oi_1
X_4509_ _4509_/Y _4553_/A _4508_/Y _4650_/A vddd vssd sg13cmos5l_a21oi_1
X_7228_ _7228_/Q _7228_/CLK _7228_/D fanout368/X vddd vssd sg13cmos5l_dfrbpq_1
Xwire1 wire1/X wire2/X vddd vssd sg13cmos5l_buf_4
X_5489_ _5491_/A _6057_/A _7177_/Q _5486_/B vddd vssd sg13cmos5l_a21oi_1
XFILLER_8_1323 vddd vssd sg13cmos5l_decap_8
X_7159_ _7159_/Q _7189_/CLK _7159_/D fanout360/X vddd vssd sg13cmos5l_dfrbpq_1
XFILLER_25_30 vddd vssd sg13cmos5l_decap_8
XFILLER_26_195 vddd vssd sg13cmos5l_decap_8
XFILLER_15_858 vddd vssd sg13cmos5l_decap_8
XFILLER_30_817 vddd vssd sg13cmos5l_decap_4
XFILLER_23_880 vddd vssd sg13cmos5l_decap_8
XFILLER_19_1987 vddd vssd sg13cmos5l_decap_8
XFILLER_13_1597 vddd vssd sg13cmos5l_decap_4
XFILLER_29_1026 vddd vssd sg13cmos5l_decap_8
XFILLER_4_2455 vddd vssd sg13cmos5l_decap_8
XFILLER_20_2258 vddd vssd sg13cmos5l_decap_8
XFILLER_4_1743 vddd vssd sg13cmos5l_decap_4
XFILLER_18_630 vddd vssd sg13cmos5l_decap_8
XFILLER_18_2132 vddd vssd sg13cmos5l_decap_8
X_4860_ _4860_/Y _4832_/Y _4859_/Y hold629/X vddd vssd sg13cmos5l_o21ai_1
XFILLER_32_154 vddd vssd sg13cmos5l_decap_8
Xoutbuffers\[112\] dbus_out[15] _5737_/Y vddd vssd sg13cmos5l_buf_16
X_3811_ _3811_/Y _3627_/Y wire85/X _4262_/A2 vddd vssd sg13cmos5l_a21oi_1
XFILLER_31_2310 vddd vssd sg13cmos5l_decap_4
XANTENNA_17 _3984_/A vddd vssd sg13cmos5l_antennanp
XANTENNA_28 _3740_/B vddd vssd sg13cmos5l_antennanp
X_4791_ _4792_/D _4533_/A _4775_/X _4803_/A vddd vssd sg13cmos5l_a21o_1
X_6530_ _6530_/Y _6530_/A _6536_/B vddd vssd sg13cmos5l_nand2_1
XANTENNA_39 _6777_/A vddd vssd sg13cmos5l_antennanp
X_3742_ _3742_/Y _3736_/Y _3742_/B vddd vssd sg13cmos5l_nand2b_1
XFILLER_31_2387 vddd vssd sg13cmos5l_decap_8
XFILLER_31_1642 vddd vssd sg13cmos5l_decap_8
X_6461_ _6467_/S _6461_/A _6475_/B vddd vssd sg13cmos5l_nand2_1
X_3673_ _3673_/Y _4972_/A _3673_/B vddd vssd sg13cmos5l_nand2_1
XFILLER_31_1686 vddd vssd sg13cmos5l_decap_4
X_6392_ _7144_/D _6754_/A _6393_/B hold722/X vddd vssd sg13cmos5l_a21oi_1
X_5412_ _5413_/D _5294_/C _5398_/B _5416_/C _5828_/B2 _5411_/Y vddd vssd sg13cmos5l_a221oi_1
X_5343_ _5343_/Y _3539_/A _5360_/C _7157_/Q vddd vssd sg13cmos5l_o21ai_1
XFILLER_29_2272 vddd vssd sg13cmos5l_decap_4
X_5274_ _5274_/Y _4911_/A _3641_/Y _3655_/B _4905_/Y vddd vssd sg13cmos5l_a22oi_1
X_7013_ _7013_/Q _7343_/CLK _7013_/D _6960_/Y vddd vssd sg13cmos5l_dfrbpq_1
X_4225_ _4225_/Y _3944_/Y _4223_/Y _4224_/Y vddd vssd sg13cmos5l_a21oi_1
XFILLER_9_1643 vddd vssd sg13cmos5l_decap_4
X_4156_ _4156_/Y _7046_/Q _6718_/A _6711_/A vddd vssd sg13cmos5l_o21ai_1
XFILLER_9_1687 vddd vssd sg13cmos5l_decap_4
XFILLER_23_1192 vddd vssd sg13cmos5l_decap_4
X_4087_ _4087_/Y _4179_/A1 sram_odata[2] _3758_/A wire4/X _4300_/B vddd vssd sg13cmos5l_a221oi_1
XFILLER_23_154 vddd vssd sg13cmos5l_decap_8
XFILLER_12_806 vddd vssd sg13cmos5l_decap_8
XFILLER_24_699 vddd vssd sg13cmos5l_decap_8
X_4989_ _5009_/A _5207_/A _5074_/C vddd vssd sg13cmos5l_and2_1
X_6728_ _7050_/D _6728_/A1 _6735_/S _6727_/Y vddd vssd sg13cmos5l_a21oi_1
XFILLER_20_894 vddd vssd sg13cmos5l_decap_8
XFILLER_14_2596 vddd vssd sg13cmos5l_decap_8
X_6659_ _6659_/Y _6732_/A _6663_/S vddd vssd sg13cmos5l_nand2_1
XFILLER_10_1704 vddd vssd sg13cmos5l_decap_8
XFILLER_11_21 vddd vssd sg13cmos5l_decap_8
XFILLER_8_1142 vddd vssd sg13cmos5l_decap_8
Xfanout340 _6915_/B_N _6917_/B_N vddd vssd sg13cmos5l_buf_1
Xfanout351 fanout351/X fanout353/X vddd vssd sg13cmos5l_buf_1
Xfanout384 fanout384/X fanout410/X vddd vssd sg13cmos5l_buf_1
Xfanout362 fanout362/X fanout364/X vddd vssd sg13cmos5l_buf_1
Xfanout373 fanout373/X fanout375/X vddd vssd sg13cmos5l_buf_1
Xfanout395 _6962_/B_N fanout396/X vddd vssd sg13cmos5l_buf_1
XFILLER_21_2556 vddd vssd sg13cmos5l_decap_8
XFILLER_4_1028 vddd vssd sg13cmos5l_decap_8
XFILLER_19_2485 vddd vssd sg13cmos5l_decap_8
XFILLER_15_666 vddd vssd sg13cmos5l_decap_8
XFILLER_14_154 vddd vssd sg13cmos5l_decap_8
XFILLER_15_1648 vddd vssd sg13cmos5l_decap_8
XFILLER_32_1951 vddd vssd sg13cmos5l_decap_8
XFILLER_11_883 vddd vssd sg13cmos5l_decap_8
XFILLER_26_2423 vddd vssd sg13cmos5l_decap_8
XFILLER_26_1700 vddd vssd sg13cmos5l_decap_8
X_4010_ _4010_/Y _4010_/A _4010_/B _4010_/C _6395_/A vddd vssd sg13cmos5l_nor4_1
XFILLER_20_2000 vddd vssd sg13cmos5l_decap_8
XFILLER_20_2066 vddd vssd sg13cmos5l_decap_8
XFILLER_20_1310 vddd vssd sg13cmos5l_decap_8
XFILLER_25_408 vddd vssd sg13cmos5l_decap_4
XFILLER_19_994 vddd vssd sg13cmos5l_decap_8
X_5961_ _5968_/C _7241_/Q _5972_/A vddd vssd sg13cmos5l_nor2b_1
XFILLER_0_1426 vddd vssd sg13cmos5l_decap_8
X_4912_ _4913_/C _4912_/A _4912_/B _4912_/C vddd vssd sg13cmos5l_nand3_1
X_5892_ _5892_/Y _6225_/A _7232_/Q _5889_/A vddd vssd sg13cmos5l_o21ai_1
XFILLER_21_636 vddd vssd sg13cmos5l_decap_8
X_4843_ _4843_/X _4841_/B _3647_/C _4842_/Y vddd vssd sg13cmos5l_a21o_1
X_4774_ _4774_/Y _4781_/A _4810_/B vddd vssd sg13cmos5l_nand2_1
X_3725_ _3725_/Y _7143_/Q _3724_/Y _3722_/Y vddd vssd sg13cmos5l_o21ai_1
X_6513_ _6513_/Y _6513_/A1 _6512_/B _6512_/Y vddd vssd sg13cmos5l_o21ai_1
XFILLER_14_1125 vddd vssd sg13cmos5l_decap_8
X_6444_ _6444_/X _6459_/A _6444_/A1 _6444_/S vddd vssd sg13cmos5l_mux2_1
X_3656_ _3656_/Y _4902_/B _4901_/B _3655_/Y _4853_/A _5985_/S vddd vssd sg13cmos5l_a221oi_1
X_3587_ _5830_/B _3587_/A vddd vssd sg13cmos5l_inv_1
X_6375_ _7136_/D _6754_/A _6388_/B hold668/X vddd vssd sg13cmos5l_o21ai_1
X_5326_ _5328_/B _5326_/A _5327_/A _5327_/B _5326_/D vddd vssd sg13cmos5l_nand4_1
XFILLER_0_518 vddd vssd sg13cmos5l_decap_8
X_5257_ _5260_/B _5257_/A _5257_/B vddd vssd sg13cmos5l_nor2_1
X_4208_ _4208_/X dbus_in_left[8] dbus_in_right[8] vddd vssd sg13cmos5l_or2_1
XFILLER_25_1287 vddd vssd sg13cmos5l_decap_8
XFILLER_9_1495 vddd vssd sg13cmos5l_decap_8
X_5188_ _6178_/A _7262_/Q _7263_/Q _5261_/B vddd vssd sg13cmos5l_nor3_1
X_4139_ _4139_/Y _5498_/B _6445_/A _6438_/A vddd vssd sg13cmos5l_a21oi_1
XFILLER_19_1036 vddd vssd sg13cmos5l_decap_8
XFILLER_16_2603 vddd vssd sg13cmos5l_decap_4
XFILLER_12_614 vddd vssd sg13cmos5l_decap_8
XFILLER_32_1247 vddd vssd sg13cmos5l_decap_8
XFILLER_32_1214 vddd vssd sg13cmos5l_decap_8
XFILLER_22_42 vddd vssd sg13cmos5l_decap_8
XFILLER_7_128 vddd vssd sg13cmos5l_decap_4
XFILLER_10_2257 vddd vssd sg13cmos5l_decap_4
XFILLER_10_2279 vddd vssd sg13cmos5l_decap_8
XFILLER_10_1545 vddd vssd sg13cmos5l_decap_8
XFILLER_10_1589 vddd vssd sg13cmos5l_decap_8
Xtiedowns\[21\] dbus_in_left[1] vddd vssd sg13cmos5l_antennanp
Xfanout192 _6558_/A _6692_/A vddd vssd sg13cmos5l_buf_1
Xfanout181 _6459_/A _6520_/A vddd vssd sg13cmos5l_buf_1
Xfanout170 _6344_/A hold1477/X vddd vssd sg13cmos5l_buf_1
XFILLER_1_2403 vddd vssd sg13cmos5l_decap_8
XFILLER_5_2561 vddd vssd sg13cmos5l_decap_8
XFILLER_5_1871 vddd vssd sg13cmos5l_decap_4
XFILLER_21_2386 vddd vssd sg13cmos5l_decap_8
XFILLER_19_2260 vddd vssd sg13cmos5l_decap_4
XFILLER_30_433 vddd vssd sg13cmos5l_decap_8
XFILLER_15_2157 vddd vssd sg13cmos5l_decap_8
XFILLER_32_2460 vddd vssd sg13cmos5l_decap_8
XFILLER_30_477 vddd vssd sg13cmos5l_decap_4
X_3510_ _3510_/Y _7097_/Q vddd vssd sg13cmos5l_inv_1
XFILLER_7_651 vddd vssd sg13cmos5l_decap_8
XFILLER_8_77 vddd vssd sg13cmos5l_decap_8
X_4490_ _4493_/B _4792_/A _4490_/B vddd vssd sg13cmos5l_nor2_1
Xhold607 _4400_/B _7350_/Q vddd vssd sg13cmos5l_dlygate4sd3_1
Xhold618 _7331_/D _4835_/Y vddd vssd sg13cmos5l_dlygate4sd3_1
Xhold629 hold629/X _4856_/Y vddd vssd sg13cmos5l_dlygate4sd3_1
X_6160_ _6160_/Y _6158_/Y _6159_/Y _6144_/X vddd vssd sg13cmos5l_o21ai_1
X_5111_ _5170_/B _7273_/Q _7272_/Q vddd vssd sg13cmos5l_nand2b_1
XFILLER_3_890 vddd vssd sg13cmos5l_decap_8
Xhold1307 _7213_/D _6521_/Y vddd vssd sg13cmos5l_dlygate4sd3_1
XFILLER_6_1602 vddd vssd sg13cmos5l_decap_8
XFILLER_6_2336 vddd vssd sg13cmos5l_decap_8
X_6091_ _6091_/Y _3822_/Y _5132_/D _5131_/C vddd vssd sg13cmos5l_a21oi_1
Xhold1329 _7049_/D _6725_/X vddd vssd sg13cmos5l_dlygate4sd3_1
Xhold1318 _6714_/A0 _7041_/Q vddd vssd sg13cmos5l_dlygate4sd3_1
XFILLER_22_2139 vddd vssd sg13cmos5l_decap_8
X_5042_ _5043_/C _5042_/A _5042_/B _5042_/C _5042_/D vddd vssd sg13cmos5l_nor4_1
XFILLER_19_0 vddd vssd sg13cmos5l_decap_8
Xclkbuf_leaf_35_SCK_regs _7229_/CLK clkload3/A vddd vssd sg13cmos5l_buf_8
XFILLER_26_728 vddd vssd sg13cmos5l_decap_8
X_6993_ _6993_/Q _7343_/CLK _6993_/D _6940_/Y vddd vssd sg13cmos5l_dfrbpq_1
XFILLER_19_791 vddd vssd sg13cmos5l_decap_8
X_5944_ _5944_/Y _5944_/A _5944_/B vddd vssd sg13cmos5l_xnor2_1
XFILLER_18_290 vddd vssd sg13cmos5l_decap_4
XFILLER_0_1289 vddd vssd sg13cmos5l_decap_4
X_5875_ _5876_/B _5875_/A _5875_/B _5875_/C vddd vssd sg13cmos5l_nand3_1
X_4826_ _4826_/Y _3504_/Y _3648_/A hold845/A vddd vssd sg13cmos5l_a21oi_1
Xtiedowns\[5\] sram_odata[5] vddd vssd sg13cmos5l_antennanp
XFILLER_18_1091 vddd vssd sg13cmos5l_decap_8
X_4757_ _4757_/Y _4757_/A _4757_/B vddd vssd sg13cmos5l_xnor2_1
X_3708_ _6597_/A _3878_/A _3876_/D vddd vssd sg13cmos5l_or2_1
X_4688_ _4694_/B _4713_/A _4698_/A vddd vssd sg13cmos5l_nand2b_1
XFILLER_11_2577 vddd vssd sg13cmos5l_decap_8
X_6427_ _6427_/X _6464_/A _6427_/A1 _6430_/S vddd vssd sg13cmos5l_mux2_1
X_3639_ _4901_/B _7087_/Q _7086_/Q vddd vssd sg13cmos5l_nor2b_1
X_6358_ _7125_/D _6661_/A _6361_/B hold642/X vddd vssd sg13cmos5l_o21ai_1
XFILLER_27_1316 vddd vssd sg13cmos5l_decap_8
X_5309_ _5310_/A _5416_/A _5306_/Y _5308_/Y io_in[0] _5307_/Y vddd vssd sg13cmos5l_a221oi_1
XFILLER_0_326 vddd vssd sg13cmos5l_decap_8
X_6289_ _6289_/X _7078_/Q _7080_/Q _6288_/Y vddd vssd sg13cmos5l_a21o_1
XFILLER_5_1145 vddd vssd sg13cmos5l_decap_8
XFILLER_17_42 vddd vssd sg13cmos5l_decap_8
XFILLER_25_750 vddd vssd sg13cmos5l_decap_4
XFILLER_31_219 vddd vssd sg13cmos5l_decap_8
XFILLER_12_411 vddd vssd sg13cmos5l_decap_8
XFILLER_9_905 vddd vssd sg13cmos5l_decap_8
XFILLER_9_927 vddd vssd sg13cmos5l_decap_8
XFILLER_32_1011 vddd vssd sg13cmos5l_decap_8
XFILLER_16_2477 vddd vssd sg13cmos5l_decap_8
XFILLER_32_1088 vddd vssd sg13cmos5l_decap_8
XFILLER_3_120 vddd vssd sg13cmos5l_decap_8
Xtiedowns\[69\] mask_rev_in[25] vddd vssd sg13cmos5l_antennanp
XFILLER_4_621 vddd vssd sg13cmos5l_decap_4
XFILLER_10_2065 vddd vssd sg13cmos5l_decap_8
XFILLER_27_2562 vddd vssd sg13cmos5l_decap_8
XFILLER_4_698 vddd vssd sg13cmos5l_decap_4
XFILLER_23_2426 vddd vssd sg13cmos5l_decap_8
XFILLER_27_1861 vddd vssd sg13cmos5l_decap_8
XFILLER_21_2150 vddd vssd sg13cmos5l_decap_8
XFILLER_12_7 vddd vssd sg13cmos5l_decap_8
Xclkbuf_4_4__f_clk_regs _7328_/CLK clkbuf_3_2_0_clk_regs/X vddd vssd sg13cmos5l_buf_8
XFILLER_1_2288 vddd vssd sg13cmos5l_decap_8
X_3990_ _3990_/Y _3988_/Y _3989_/Y _3863_/Y vddd vssd sg13cmos5l_o21ai_1
XFILLER_1_1554 vddd vssd sg13cmos5l_decap_8
XFILLER_31_720 vddd vssd sg13cmos5l_decap_8
X_5660_ _5660_/Y _5673_/C _5659_/Y _5673_/A vddd vssd sg13cmos5l_o21ai_1
XFILLER_17_1518 vddd vssd sg13cmos5l_decap_8
X_4611_ _4611_/Y _4600_/Y _4608_/Y _4746_/B1 vddd vssd sg13cmos5l_o21ai_1
X_5591_ _5591_/Y _7190_/Q _7191_/Q _5613_/A _7193_/Q vddd vssd sg13cmos5l_nor4_1
XFILLER_30_1729 vddd vssd sg13cmos5l_decap_4
X_4542_ _4542_/Y _4528_/Y _4539_/Y _4804_/B1 vddd vssd sg13cmos5l_o21ai_1
X_7330_ _7330_/Q _7398_/CLK _7330_/D _6844_/Y vddd vssd sg13cmos5l_dfrbpq_1
XFILLER_8_960 vddd vssd sg13cmos5l_decap_8
X_4473_ _4556_/A _5623_/A _4577_/A _4577_/B vddd vssd sg13cmos5l_nor3_1
X_7261_ _7261_/Q _7264_/CLK _7261_/D fanout381/X vddd vssd sg13cmos5l_dfrbpq_1
X_6212_ _6213_/B _6212_/A1 _6235_/C _7237_/Q vddd vssd sg13cmos5l_o21ai_1
X_7192_ _7192_/Q _7200_/CLK _7192_/D fanout363/X vddd vssd sg13cmos5l_dfrbpq_1
XFILLER_28_1625 vddd vssd sg13cmos5l_decap_4
X_6143_ _6143_/Y _7343_/Q _6121_/B _6142_/Y vddd vssd sg13cmos5l_o21ai_1
Xoutbuffers\[52\] bandgap_trim[13] _6296_/Y vddd vssd sg13cmos5l_buf_16
Xhold1115 _6544_/A1 _3920_/A vddd vssd sg13cmos5l_dlygate4sd3_1
XFILLER_2_2008 vddd vssd sg13cmos5l_decap_8
X_6074_ _6075_/B _6136_/A _6074_/B vddd vssd sg13cmos5l_nor2_1
Xhold1104 _3575_/A _7207_/Q vddd vssd sg13cmos5l_dlygate4sd3_1
Xhold1148 _6479_/A1 _5601_/B vddd vssd sg13cmos5l_dlygate4sd3_1
Xhold1137 _7272_/D _6625_/X vddd vssd sg13cmos5l_dlygate4sd3_1
XFILLER_22_1224 vddd vssd sg13cmos5l_decap_8
Xhold1126 _6565_/A1 _6219_/B vddd vssd sg13cmos5l_dlygate4sd3_1
X_5025_ _5043_/A _7291_/Q _5233_/A _5025_/C _5025_/D vddd vssd sg13cmos5l_nor4_1
XFILLER_6_2188 vddd vssd sg13cmos5l_decap_8
XFILLER_22_1257 vddd vssd sg13cmos5l_decap_8
Xhold1159 _6460_/A1 _5518_/B vddd vssd sg13cmos5l_dlygate4sd3_1
X_6976_ _6976_/Q _6981_/CLK _6976_/D _6923_/Y vddd vssd sg13cmos5l_dfrbpq_1
X_5927_ _5930_/B _5927_/A _5927_/B vddd vssd sg13cmos5l_and2_1
XFILLER_16_1039 vddd vssd sg13cmos5l_decap_8
X_5858_ _5873_/C _7226_/Q _5861_/B vddd vssd sg13cmos5l_nor2_1
X_5789_ _5789_/X _5789_/A _5789_/B vddd vssd sg13cmos5l_and2_1
X_4809_ _4809_/Y _4808_/A _4796_/Y _4808_/Y vddd vssd sg13cmos5l_a21oi_1
XFILLER_11_1684 vddd vssd sg13cmos5l_decap_8
XFILLER_27_1113 vddd vssd sg13cmos5l_decap_8
Xhold960 _6476_/A _7190_/Q vddd vssd sg13cmos5l_dlygate4sd3_1
Xhold982 _6971_/D _5925_/Y vddd vssd sg13cmos5l_dlygate4sd3_1
Xhold971 _7261_/D _6608_/X vddd vssd sg13cmos5l_dlygate4sd3_1
XFILLER_0_134 vddd vssd sg13cmos5l_decap_8
Xhold993 _3577_/A _7211_/Q vddd vssd sg13cmos5l_dlygate4sd3_1
XFILLER_28_30 vddd vssd sg13cmos5l_decap_8
XFILLER_22_2492 vddd vssd sg13cmos5l_decap_8
XFILLER_29_374 vddd vssd sg13cmos5l_decap_8
XFILLER_28_85 vddd vssd sg13cmos5l_decap_8
XFILLER_2_2597 vddd vssd sg13cmos5l_decap_8
XFILLER_2_1874 vddd vssd sg13cmos5l_decap_8
XFILLER_18_2528 vddd vssd sg13cmos5l_decap_8
XFILLER_8_267 vddd vssd sg13cmos5l_decap_8
XFILLER_4_484 vddd vssd sg13cmos5l_decap_8
XFILLER_5_56 vddd vssd sg13cmos5l_decap_8
XFILLER_10_1183 vddd vssd sg13cmos5l_decap_8
XFILLER_23_1533 vddd vssd sg13cmos5l_decap_8
XFILLER_7_1785 vddd vssd sg13cmos5l_decap_8
X_6830_ _6830_/Y _6835_/A _6835_/B_N vddd vssd sg13cmos5l_nor2b_1
X_6761_ _6761_/X _6777_/A _6761_/A1 _6761_/S vddd vssd sg13cmos5l_mux2_1
XFILLER_23_528 vddd vssd sg13cmos5l_decap_8
XFILLER_17_2027 vddd vssd sg13cmos5l_decap_8
X_3973_ _3973_/Y _3538_/Y _4238_/B _3972_/Y _3970_/Y _3821_/Y vddd vssd sg13cmos5l_a221oi_1
X_5712_ _5712_/Y _7206_/Q _7207_/Q vddd vssd sg13cmos5l_nand2_1
X_6692_ _6692_/Y _6692_/A _6695_/S vddd vssd sg13cmos5l_nor2_1
X_5643_ _5643_/Y _5841_/A _5641_/A _5642_/Y vddd vssd sg13cmos5l_a21oi_1
X_5574_ _5574_/Y _3564_/Y _5570_/Y _5573_/Y vddd vssd sg13cmos5l_o21ai_1
X_4525_ _4525_/Y _4452_/X _4524_/Y _4736_/B1 vddd vssd sg13cmos5l_a21oi_1
X_7313_ _7313_/Q _7400_/CLK _7313_/D _6835_/Y vddd vssd sg13cmos5l_dfrbpq_1
XFILLER_12_1960 vddd vssd sg13cmos5l_decap_8
X_4456_ _4456_/Y _4461_/A _4461_/B _4456_/C vddd vssd sg13cmos5l_nor3_1
X_7244_ _7244_/Q _7291_/CLK _7244_/D fanout376/X vddd vssd sg13cmos5l_dfrbpq_1
X_7175_ _7175_/Q _7210_/CLK _7175_/D fanout361/X vddd vssd sg13cmos5l_dfrbpq_1
X_4387_ _4392_/C _4781_/A _7122_/Q vddd vssd sg13cmos5l_xor2_1
X_6126_ _6126_/Y _6263_/A1 _5162_/A _5162_/B vddd vssd sg13cmos5l_a21oi_1
XFILLER_22_1043 vddd vssd sg13cmos5l_decap_8
Xclkbuf_3_0_0_clk_regs clkbuf_3_0_0_clk_regs/X clkbuf_0_clk_regs/X vddd vssd sg13cmos5l_buf_8
X_6057_ _6057_/Y _6057_/A _6057_/B vddd vssd sg13cmos5l_nor2_1
X_5008_ _5013_/A _5008_/A _5008_/B _5008_/C _5008_/D vddd vssd sg13cmos5l_nor4_1
XFILLER_2_1159 vddd vssd sg13cmos5l_decap_4
XFILLER_27_889 vddd vssd sg13cmos5l_decap_8
X_6959_ _6959_/Y _6959_/A _6960_/B_N vddd vssd sg13cmos5l_nor2b_1
XFILLER_22_550 vddd vssd sg13cmos5l_decap_4
XFILLER_17_2583 vddd vssd sg13cmos5l_decap_8
XFILLER_14_21 vddd vssd sg13cmos5l_decap_8
XFILLER_13_2436 vddd vssd sg13cmos5l_decap_8
XFILLER_13_1746 vddd vssd sg13cmos5l_decap_8
XFILLER_10_778 vddd vssd sg13cmos5l_decap_8
XFILLER_13_1779 vddd vssd sg13cmos5l_decap_8
XFILLER_30_86 vddd vssd sg13cmos5l_decap_8
XFILLER_1_410 vddd vssd sg13cmos5l_decap_4
Xhold790 _6313_/A _7104_/Q vddd vssd sg13cmos5l_dlygate4sd3_1
XFILLER_2_988 vddd vssd sg13cmos5l_decap_8
XFILLER_24_2565 vddd vssd sg13cmos5l_decap_8
XFILLER_29_182 vddd vssd sg13cmos5l_decap_8
Xhold1490 hold497/A _6984_/Q vddd vssd sg13cmos5l_dlygate4sd3_1
XFILLER_32_303 vddd vssd sg13cmos5l_decap_8
XFILLER_2_1671 vddd vssd sg13cmos5l_decap_8
XFILLER_18_1646 vddd vssd sg13cmos5l_decap_8
XFILLER_13_550 vddd vssd sg13cmos5l_decap_8
XFILLER_9_532 vddd vssd sg13cmos5l_decap_8
XFILLER_31_2569 vddd vssd sg13cmos5l_decap_8
XFILLER_12_1245 vddd vssd sg13cmos5l_decap_8
XFILLER_29_2443 vddd vssd sg13cmos5l_decap_8
X_5290_ _5290_/Y _7147_/Q _5308_/D _5304_/A vddd vssd sg13cmos5l_o21ai_1
X_4310_ _4310_/Y _4963_/A _4963_/B _4310_/C _4964_/B vddd vssd sg13cmos5l_nand4_1
XFILLER_29_1753 vddd vssd sg13cmos5l_decap_8
X_4241_ _4241_/Y _3611_/Y _4241_/A2 _6746_/A vddd vssd sg13cmos5l_a21oi_1
XFILLER_9_2548 vddd vssd sg13cmos5l_decap_8
X_4172_ _4172_/Y _7089_/Q _4172_/A2 _4172_/B1 vddd vssd sg13cmos5l_a21oi_1
XFILLER_7_1582 vddd vssd sg13cmos5l_decap_8
XFILLER_23_2097 vddd vssd sg13cmos5l_decap_8
Xoutbuffers\[15\] proj_sel[2] _7026_/Q vddd vssd sg13cmos5l_buf_16
X_6813_ _6813_/X _6813_/A vddd vssd sg13cmos5l_buf_1
X_6744_ _6744_/Y _6744_/A1 _6745_/S _6743_/Y vddd vssd sg13cmos5l_o21ai_1
XFILLER_17_1123 vddd vssd sg13cmos5l_decap_8
X_3956_ _3956_/Y _6438_/A vddd vssd sg13cmos5l_inv_1
XFILLER_32_892 vddd vssd sg13cmos5l_decap_8
X_6675_ _6675_/X _6675_/A0 sram_odata[0] _6683_/S vddd vssd sg13cmos5l_mux2_1
X_5626_ _5638_/A _5633_/B _5629_/A vddd vssd sg13cmos5l_nor2b_1
X_3887_ _4019_/B _6597_/A _6597_/B vddd vssd sg13cmos5l_nor2_1
X_5557_ _5557_/Y _5557_/A _5557_/B _5557_/C vddd vssd sg13cmos5l_nor3_1
X_4508_ _4508_/Y _4503_/A _4508_/B _4508_/C vddd vssd sg13cmos5l_nand3b_1
X_5488_ _5488_/Y _5488_/A _5488_/B _5488_/C _5488_/D vddd vssd sg13cmos5l_nor4_1
X_4439_ _4439_/X _3495_/A _4438_/D _4438_/Y vddd vssd sg13cmos5l_a21o_1
Xwire2 wire2/X wire2/A vddd vssd sg13cmos5l_buf_4
X_7227_ _7227_/Q _7229_/CLK _7227_/D fanout368/X vddd vssd sg13cmos5l_dfrbpq_1
XFILLER_8_1302 vddd vssd sg13cmos5l_decap_8
XFILLER_8_2047 vddd vssd sg13cmos5l_decap_8
X_7158_ _7158_/Q _7190_/CLK _7158_/D fanout360/X vddd vssd sg13cmos5l_dfrbpq_1
X_6109_ _6109_/Y _5150_/B _6107_/Y _6108_/Y vddd vssd sg13cmos5l_o21ai_1
X_7089_ _7089_/Q _7123_/CLK _7089_/D _6865_/B_N vddd vssd sg13cmos5l_dfrbpq_1
XFILLER_18_119 vddd vssd sg13cmos5l_decap_8
XFILLER_27_642 vddd vssd sg13cmos5l_decap_4
XFILLER_26_174 vddd vssd sg13cmos5l_decap_8
XFILLER_25_86 vddd vssd sg13cmos5l_decap_8
XFILLER_13_2222 vddd vssd sg13cmos5l_decap_4
XFILLER_10_520 vddd vssd sg13cmos5l_decap_8
XFILLER_13_1543 vddd vssd sg13cmos5l_decap_8
XFILLER_13_1521 vddd vssd sg13cmos5l_decap_8
XFILLER_6_557 vddd vssd sg13cmos5l_decap_8
XFILLER_29_1049 vddd vssd sg13cmos5l_decap_8
Xtiedowns\[51\] mask_rev_in[7] vddd vssd sg13cmos5l_antennanp
XFILLER_2_730 vddd vssd sg13cmos5l_decap_8
XFILLER_26_1926 vddd vssd sg13cmos5l_decap_8
XFILLER_24_2340 vddd vssd sg13cmos5l_decap_8
Xclkbuf_1_1__f_SCK sram_clk_mux/A0 clkbuf_0_SCK/X vddd vssd sg13cmos5l_buf_8
XFILLER_2_35 vddd vssd sg13cmos5l_decap_8
XFILLER_8_2592 vddd vssd sg13cmos5l_decap_8
XFILLER_4_2434 vddd vssd sg13cmos5l_decap_8
XFILLER_18_2111 vddd vssd sg13cmos5l_decap_8
XFILLER_32_133 vddd vssd sg13cmos5l_decap_8
X_4790_ _4792_/C _4790_/A _4790_/B vddd vssd sg13cmos5l_nand2_1
X_3810_ _3810_/Y _3810_/A _3810_/B _3810_/C _3810_/D vddd vssd sg13cmos5l_nand4_1
Xoutbuffers\[105\] dbus_out[8] _5533_/Y vddd vssd sg13cmos5l_buf_16
XANTENNA_18 _3984_/A vddd vssd sg13cmos5l_antennanp
XFILLER_18_1443 vddd vssd sg13cmos5l_decap_8
XFILLER_14_2019 vddd vssd sg13cmos5l_decap_8
XANTENNA_29 _3740_/B vddd vssd sg13cmos5l_antennanp
X_3741_ _3742_/B _7095_/Q _4172_/A2 _4172_/B1 vddd vssd sg13cmos5l_a21oi_1
XFILLER_14_892 vddd vssd sg13cmos5l_decap_8
X_3672_ _3753_/C _4355_/A _4357_/A _3672_/S vddd vssd sg13cmos5l_mux2_1
X_6460_ _6460_/Y _6460_/A1 _6459_/B _6459_/Y vddd vssd sg13cmos5l_a21oi_1
XFILLER_9_384 vddd vssd sg13cmos5l_decap_8
X_6391_ _6391_/Y _6391_/A _6393_/B vddd vssd sg13cmos5l_nor2_1
X_5411_ _5411_/Y _5484_/A _5408_/B vddd vssd sg13cmos5l_nor2b_1
XFILLER_31_1698 vddd vssd sg13cmos5l_decap_8
X_5342_ _5342_/Y _5566_/A _7154_/Q _5348_/B vddd vssd sg13cmos5l_nor3_1
X_7012_ _7012_/Q _7343_/CLK _7012_/D _6959_/Y vddd vssd sg13cmos5l_dfrbpq_1
X_5273_ _7401_/D _5273_/A vddd vssd sg13cmos5l_inv_1
XFILLER_9_2356 vddd vssd sg13cmos5l_decap_8
X_4224_ _4224_/Y _5581_/A _3944_/Y _3947_/Y vddd vssd sg13cmos5l_o21ai_1
XFILLER_9_1666 vddd vssd sg13cmos5l_decap_8
X_4155_ _4155_/Y _7051_/Q _4244_/A2 _4153_/Y _4154_/Y _3831_/X vddd vssd sg13cmos5l_a221oi_1
XFILLER_23_1171 vddd vssd sg13cmos5l_decap_8
XFILLER_3_1254 vddd vssd sg13cmos5l_decap_8
X_4086_ wire4/A _4084_/Y _4085_/Y wire76/X vddd vssd sg13cmos5l_o21ai_1
XFILLER_24_678 vddd vssd sg13cmos5l_decap_8
XFILLER_23_133 vddd vssd sg13cmos5l_decap_8
X_4988_ _5074_/C _7260_/Q _7261_/Q vddd vssd sg13cmos5l_nor2_1
XFILLER_32_1429 vddd vssd sg13cmos5l_decap_8
X_6727_ _6727_/Y _6727_/A _6735_/S vddd vssd sg13cmos5l_nor2_1
X_3939_ _3939_/X _5666_/B _6490_/A _6483_/A vddd vssd sg13cmos5l_a21o_1
X_6658_ _6658_/X _6658_/A0 _6581_/A _6663_/S vddd vssd sg13cmos5l_mux2_1
XFILLER_14_2575 vddd vssd sg13cmos5l_decap_8
XFILLER_14_1852 vddd vssd sg13cmos5l_decap_4
X_5609_ _5609_/Y _5609_/A _5609_/B _5609_/C vddd vssd sg13cmos5l_nor3_1
X_6589_ _6589_/X _6589_/A0 _6581_/A _6589_/S vddd vssd sg13cmos5l_mux2_1
XFILLER_10_1749 vddd vssd sg13cmos5l_decap_8
XFILLER_11_77 vddd vssd sg13cmos5l_decap_4
Xfanout341 _6917_/B_N fanout347/X vddd vssd sg13cmos5l_buf_1
Xfanout330 _6748_/A1 _6764_/A1 vddd vssd sg13cmos5l_buf_1
Xfanout374 fanout374/X fanout375/X vddd vssd sg13cmos5l_buf_1
Xfanout352 fanout352/X fanout353/X vddd vssd sg13cmos5l_buf_1
Xfanout363 fanout363/X fanout364/X vddd vssd sg13cmos5l_buf_1
Xfanout396 fanout396/X fanout409/X vddd vssd sg13cmos5l_buf_1
Xfanout385 fanout385/X fanout410/X vddd vssd sg13cmos5l_buf_1
XFILLER_21_2535 vddd vssd sg13cmos5l_decap_8
XFILLER_28_951 vddd vssd sg13cmos5l_decap_4
XFILLER_21_1834 vddd vssd sg13cmos5l_decap_4
XFILLER_19_2464 vddd vssd sg13cmos5l_decap_8
XFILLER_19_1763 vddd vssd sg13cmos5l_decap_8
XFILLER_15_1616 vddd vssd sg13cmos5l_decap_8
XFILLER_32_1930 vddd vssd sg13cmos5l_decap_8
XFILLER_7_833 vddd vssd sg13cmos5l_decap_8
XFILLER_26_2402 vddd vssd sg13cmos5l_decap_8
XFILLER_26_2479 vddd vssd sg13cmos5l_decap_8
XFILLER_6_1806 vddd vssd sg13cmos5l_decap_8
XFILLER_6_2529 vddd vssd sg13cmos5l_decap_8
XFILLER_24_2181 vddd vssd sg13cmos5l_decap_8
XFILLER_22_1609 vddd vssd sg13cmos5l_decap_8
XFILLER_4_2242 vddd vssd sg13cmos5l_decap_8
XFILLER_0_2128 vddd vssd sg13cmos5l_decap_8
X_5960_ _5966_/A _5958_/Y _5959_/Y _5972_/C vddd vssd sg13cmos5l_o21ai_1
XFILLER_0_1405 vddd vssd sg13cmos5l_decap_8
XFILLER_4_1596 vddd vssd sg13cmos5l_decap_8
X_4911_ _4911_/Y _4911_/A _4912_/B vddd vssd sg13cmos5l_nand2_1
X_5891_ _5891_/Y _6224_/A _5901_/D vddd vssd sg13cmos5l_nor2_1
X_4842_ _4842_/Y _4841_/B _3647_/C _4853_/A vddd vssd sg13cmos5l_o21ai_1
XFILLER_18_1273 vddd vssd sg13cmos5l_decap_8
X_4773_ _4773_/Y _4547_/A _4772_/Y _4753_/Y vddd vssd sg13cmos5l_o21ai_1
X_3724_ _3724_/Y _3908_/A _3734_/A vddd vssd sg13cmos5l_nand2_1
X_6512_ _6512_/Y _6552_/A _6512_/B vddd vssd sg13cmos5l_nand2_1
X_6443_ _7172_/D _6472_/A _6443_/A1 _6444_/S vddd vssd sg13cmos5l_mux2_1
X_3655_ _3655_/Y _3655_/A _3655_/B vddd vssd sg13cmos5l_nand2_1
XFILLER_14_1159 vddd vssd sg13cmos5l_decap_8
Xoutbuffers\[82\] io_oe[9] _5237_/Y vddd vssd sg13cmos5l_buf_16
XFILLER_31_1484 vddd vssd sg13cmos5l_decap_8
X_3586_ _3920_/A _3586_/A vddd vssd sg13cmos5l_inv_1
X_6374_ _6374_/Y _6374_/A _6388_/B vddd vssd sg13cmos5l_nand2_1
X_5325_ _5328_/A _5327_/A _5313_/Y _5324_/Y vddd vssd sg13cmos5l_o21ai_1
X_5256_ _6261_/B _5256_/A _5256_/B vddd vssd sg13cmos5l_nor2_1
X_4207_ _4207_/Y dbus_in_left[8] dbus_in_right[8] vddd vssd sg13cmos5l_nor2_1
XFILLER_25_1222 vddd vssd sg13cmos5l_decap_4
XFILLER_28_214 vddd vssd sg13cmos5l_decap_8
X_5187_ _5261_/B _7264_/Q _7265_/Q vddd vssd sg13cmos5l_nand2b_1
X_4138_ _4138_/X _7179_/Q _6453_/A _6445_/A vddd vssd sg13cmos5l_a21o_1
XFILLER_28_258 vddd vssd sg13cmos5l_decap_8
X_4069_ _4069_/Y _7138_/Q _4183_/B1 _6363_/A vddd vssd sg13cmos5l_o21ai_1
XFILLER_19_1015 vddd vssd sg13cmos5l_decap_8
Xwire95 wire95/X wire95/A vddd vssd sg13cmos5l_buf_4
XFILLER_24_497 vddd vssd sg13cmos5l_decap_8
XFILLER_22_21 vddd vssd sg13cmos5l_decap_8
XFILLER_16_1958 vddd vssd sg13cmos5l_decap_8
XFILLER_7_107 vddd vssd sg13cmos5l_decap_8
Xclkbuf_leaf_5_SCK_regs _7189_/CLK clkload5/A vddd vssd sg13cmos5l_buf_8
Xfanout182 _6552_/A _6520_/A vddd vssd sg13cmos5l_buf_1
Xfanout160 _5985_/S _4492_/A vddd vssd sg13cmos5l_buf_1
XFILLER_5_2540 vddd vssd sg13cmos5l_decap_8
XFILLER_19_236 vddd vssd sg13cmos5l_decap_8
Xfanout193 _6692_/A fanout198/X vddd vssd sg13cmos5l_buf_1
Xclkbuf_4_3__f_clk_regs _7342_/CLK clkbuf_3_1_0_clk_regs/X vddd vssd sg13cmos5l_buf_8
XFILLER_21_1664 vddd vssd sg13cmos5l_decap_8
Xtiedowns\[14\] io_in[6] vddd vssd sg13cmos5l_antennanp
XFILLER_15_2147 vddd vssd sg13cmos5l_decap_4
XFILLER_8_56 vddd vssd sg13cmos5l_decap_8
XFILLER_15_1479 vddd vssd sg13cmos5l_decap_8
XFILLER_32_1782 vddd vssd sg13cmos5l_decap_8
Xhold608 _4419_/C _4418_/Y vddd vssd sg13cmos5l_dlygate4sd3_1
XFILLER_13_1170 vddd vssd sg13cmos5l_decap_4
Xhold619 _4309_/C _7376_/Q vddd vssd sg13cmos5l_dlygate4sd3_1
X_5110_ _6082_/B _7282_/Q _7283_/Q _5171_/B vddd vssd sg13cmos5l_nor3_1
X_6090_ _6090_/Y _6154_/A _5133_/C _6089_/Y vddd vssd sg13cmos5l_o21ai_1
X_5041_ _5042_/D _7264_/Q _7265_/Q _5228_/A vddd vssd sg13cmos5l_nor3_1
Xhold1319 _7041_/D _6714_/X vddd vssd sg13cmos5l_dlygate4sd3_1
Xhold1308 _3515_/A _7247_/Q vddd vssd sg13cmos5l_dlygate4sd3_1
XFILLER_6_1625 vddd vssd sg13cmos5l_decap_8
XFILLER_26_1597 vddd vssd sg13cmos5l_decap_8
X_6992_ _6992_/Q _7343_/CLK _6992_/D _6939_/Y vddd vssd sg13cmos5l_dfrbpq_1
X_5943_ _5943_/Y _5945_/A _5943_/B vddd vssd sg13cmos5l_nor2_1
X_5874_ _5874_/Y _5875_/B _5875_/C _5871_/Y _5872_/Y _5873_/X vddd vssd sg13cmos5l_a221oi_1
X_4825_ _4825_/X hold626/X _4491_/Y _4824_/Y vddd vssd sg13cmos5l_a21o_1
XFILLER_21_467 vddd vssd sg13cmos5l_decap_8
XFILLER_30_990 vddd vssd sg13cmos5l_decap_8
X_4756_ _4757_/B _4778_/A _4756_/B vddd vssd sg13cmos5l_nor2_1
X_3707_ _3707_/Y _3878_/A _3876_/D vddd vssd sg13cmos5l_nor2_1
X_4687_ _4687_/Y _4698_/A _4732_/B vddd vssd sg13cmos5l_nand2_1
XFILLER_11_2556 vddd vssd sg13cmos5l_decap_8
X_6426_ _7162_/D _6748_/A1 _6430_/S hold930/X vddd vssd sg13cmos5l_o21ai_1
X_3638_ _3638_/Y _4315_/A _3638_/B vddd vssd sg13cmos5l_nand2b_1
X_3569_ _5661_/B _3569_/A vddd vssd sg13cmos5l_inv_1
X_6357_ _6357_/Y _6357_/A _6361_/B vddd vssd sg13cmos5l_nand2_1
X_5308_ _5308_/Y _7146_/Q _7147_/Q _7148_/Q _5308_/D vddd vssd sg13cmos5l_nor4_1
XFILLER_0_305 vddd vssd sg13cmos5l_decap_8
X_6288_ _6288_/Y _6285_/B _6291_/A _6287_/A vddd vssd sg13cmos5l_a21oi_1
X_5239_ _5253_/B _5239_/A _5257_/B vddd vssd sg13cmos5l_nor2_1
XFILLER_5_1113 vddd vssd sg13cmos5l_decap_4
XFILLER_17_21 vddd vssd sg13cmos5l_decap_8
XFILLER_17_98 vddd vssd sg13cmos5l_decap_8
XFILLER_13_924 vddd vssd sg13cmos5l_decap_8
XFILLER_16_2456 vddd vssd sg13cmos5l_decap_8
XFILLER_16_1733 vddd vssd sg13cmos5l_decap_8
XFILLER_8_405 vddd vssd sg13cmos5l_decap_8
XFILLER_32_1067 vddd vssd sg13cmos5l_decap_8
XFILLER_10_2044 vddd vssd sg13cmos5l_decap_8
XFILLER_27_2541 vddd vssd sg13cmos5l_decap_8
XFILLER_27_1840 vddd vssd sg13cmos5l_decap_8
XFILLER_0_861 vddd vssd sg13cmos5l_decap_8
XFILLER_7_1945 vddd vssd sg13cmos5l_decap_8
XFILLER_23_1726 vddd vssd sg13cmos5l_decap_8
XFILLER_5_1680 vddd vssd sg13cmos5l_decap_8
XFILLER_16_795 vddd vssd sg13cmos5l_decap_8
X_4610_ _4610_/Y _4656_/A _4610_/B vddd vssd sg13cmos5l_nor2_1
XFILLER_30_297 vddd vssd sg13cmos5l_decap_8
X_5590_ _5590_/Y _5590_/A1 _5589_/B _5589_/Y vddd vssd sg13cmos5l_a21oi_1
X_4541_ _4541_/Y _4803_/A _4541_/B vddd vssd sg13cmos5l_nor2_1
XFILLER_32_1590 vddd vssd sg13cmos5l_decap_8
X_4472_ _4578_/A _4577_/A _4577_/B vddd vssd sg13cmos5l_nor2_1
X_7260_ _7260_/Q _7264_/CLK _7260_/D fanout381/X vddd vssd sg13cmos5l_dfrbpq_1
X_7191_ _7191_/Q _7200_/CLK _7191_/D fanout363/X vddd vssd sg13cmos5l_dfrbpq_1
X_6211_ _6213_/A _6211_/A _7234_/Q _7235_/Q vddd vssd sg13cmos5l_nor3_1
X_6142_ _6142_/Y _6057_/A _6121_/B _6278_/A1 vddd vssd sg13cmos5l_a21oi_1
XFILLER_31_0 vddd vssd sg13cmos5l_decap_8
X_6073_ _6073_/Y _6074_/B _6073_/B _6073_/C vddd vssd sg13cmos5l_nand3_1
XFILLER_6_2167 vddd vssd sg13cmos5l_decap_8
Xhold1105 _6510_/A1 _5716_/B vddd vssd sg13cmos5l_dlygate4sd3_1
Xoutbuffers\[45\] bandgap_trim[6] _6290_/Y vddd vssd sg13cmos5l_buf_16
X_5024_ _5025_/D _5024_/A _5024_/B _5024_/C _6014_/B vddd vssd sg13cmos5l_or4_1
Xhold1149 _7191_/D _6479_/Y vddd vssd sg13cmos5l_dlygate4sd3_1
Xhold1138 _3556_/A _7171_/Q vddd vssd sg13cmos5l_dlygate4sd3_1
Xhold1116 _7225_/D _6544_/Y vddd vssd sg13cmos5l_dlygate4sd3_1
Xhold1127 _7235_/D _6565_/Y vddd vssd sg13cmos5l_dlygate4sd3_1
XFILLER_6_1455 vddd vssd sg13cmos5l_decap_8
XFILLER_26_559 vddd vssd sg13cmos5l_decap_8
X_6975_ _6975_/Q _6981_/CLK _6975_/D _6922_/Y vddd vssd sg13cmos5l_dfrbpq_1
XFILLER_0_1054 vddd vssd sg13cmos5l_decap_8
X_5926_ _5945_/A _5926_/A _5926_/B _5926_/C vddd vssd sg13cmos5l_nand3_1
X_5857_ _5857_/Y _5855_/Y _5857_/B vddd vssd sg13cmos5l_nand2b_1
X_5788_ _5788_/Y _5841_/A _5786_/B _5786_/Y _5780_/Y _5789_/B vddd vssd sg13cmos5l_a221oi_1
X_4808_ _4808_/Y _4808_/A _4808_/B _4808_/C vddd vssd sg13cmos5l_nor3_1
X_4739_ _4740_/B _4743_/A _4739_/B vddd vssd sg13cmos5l_nor2_1
XFILLER_11_1652 vddd vssd sg13cmos5l_decap_8
X_6409_ _6409_/Y _6409_/A1 _6408_/B _6408_/Y vddd vssd sg13cmos5l_a21oi_1
Xhold961 hold961/X _6476_/Y vddd vssd sg13cmos5l_dlygate4sd3_1
Xhold972 _6628_/A _7274_/Q vddd vssd sg13cmos5l_dlygate4sd3_1
X_7389_ _7389_/Q _7389_/CLK _7389_/D _6822_/Y vddd vssd sg13cmos5l_dfrbpq_1
Xhold950 hold950/X _4946_/A vddd vssd sg13cmos5l_dlygate4sd3_1
Xhold983 _3615_/A _7074_/Q vddd vssd sg13cmos5l_dlygate4sd3_1
Xclkbuf_3_5_0_SCK_regs clkload7/A clkbuf_0_SCK_regs/X vddd vssd sg13cmos5l_buf_8
XFILLER_0_113 vddd vssd sg13cmos5l_decap_8
Xhold994 hold994/X _5748_/B vddd vssd sg13cmos5l_dlygate4sd3_1
XFILLER_22_2471 vddd vssd sg13cmos5l_decap_8
XFILLER_2_1820 vddd vssd sg13cmos5l_decap_4
XFILLER_18_2507 vddd vssd sg13cmos5l_decap_8
XFILLER_2_1853 vddd vssd sg13cmos5l_decap_8
XFILLER_12_220 vddd vssd sg13cmos5l_decap_8
XFILLER_13_754 vddd vssd sg13cmos5l_decap_4
XFILLER_16_1552 vddd vssd sg13cmos5l_decap_8
XFILLER_9_747 vddd vssd sg13cmos5l_decap_4
XFILLER_12_275 vddd vssd sg13cmos5l_decap_8
XFILLER_16_1585 vddd vssd sg13cmos5l_decap_8
XFILLER_12_1449 vddd vssd sg13cmos5l_decap_8
XFILLER_5_35 vddd vssd sg13cmos5l_decap_8
XFILLER_10_1151 vddd vssd sg13cmos5l_decap_8
XFILLER_4_463 vddd vssd sg13cmos5l_decap_8
XFILLER_10_1195 vddd vssd sg13cmos5l_decap_8
XFILLER_29_1968 vddd vssd sg13cmos5l_decap_4
XFILLER_23_2202 vddd vssd sg13cmos5l_decap_8
XFILLER_0_691 vddd vssd sg13cmos5l_decap_8
XFILLER_7_2487 vddd vssd sg13cmos5l_decap_8
XFILLER_1_1352 vddd vssd sg13cmos5l_decap_8
X_6760_ _7071_/D _6760_/A1 _6761_/S _6759_/Y vddd vssd sg13cmos5l_a21oi_1
XFILLER_23_507 vddd vssd sg13cmos5l_decap_8
X_5711_ _5711_/Y io_in[0] _5727_/B _5733_/B vddd vssd sg13cmos5l_nand3_1
XFILLER_17_1305 vddd vssd sg13cmos5l_decap_8
X_3972_ _3972_/Y _7153_/Q _6402_/A _4238_/B vddd vssd sg13cmos5l_a21oi_1
X_6691_ _6691_/Y _6691_/A1 _6695_/S _6690_/Y vddd vssd sg13cmos5l_a21oi_1
X_5642_ _5642_/Y _7194_/Q _7195_/Q _5642_/C vddd vssd sg13cmos5l_nor3_1
X_5573_ _5573_/Y _5807_/A1 _3565_/Y _5571_/Y _3564_/Y _5572_/Y vddd vssd sg13cmos5l_a221oi_1
X_4524_ _4524_/Y _4524_/A _4524_/B vddd vssd sg13cmos5l_nand2_1
X_7312_ _7312_/Q _7401_/CLK _7312_/D _6834_/Y vddd vssd sg13cmos5l_dfrbpq_1
X_4455_ _4456_/C _4508_/C _4453_/Y _4454_/Y vddd vssd sg13cmos5l_a21oi_1
X_7243_ _7243_/Q _7291_/CLK _7243_/D fanout376/X vddd vssd sg13cmos5l_dfrbpq_1
X_4386_ _4390_/D _6009_/A _7120_/Q vddd vssd sg13cmos5l_xnor2_1
X_7174_ _7174_/Q _7214_/CLK _7174_/D fanout359/X vddd vssd sg13cmos5l_dfrbpq_1
X_6125_ _6125_/Y _6123_/Y _6125_/B vddd vssd sg13cmos5l_nand2b_1
XFILLER_8_1539 vddd vssd sg13cmos5l_decap_8
XFILLER_22_1022 vddd vssd sg13cmos5l_decap_8
X_6056_ _6056_/Y _6167_/B1 _6055_/Y _6053_/Y vddd vssd sg13cmos5l_o21ai_1
X_5007_ _5009_/C _5212_/A _5212_/B _7288_/Q _7289_/Q vddd vssd sg13cmos5l_nor4_1
XFILLER_6_1296 vddd vssd sg13cmos5l_decap_4
X_6958_ _6958_/Y _6959_/A _6958_/B_N vddd vssd sg13cmos5l_nor2b_1
XFILLER_17_2562 vddd vssd sg13cmos5l_decap_8
X_5909_ _5909_/Y _7097_/Q _5927_/B vddd vssd sg13cmos5l_nor2_1
X_6889_ _6889_/Y _6916_/A _6915_/B_N vddd vssd sg13cmos5l_nor2b_1
XFILLER_17_1872 vddd vssd sg13cmos5l_decap_4
XFILLER_13_2415 vddd vssd sg13cmos5l_decap_8
XFILLER_13_1725 vddd vssd sg13cmos5l_decap_8
XFILLER_10_746 vddd vssd sg13cmos5l_decap_8
XFILLER_30_65 vddd vssd sg13cmos5l_decap_8
XFILLER_11_1482 vddd vssd sg13cmos5l_decap_8
Xhold780 _4333_/A _7365_/Q vddd vssd sg13cmos5l_dlygate4sd3_1
Xhold791 hold791/X _6313_/Y vddd vssd sg13cmos5l_dlygate4sd3_1
XFILLER_1_455 vddd vssd sg13cmos5l_decap_8
XFILLER_24_2544 vddd vssd sg13cmos5l_decap_8
XFILLER_7_1027 vddd vssd sg13cmos5l_decap_4
XFILLER_29_161 vddd vssd sg13cmos5l_decap_8
XFILLER_4_1948 vddd vssd sg13cmos5l_decap_4
Xhold1480 _6775_/A0 _7080_/Q vddd vssd sg13cmos5l_dlygate4sd3_1
Xhold1491 _6985_/D _4795_/B vddd vssd sg13cmos5l_dlygate4sd3_1
XFILLER_32_359 vddd vssd sg13cmos5l_decap_8
XFILLER_31_2548 vddd vssd sg13cmos5l_decap_8
XFILLER_29_2422 vddd vssd sg13cmos5l_decap_8
XFILLER_9_2527 vddd vssd sg13cmos5l_decap_8
X_4240_ _4240_/Y _4240_/A _4240_/B _4240_/C vddd vssd sg13cmos5l_nand3_1
XFILLER_29_2499 vddd vssd sg13cmos5l_decap_8
XFILLER_23_2010 vddd vssd sg13cmos5l_decap_8
X_4171_ _4171_/Y _4168_/Y _4169_/Y _4170_/Y vddd vssd sg13cmos5l_o21ai_1
X_6812_ _6812_/X _6812_/A vddd vssd sg13cmos5l_buf_1
XFILLER_23_326 vddd vssd sg13cmos5l_decap_8
X_6743_ _6743_/Y _6767_/A _6745_/S vddd vssd sg13cmos5l_nand2_1
XFILLER_17_1102 vddd vssd sg13cmos5l_decap_8
X_3955_ _3955_/Y _3955_/A _6395_/B vddd vssd sg13cmos5l_nor2_1
XFILLER_32_871 vddd vssd sg13cmos5l_decap_8
XFILLER_17_1146 vddd vssd sg13cmos5l_decap_8
X_6674_ _6674_/Y _6674_/A _6672_/Y vddd vssd sg13cmos5l_nor2b_1
XFILLER_31_381 vddd vssd sg13cmos5l_decap_8
X_5625_ _5625_/Y _5861_/A _5629_/A vddd vssd sg13cmos5l_nor2b_1
X_3886_ _3886_/Y _7261_/Q _6603_/A vddd vssd sg13cmos5l_nor2_1
XFILLER_30_1313 vddd vssd sg13cmos5l_decap_4
X_5556_ _5556_/Y _7184_/Q _7185_/Q _5556_/C vddd vssd sg13cmos5l_nor3_1
X_5487_ _5488_/D _5566_/A _7174_/Q _7175_/Q vddd vssd sg13cmos5l_nor3_1
X_4507_ _4507_/X _4507_/A _4507_/B vddd vssd sg13cmos5l_or2_1
X_4438_ _4438_/Y _4492_/A _4553_/A _4461_/A _4438_/D vddd vssd sg13cmos5l_nor4_1
X_7226_ _7226_/Q _7229_/CLK _7226_/D fanout368/X vddd vssd sg13cmos5l_dfrbpq_1
Xwire3 wire3/X wire3/A vddd vssd sg13cmos5l_buf_4
XFILLER_24_1117 vddd vssd sg13cmos5l_decap_8
X_7157_ _7157_/Q _7404_/CLK _7157_/D _6819_/B_N vddd vssd sg13cmos5l_dfrbpq_1
X_4369_ _4369_/Y _4366_/Y _4368_/Y _4359_/Y vddd vssd sg13cmos5l_o21ai_1
XFILLER_8_1358 vddd vssd sg13cmos5l_decap_8
X_6108_ _6108_/Y _6175_/A _5150_/B _5150_/C vddd vssd sg13cmos5l_a21oi_1
X_7088_ _7088_/Q _7123_/CLK _7088_/D _6865_/B_N vddd vssd sg13cmos5l_dfrbpq_1
X_6039_ _6039_/Y _6175_/A _6039_/B vddd vssd sg13cmos5l_nand2_1
XFILLER_27_665 vddd vssd sg13cmos5l_decap_8
XFILLER_26_153 vddd vssd sg13cmos5l_decap_8
XFILLER_25_65 vddd vssd sg13cmos5l_decap_8
XFILLER_19_1945 vddd vssd sg13cmos5l_decap_8
XFILLER_17_2392 vddd vssd sg13cmos5l_decap_8
XFILLER_6_514 vddd vssd sg13cmos5l_decap_8
XFILLER_30_2581 vddd vssd sg13cmos5l_decap_8
XFILLER_9_0 vddd vssd sg13cmos5l_decap_8
XFILLER_2_775 vddd vssd sg13cmos5l_decap_8
Xtiedowns\[44\] mask_rev_in[0] vddd vssd sg13cmos5l_antennanp
XFILLER_2_14 vddd vssd sg13cmos5l_decap_8
XFILLER_8_2571 vddd vssd sg13cmos5l_decap_8
XFILLER_24_2363 vddd vssd sg13cmos5l_decap_8
XFILLER_2_69 vddd vssd sg13cmos5l_decap_8
XFILLER_24_1684 vddd vssd sg13cmos5l_decap_8
XFILLER_0_1609 vddd vssd sg13cmos5l_decap_8
XFILLER_4_1756 vddd vssd sg13cmos5l_decap_8
XFILLER_18_676 vddd vssd sg13cmos5l_decap_8
XFILLER_32_112 vddd vssd sg13cmos5l_decap_8
XFILLER_21_808 vddd vssd sg13cmos5l_decap_4
XFILLER_32_189 vddd vssd sg13cmos5l_decap_8
X_3740_ _6789_/A _3755_/A _3740_/B vddd vssd sg13cmos5l_nand2_1
XANTENNA_19 _3758_/X vddd vssd sg13cmos5l_antennanp
XFILLER_14_871 vddd vssd sg13cmos5l_decap_8
XFILLER_18_1477 vddd vssd sg13cmos5l_decap_8
XFILLER_13_392 vddd vssd sg13cmos5l_decap_8
X_3671_ _3671_/Y _3674_/S _4355_/A vddd vssd sg13cmos5l_nor2b_1
X_6390_ _6393_/B _6390_/A _6762_/C vddd vssd sg13cmos5l_nor2_1
X_5410_ _5413_/C _5544_/A _5410_/B vddd vssd sg13cmos5l_or2_1
Xclkbuf_leaf_29_SCK_regs _7264_/CLK clkload6/A vddd vssd sg13cmos5l_buf_8
X_5341_ _5341_/Y _5360_/C _5354_/C vddd vssd sg13cmos5l_nor2_1
XFILLER_9_2335 vddd vssd sg13cmos5l_decap_8
XFILLER_12_1098 vddd vssd sg13cmos5l_decap_4
X_7011_ _7011_/Q _7342_/CLK _7011_/D _6958_/Y vddd vssd sg13cmos5l_dfrbpq_1
X_5272_ _5272_/Y hold636/X _3641_/Y _4912_/B _4828_/A vddd vssd sg13cmos5l_a22oi_1
XFILLER_9_1623 vddd vssd sg13cmos5l_decap_8
X_4223_ _4223_/Y _4219_/Y _4222_/Y _4184_/Y vddd vssd sg13cmos5l_o21ai_1
XFILLER_9_2379 vddd vssd sg13cmos5l_decap_8
X_4154_ _4154_/Y _6285_/A wire70/X _4244_/A2 vddd vssd sg13cmos5l_a21oi_1
XFILLER_5_1509 vddd vssd sg13cmos5l_decap_4
XFILLER_7_2070 vddd vssd sg13cmos5l_decap_8
X_4085_ _4085_/Y mask_rev_in[26] _4263_/B _3786_/Y vddd vssd sg13cmos5l_o21ai_1
XFILLER_23_112 vddd vssd sg13cmos5l_decap_8
XFILLER_24_657 vddd vssd sg13cmos5l_decap_8
X_6726_ _6726_/Y _6726_/A _6726_/B vddd vssd sg13cmos5l_nand2_1
XFILLER_23_189 vddd vssd sg13cmos5l_decap_8
X_4987_ _5207_/A _7258_/Q _7259_/Q vddd vssd sg13cmos5l_nor2_1
XFILLER_32_1408 vddd vssd sg13cmos5l_decap_8
XFILLER_32_690 vddd vssd sg13cmos5l_decap_8
X_3938_ _6483_/A _3938_/A _3938_/B _3961_/B vddd vssd sg13cmos5l_nor3_1
XFILLER_14_2554 vddd vssd sg13cmos5l_decap_8
X_3869_ wire91/A _3878_/A _3878_/C _3936_/B _4010_/C vddd vssd sg13cmos5l_nor4_1
XFILLER_20_885 vddd vssd sg13cmos5l_decap_4
X_6657_ _6657_/X _6657_/A0 _6550_/A _6663_/S vddd vssd sg13cmos5l_mux2_1
X_5608_ _5609_/C _5606_/Y _5607_/X _5614_/C vddd vssd sg13cmos5l_a21oi_1
XFILLER_14_1875 vddd vssd sg13cmos5l_decap_4
X_6588_ _6588_/X _6588_/A0 _6550_/A _6589_/S vddd vssd sg13cmos5l_mux2_1
XFILLER_30_1154 vddd vssd sg13cmos5l_decap_4
X_5539_ _5552_/A _5557_/A _5539_/B vddd vssd sg13cmos5l_nor2_1
XFILLER_11_56 vddd vssd sg13cmos5l_decap_8
XFILLER_2_7 vddd vssd sg13cmos5l_decap_8
Xfanout331 _6492_/A1 _6764_/A1 vddd vssd sg13cmos5l_buf_1
Xfanout320 _5590_/A1 _6238_/A1 vddd vssd sg13cmos5l_buf_1
X_7209_ _7209_/Q _7231_/CLK _7209_/D fanout364/X vddd vssd sg13cmos5l_dfrbpq_1
Xfanout353 fanout353/X fanout354/X vddd vssd sg13cmos5l_buf_1
Xfanout375 fanout375/X fanout380/X vddd vssd sg13cmos5l_buf_1
Xfanout364 fanout364/X fanout372/X vddd vssd sg13cmos5l_buf_1
XFILLER_21_2514 vddd vssd sg13cmos5l_decap_8
Xfanout342 _6893_/B_N _6874_/B_N vddd vssd sg13cmos5l_buf_1
XFILLER_19_429 vddd vssd sg13cmos5l_decap_8
Xclkbuf_4_2__f_clk_regs _7338_/CLK clkbuf_3_1_0_clk_regs/X vddd vssd sg13cmos5l_buf_8
Xfanout386 _6954_/B_N fanout389/X vddd vssd sg13cmos5l_buf_1
Xfanout397 _6952_/B_N _6933_/B_N vddd vssd sg13cmos5l_buf_1
XFILLER_28_930 vddd vssd sg13cmos5l_decap_8
XFILLER_19_2443 vddd vssd sg13cmos5l_decap_8
XFILLER_19_1720 vddd vssd sg13cmos5l_decap_8
XFILLER_15_646 vddd vssd sg13cmos5l_decap_8
XFILLER_13_2097 vddd vssd sg13cmos5l_decap_8
XFILLER_10_373 vddd vssd sg13cmos5l_decap_8
XFILLER_32_1986 vddd vssd sg13cmos5l_decap_8
XFILLER_6_2508 vddd vssd sg13cmos5l_decap_8
XFILLER_26_2458 vddd vssd sg13cmos5l_decap_8
XFILLER_26_1735 vddd vssd sg13cmos5l_decap_8
XFILLER_20_2024 vddd vssd sg13cmos5l_decap_8
XFILLER_19_941 vddd vssd sg13cmos5l_decap_8
XFILLER_0_2107 vddd vssd sg13cmos5l_decap_8
XFILLER_4_1531 vddd vssd sg13cmos5l_decap_8
XFILLER_20_1345 vddd vssd sg13cmos5l_decap_4
XFILLER_4_1575 vddd vssd sg13cmos5l_decap_8
XFILLER_20_1367 vddd vssd sg13cmos5l_decap_8
X_4910_ _7323_/D _4910_/A vddd vssd sg13cmos5l_inv_1
X_5890_ _5890_/Y _5890_/A _5890_/B _5890_/C vddd vssd sg13cmos5l_nand3_1
X_4841_ _4841_/Y _4832_/B _4841_/B vddd vssd sg13cmos5l_nand2b_1
X_4772_ _4772_/Y _4767_/Y _4770_/Y _4771_/Y _4590_/A vddd vssd sg13cmos5l_a22oi_1
X_3723_ wire81/A _3955_/A _6762_/B vddd vssd sg13cmos5l_nor2_1
X_6511_ _6511_/X _6511_/A0 _6558_/A _6512_/B vddd vssd sg13cmos5l_mux2_1
X_3654_ _3655_/B _4831_/B _3654_/B _3654_/C vddd vssd sg13cmos5l_nor3_1
X_6442_ _7171_/D _6442_/A1 _6444_/S _6441_/Y vddd vssd sg13cmos5l_a21oi_1
X_6373_ _6373_/Y wire81/A _6753_/B vddd vssd sg13cmos5l_nand2_1
X_3585_ _3585_/Y _3585_/A vddd vssd sg13cmos5l_inv_1
X_5324_ _5324_/Y _5322_/Y _5323_/Y _5321_/Y vddd vssd sg13cmos5l_o21ai_1
Xoutbuffers\[75\] io_oe[2] _5072_/X vddd vssd sg13cmos5l_buf_16
XFILLER_9_2121 vddd vssd sg13cmos5l_decap_8
X_5255_ _6261_/A _6145_/B _6188_/C vddd vssd sg13cmos5l_or2_1
XFILLER_9_2176 vddd vssd sg13cmos5l_decap_8
X_4206_ _4206_/Y _4206_/A _6185_/C vddd vssd sg13cmos5l_nor2_1
XFILLER_9_1453 vddd vssd sg13cmos5l_decap_8
X_5186_ wire27/A _5186_/A _5186_/B _6144_/B _5186_/D vddd vssd sg13cmos5l_nand4_1
X_4137_ _4137_/Y _5544_/B _6461_/A _4135_/Y _4136_/Y vddd vssd sg13cmos5l_a22oi_1
X_4068_ _4068_/Y _3984_/A _3984_/B _4159_/B _3619_/Y wire81/A vddd vssd sg13cmos5l_a221oi_1
XFILLER_20_2591 vddd vssd sg13cmos5l_decap_8
Xwire96 wire96/X wire96/A vddd vssd sg13cmos5l_buf_4
Xwire85 wire85/X wire85/A vddd vssd sg13cmos5l_buf_4
XFILLER_24_476 vddd vssd sg13cmos5l_decap_8
X_6709_ _6709_/X _6709_/A0 _6342_/A _6709_/S vddd vssd sg13cmos5l_mux2_1
XFILLER_22_77 vddd vssd sg13cmos5l_decap_8
XFILLER_3_336 vddd vssd sg13cmos5l_decap_4
Xfanout172 _6342_/A _6801_/A vddd vssd sg13cmos5l_buf_1
Xfanout150 _6278_/A1 _5271_/A vddd vssd sg13cmos5l_buf_1
Xfanout183 _6520_/A fanout188/X vddd vssd sg13cmos5l_buf_1
Xfanout161 _4492_/A _3493_/Y vddd vssd sg13cmos5l_buf_1
Xfanout194 _6550_/A _6650_/A vddd vssd sg13cmos5l_buf_1
XFILLER_5_2596 vddd vssd sg13cmos5l_decap_8
XFILLER_8_35 vddd vssd sg13cmos5l_decap_8
XFILLER_32_2495 vddd vssd sg13cmos5l_decap_8
XFILLER_15_1458 vddd vssd sg13cmos5l_decap_8
XFILLER_7_631 vddd vssd sg13cmos5l_decap_4
XFILLER_32_1761 vddd vssd sg13cmos5l_decap_8
Xhold609 _7350_/D _4419_/Y vddd vssd sg13cmos5l_dlygate4sd3_1
X_5040_ _5228_/A _7263_/Q _7262_/Q vddd vssd sg13cmos5l_nand2b_1
Xhold1309 _6587_/A1 _5247_/B vddd vssd sg13cmos5l_dlygate4sd3_1
X_6991_ _6991_/Q _7342_/CLK _6991_/D _6938_/Y vddd vssd sg13cmos5l_dfrbpq_1
XFILLER_4_2084 vddd vssd sg13cmos5l_decap_4
X_5942_ _5942_/Y _5942_/A _5942_/B vddd vssd sg13cmos5l_xnor2_1
XFILLER_0_1236 vddd vssd sg13cmos5l_decap_8
X_5873_ _5873_/X _5873_/A _5875_/B _5873_/C vddd vssd sg13cmos5l_and3_1
X_4824_ _4824_/Y _4808_/A _4814_/Y _4819_/Y _4823_/Y _4547_/A vddd vssd sg13cmos5l_a221oi_1
X_4755_ _4755_/Y _4737_/B _4754_/Y _4769_/A1 vddd vssd sg13cmos5l_o21ai_1
X_3706_ _3706_/Y _4009_/B _3936_/B _4010_/B _4010_/C vddd vssd sg13cmos5l_nor4_1
XFILLER_11_2535 vddd vssd sg13cmos5l_decap_8
XFILLER_15_1981 vddd vssd sg13cmos5l_decap_8
X_4686_ _4686_/X _4670_/B _4732_/B _4685_/Y vddd vssd sg13cmos5l_a21o_1
X_6425_ _6425_/Y _6425_/A _6430_/S vddd vssd sg13cmos5l_nand2_1
X_3637_ _3638_/B _4963_/A _4315_/B _4963_/B vddd vssd sg13cmos5l_nand3b_1
X_3568_ _3568_/Y _3568_/A vddd vssd sg13cmos5l_inv_1
X_6356_ _6356_/Y _6732_/A _6359_/B hold634/X vddd vssd sg13cmos5l_o21ai_1
X_5307_ _5307_/Y _5795_/A1 _5304_/Y _5305_/Y _5303_/Y _5306_/Y vddd vssd sg13cmos5l_a221oi_1
X_6287_ _6287_/Y _6287_/A _6287_/B vddd vssd sg13cmos5l_nand2_1
X_3499_ _5513_/A _4674_/A vddd vssd sg13cmos5l_inv_1
X_5238_ _5253_/A _6123_/B _6188_/C vddd vssd sg13cmos5l_nor2_1
XFILLER_29_546 vddd vssd sg13cmos5l_decap_8
X_5169_ wire28/A _5169_/A _5169_/B _6136_/B _5169_/D vddd vssd sg13cmos5l_nand4_1
XFILLER_9_1294 vddd vssd sg13cmos5l_decap_8
XFILLER_17_77 vddd vssd sg13cmos5l_decap_8
XFILLER_0_2482 vddd vssd sg13cmos5l_decap_8
XFILLER_25_774 vddd vssd sg13cmos5l_decap_8
XFILLER_13_903 vddd vssd sg13cmos5l_decap_8
XFILLER_25_796 vddd vssd sg13cmos5l_decap_4
XFILLER_24_295 vddd vssd sg13cmos5l_decap_8
XFILLER_16_2435 vddd vssd sg13cmos5l_decap_8
XFILLER_16_1712 vddd vssd sg13cmos5l_decap_8
XFILLER_12_457 vddd vssd sg13cmos5l_decap_8
XFILLER_32_1046 vddd vssd sg13cmos5l_decap_8
XFILLER_14_1480 vddd vssd sg13cmos5l_decap_8
XFILLER_27_2520 vddd vssd sg13cmos5l_decap_8
XFILLER_0_840 vddd vssd sg13cmos5l_decap_8
XFILLER_27_2597 vddd vssd sg13cmos5l_decap_8
XFILLER_23_1705 vddd vssd sg13cmos5l_decap_8
XFILLER_1_2246 vddd vssd sg13cmos5l_decap_8
XFILLER_21_2185 vddd vssd sg13cmos5l_decap_8
XFILLER_21_1473 vddd vssd sg13cmos5l_decap_8
XFILLER_17_1509 vddd vssd sg13cmos5l_decap_4
X_4540_ _4541_/B _4540_/A _4540_/B vddd vssd sg13cmos5l_xnor2_1
XFILLER_11_1119 vddd vssd sg13cmos5l_decap_8
X_4471_ _4577_/B _6121_/A _4628_/A vddd vssd sg13cmos5l_nand2_1
X_7190_ _7190_/Q _7190_/CLK _7190_/D fanout363/X vddd vssd sg13cmos5l_dfrbpq_1
X_6210_ _6235_/C _7234_/Q _6219_/B vddd vssd sg13cmos5l_nand2_1
X_6141_ wire13/A _6167_/B1 _6122_/Y _6140_/Y vddd vssd sg13cmos5l_o21ai_1
Xhold1106 _6709_/A0 _7038_/Q vddd vssd sg13cmos5l_dlygate4sd3_1
XFILLER_24_0 vddd vssd sg13cmos5l_decap_8
X_6072_ _6073_/C _6072_/A _6072_/B vddd vssd sg13cmos5l_nand2_1
XFILLER_6_2146 vddd vssd sg13cmos5l_decap_8
Xhold1128 _3611_/A _7067_/Q vddd vssd sg13cmos5l_dlygate4sd3_1
X_5023_ _6014_/B _7284_/Q _7285_/Q _5219_/A vddd vssd sg13cmos5l_nor3_1
Xhold1139 _6442_/A1 _5459_/B vddd vssd sg13cmos5l_dlygate4sd3_1
Xhold1117 _6596_/A0 _7253_/Q vddd vssd sg13cmos5l_dlygate4sd3_1
Xoutbuffers\[38\] biasgen_ena _7058_/Q vddd vssd sg13cmos5l_buf_16
XFILLER_26_538 vddd vssd sg13cmos5l_decap_8
X_6974_ _6974_/Q _7357_/CLK _6974_/D _6921_/Y vddd vssd sg13cmos5l_dfrbpq_1
XFILLER_19_590 vddd vssd sg13cmos5l_decap_8
XFILLER_0_1033 vddd vssd sg13cmos5l_decap_8
X_5925_ _5925_/Y _5926_/B hold981/X _5924_/Y vddd vssd sg13cmos5l_a21oi_1
X_5856_ _5857_/B _3539_/Y _5875_/C _3591_/Y vddd vssd sg13cmos5l_a21oi_1
X_4807_ _4808_/C _4798_/A _4802_/B _4806_/Y vddd vssd sg13cmos5l_a21oi_1
XFILLER_22_799 vddd vssd sg13cmos5l_decap_8
XFILLER_21_276 vddd vssd sg13cmos5l_decap_4
X_5787_ _5789_/B _7214_/Q _7215_/Q _5787_/C vddd vssd sg13cmos5l_nor3_1
X_4738_ _4738_/Y _4533_/A _4713_/Y _4737_/Y vddd vssd sg13cmos5l_o21ai_1
X_4669_ _4669_/X _4668_/A _4665_/Y _4668_/Y vddd vssd sg13cmos5l_a21o_1
XFILLER_11_1631 vddd vssd sg13cmos5l_decap_8
X_6408_ _6408_/Y _6408_/A _6408_/B vddd vssd sg13cmos5l_nor2_1
Xhold940 _6411_/A _7154_/Q vddd vssd sg13cmos5l_dlygate4sd3_1
Xhold973 hold973/X _6628_/Y vddd vssd sg13cmos5l_dlygate4sd3_1
Xhold962 _6432_/A _7166_/Q vddd vssd sg13cmos5l_dlygate4sd3_1
X_7388_ _7388_/Q _7388_/CLK _7388_/D _6823_/Y vddd vssd sg13cmos5l_dfrbpq_1
Xhold951 _7309_/D _4947_/Y vddd vssd sg13cmos5l_dlygate4sd3_1
Xhold984 hold984/X _3615_/Y vddd vssd sg13cmos5l_dlygate4sd3_1
Xclkbuf_1_1__f_clk outbuffers\[18\]/A clkbuf_0_clk/X vddd vssd sg13cmos5l_buf_8
X_6339_ _6339_/Y hold987/X _6338_/B _6338_/Y vddd vssd sg13cmos5l_o21ai_1
Xhold995 _3494_/A _7356_/Q vddd vssd sg13cmos5l_dlygate4sd3_1
XFILLER_0_158 vddd vssd sg13cmos5l_decap_8
XFILLER_29_343 vddd vssd sg13cmos5l_decap_8
XFILLER_28_65 vddd vssd sg13cmos5l_decap_4
XFILLER_22_2450 vddd vssd sg13cmos5l_decap_8
XFILLER_22_1771 vddd vssd sg13cmos5l_decap_8
XFILLER_17_538 vddd vssd sg13cmos5l_decap_8
XFILLER_9_726 vddd vssd sg13cmos5l_decap_8
Xtiedowns\[74\] mask_rev_in[30] vddd vssd sg13cmos5l_antennanp
XFILLER_5_14 vddd vssd sg13cmos5l_decap_8
XFILLER_29_1947 vddd vssd sg13cmos5l_decap_8
XFILLER_7_2411 vddd vssd sg13cmos5l_decap_4
XFILLER_27_2394 vddd vssd sg13cmos5l_decap_8
XFILLER_7_2466 vddd vssd sg13cmos5l_decap_8
XFILLER_27_1660 vddd vssd sg13cmos5l_decap_8
XFILLER_7_1754 vddd vssd sg13cmos5l_decap_8
X_3971_ _4238_/B _6395_/A _6395_/B vddd vssd sg13cmos5l_nor2_1
X_5710_ _5710_/Y _5727_/B _5733_/B vddd vssd sg13cmos5l_nand2_1
XFILLER_16_571 vddd vssd sg13cmos5l_decap_8
XFILLER_31_541 vddd vssd sg13cmos5l_decap_8
X_6690_ _6690_/Y _6690_/A _6695_/S vddd vssd sg13cmos5l_nor2_1
X_5641_ _5641_/X _5641_/A _5641_/B _5641_/C vddd vssd sg13cmos5l_or3_1
X_5572_ _5572_/Y _5581_/A _5569_/B vddd vssd sg13cmos5l_nor2b_1
X_4523_ _4523_/X _4496_/A _4810_/B _4522_/Y vddd vssd sg13cmos5l_a21o_1
XFILLER_15_1074 vddd vssd sg13cmos5l_decap_8
XFILLER_8_770 vddd vssd sg13cmos5l_decap_8
X_7311_ _7311_/Q _7401_/CLK _7311_/D _6833_/Y vddd vssd sg13cmos5l_dfrbpq_1
X_7242_ _7242_/Q _7292_/CLK _7242_/D fanout376/X vddd vssd sg13cmos5l_dfrbpq_1
XFILLER_12_1984 vddd vssd sg13cmos5l_decap_8
X_4454_ _4454_/Y _4508_/C _4453_/Y _4553_/A vddd vssd sg13cmos5l_o21ai_1
X_4385_ _4391_/B _4385_/A _7134_/Q vddd vssd sg13cmos5l_xor2_1
X_7173_ _7173_/Q _7189_/CLK _7173_/D fanout360/X vddd vssd sg13cmos5l_dfrbpq_1
X_6124_ _6125_/B _6146_/A _6123_/D _5162_/A vddd vssd sg13cmos5l_a21oi_1
XFILLER_8_1518 vddd vssd sg13cmos5l_decap_4
X_6055_ _6055_/Y _4781_/A _6057_/B _6054_/Y vddd vssd sg13cmos5l_a21oi_1
X_5006_ _5096_/C _7288_/Q _7289_/Q vddd vssd sg13cmos5l_nor2_1
XFILLER_22_1001 vddd vssd sg13cmos5l_decap_8
XFILLER_27_814 vddd vssd sg13cmos5l_decap_8
XFILLER_6_1275 vddd vssd sg13cmos5l_decap_4
XFILLER_26_335 vddd vssd sg13cmos5l_decap_4
XFILLER_22_1078 vddd vssd sg13cmos5l_decap_4
X_6957_ _6957_/Y _6959_/A _6957_/B_N vddd vssd sg13cmos5l_nor2b_1
X_5908_ _5908_/Y _5939_/A _7101_/Q vddd vssd sg13cmos5l_nand2b_1
XFILLER_17_2541 vddd vssd sg13cmos5l_decap_8
X_6888_ _6888_/Y _6893_/A _6893_/B_N vddd vssd sg13cmos5l_nor2b_1
XFILLER_22_574 vddd vssd sg13cmos5l_decap_8
X_5839_ _5839_/Y _5845_/C _5834_/Y _5842_/B _5848_/B _5838_/Y vddd vssd sg13cmos5l_a221oi_1
XFILLER_10_725 vddd vssd sg13cmos5l_decap_8
XFILLER_14_56 vddd vssd sg13cmos5l_decap_8
XFILLER_6_718 vddd vssd sg13cmos5l_decap_4
XFILLER_30_44 vddd vssd sg13cmos5l_decap_8
Xhold781 _4335_/A _4333_/Y vddd vssd sg13cmos5l_dlygate4sd3_1
Xhold770 _7142_/D _6387_/Y vddd vssd sg13cmos5l_dlygate4sd3_1
XFILLER_24_2523 vddd vssd sg13cmos5l_decap_8
Xhold792 hold792/X _7134_/Q vddd vssd sg13cmos5l_dlygate4sd3_1
XFILLER_7_1006 vddd vssd sg13cmos5l_decap_8
XFILLER_24_1822 vddd vssd sg13cmos5l_decap_8
XFILLER_4_1905 vddd vssd sg13cmos5l_decap_8
Xhold1470 _7054_/D _6733_/Y vddd vssd sg13cmos5l_dlygate4sd3_1
XFILLER_29_140 vddd vssd sg13cmos5l_decap_8
Xhold1481 _7080_/D _6775_/X vddd vssd sg13cmos5l_dlygate4sd3_1
XFILLER_18_858 vddd vssd sg13cmos5l_decap_8
Xhold1492 hold498/A _7007_/Q vddd vssd sg13cmos5l_dlygate4sd3_1
XFILLER_32_338 vddd vssd sg13cmos5l_decap_8
XFILLER_18_1604 vddd vssd sg13cmos5l_decap_8
XFILLER_31_2527 vddd vssd sg13cmos5l_decap_8
XFILLER_16_2062 vddd vssd sg13cmos5l_decap_8
XFILLER_29_2401 vddd vssd sg13cmos5l_decap_8
XFILLER_5_773 vddd vssd sg13cmos5l_decap_8
XFILLER_9_2506 vddd vssd sg13cmos5l_decap_8
XFILLER_29_2478 vddd vssd sg13cmos5l_decap_8
X_4170_ _4170_/Y _3510_/Y _4256_/B _4172_/A2 vddd vssd sg13cmos5l_a21oi_1
XFILLER_23_1376 vddd vssd sg13cmos5l_decap_4
X_6811_ _6811_/X _6811_/A vddd vssd sg13cmos5l_buf_1
XFILLER_32_850 vddd vssd sg13cmos5l_decap_8
X_6742_ _6742_/X _6742_/A0 _6405_/A _6745_/S vddd vssd sg13cmos5l_mux2_1
X_3954_ _3954_/Y _3948_/Y _3951_/Y _3953_/Y vddd vssd sg13cmos5l_o21ai_1
Xoutbuffers\[1\] reset _7370_/Q vddd vssd sg13cmos5l_buf_16
X_3885_ _3885_/Y _3881_/Y _3882_/Y _3884_/Y vddd vssd sg13cmos5l_a21oi_1
X_6673_ _6674_/A _4911_/A _4829_/Y _3641_/Y vddd vssd sg13cmos5l_a21oi_1
X_5624_ _5624_/Y _5644_/C _5623_/Y _7196_/Q vddd vssd sg13cmos5l_o21ai_1
XFILLER_30_1358 vddd vssd sg13cmos5l_decap_8
X_5555_ _5555_/X _5789_/A _5555_/B vddd vssd sg13cmos5l_and2_1
XFILLER_12_2493 vddd vssd sg13cmos5l_decap_8
X_5486_ _5488_/C _5748_/A _5486_/B vddd vssd sg13cmos5l_nor2_1
X_4506_ _4650_/A _4507_/A _4507_/B vddd vssd sg13cmos5l_nor2_1
X_7225_ _7225_/Q _7228_/CLK _7225_/D fanout366/X vddd vssd sg13cmos5l_dfrbpq_1
X_4437_ _4438_/D _4437_/A _4437_/B vddd vssd sg13cmos5l_nand2_1
Xwire4 wire4/X wire4/A vddd vssd sg13cmos5l_buf_4
X_7156_ _7156_/Q _7171_/CLK _7156_/D fanout356/X vddd vssd sg13cmos5l_dfrbpq_1
XFILLER_28_1287 vddd vssd sg13cmos5l_decap_8
X_6107_ _6107_/Y _6037_/A _5149_/A _6105_/Y _6106_/Y vddd vssd sg13cmos5l_a22oi_1
Xclkbuf_4_1__f_clk_regs _7335_/CLK clkbuf_3_0_0_clk_regs/X vddd vssd sg13cmos5l_buf_8
X_4368_ _4368_/Y _4412_/A _3532_/Y _4367_/Y vddd vssd sg13cmos5l_o21ai_1
XFILLER_8_1337 vddd vssd sg13cmos5l_decap_8
X_4299_ _4299_/Y _4309_/C _4310_/C _4299_/C vddd vssd sg13cmos5l_nand3_1
X_7087_ _7087_/Q _7268_/CLK _7087_/D fanout387/X vddd vssd sg13cmos5l_dfrbpq_1
X_6038_ _6038_/X _6039_/B _6038_/B vddd vssd sg13cmos5l_or2_1
XFILLER_26_132 vddd vssd sg13cmos5l_decap_8
XFILLER_25_44 vddd vssd sg13cmos5l_decap_8
XFILLER_19_1957 vddd vssd sg13cmos5l_decap_8
XFILLER_10_533 vddd vssd sg13cmos5l_decap_8
XFILLER_30_2560 vddd vssd sg13cmos5l_decap_8
XFILLER_8_2550 vddd vssd sg13cmos5l_decap_8
Xtiedowns\[37\] dbus_in_right[5] vddd vssd sg13cmos5l_antennanp
XFILLER_20_1516 vddd vssd sg13cmos5l_decap_8
XFILLER_4_1779 vddd vssd sg13cmos5l_decap_8
XFILLER_14_850 vddd vssd sg13cmos5l_decap_8
XFILLER_32_168 vddd vssd sg13cmos5l_decap_8
XFILLER_14_1309 vddd vssd sg13cmos5l_decap_4
X_3670_ _3902_/A _3753_/A _3753_/B vddd vssd sg13cmos5l_nand2b_1
X_5340_ _5354_/C _7156_/Q _5340_/B vddd vssd sg13cmos5l_nand2_1
X_5271_ _5271_/Y _5271_/A _6261_/A _5271_/C _5271_/D vddd vssd sg13cmos5l_nand4_1
XFILLER_5_592 vddd vssd sg13cmos5l_decap_4
XFILLER_29_1530 vddd vssd sg13cmos5l_decap_8
X_4222_ _4222_/Y _4222_/A _4222_/B vddd vssd sg13cmos5l_nand2_1
X_7010_ _7010_/Q _7336_/CLK _7010_/D _6957_/Y vddd vssd sg13cmos5l_dfrbpq_1
XFILLER_25_2139 vddd vssd sg13cmos5l_decap_8
X_4153_ _4153_/Y _4153_/A _4153_/B _4153_/C vddd vssd sg13cmos5l_nand3_1
X_4084_ _4084_/Y mask_rev_in[18] _4262_/A2 _4082_/Y _4083_/Y _3748_/Y vddd vssd sg13cmos5l_a221oi_1
Xoutbuffers\[20\] voltgen_source[1] _7074_/Q vddd vssd sg13cmos5l_buf_16
X_4986_ _5011_/A _4986_/A _4986_/B vddd vssd sg13cmos5l_nand2_1
X_6725_ _6725_/X _6725_/A0 _6759_/A _6725_/S vddd vssd sg13cmos5l_mux2_1
XFILLER_23_168 vddd vssd sg13cmos5l_decap_8
X_3937_ _3937_/Y _7205_/Q _6498_/A _3935_/Y _3932_/Y _6490_/A vddd vssd sg13cmos5l_a221oi_1
XFILLER_14_2533 vddd vssd sg13cmos5l_decap_8
X_3868_ _3881_/B _7301_/Q wire92/X vddd vssd sg13cmos5l_nand2_1
XFILLER_14_1832 vddd vssd sg13cmos5l_decap_8
X_6656_ _6656_/X _6656_/A0 _6668_/A _6663_/S vddd vssd sg13cmos5l_mux2_1
XFILLER_30_1133 vddd vssd sg13cmos5l_decap_8
X_5607_ _5607_/X _5627_/A _5613_/A vddd vssd sg13cmos5l_or2_1
X_3799_ wire70/A _3938_/A _3938_/B _6762_/B vddd vssd sg13cmos5l_nor3_1
X_6587_ _6587_/Y _6587_/A1 _6589_/S _6586_/Y vddd vssd sg13cmos5l_o21ai_1
X_5538_ _5539_/B _5538_/A _5538_/B vddd vssd sg13cmos5l_nor2_1
XFILLER_11_35 vddd vssd sg13cmos5l_decap_8
X_5469_ _5469_/Y _5326_/A _5467_/B _5467_/Y _5461_/Y _5470_/B vddd vssd sg13cmos5l_a221oi_1
X_7208_ _7208_/Q _7231_/CLK _7208_/D fanout365/X vddd vssd sg13cmos5l_dfrbpq_1
Xfanout321 _5797_/A1 _6238_/A1 vddd vssd sg13cmos5l_buf_1
Xfanout310 _4566_/A1 _4659_/A1 vddd vssd sg13cmos5l_buf_1
XFILLER_8_1101 vddd vssd sg13cmos5l_decap_8
Xfanout332 _6540_/A1 _6764_/A1 vddd vssd sg13cmos5l_buf_1
Xfanout354 fanout354/X fanout358/X vddd vssd sg13cmos5l_buf_1
XFILLER_28_1084 vddd vssd sg13cmos5l_decap_8
X_7139_ _7139_/Q _7363_/CLK _7139_/D fanout352/X vddd vssd sg13cmos5l_dfrbpq_1
XFILLER_8_1156 vddd vssd sg13cmos5l_decap_8
Xfanout343 _6840_/B_N _6874_/B_N vddd vssd sg13cmos5l_buf_1
Xfanout365 fanout365/X fanout367/X vddd vssd sg13cmos5l_buf_1
XFILLER_19_408 vddd vssd sg13cmos5l_decap_8
Xfanout398 _6933_/B_N fanout408/X vddd vssd sg13cmos5l_buf_1
Xfanout376 fanout376/X fanout380/X vddd vssd sg13cmos5l_buf_1
XFILLER_8_1178 vddd vssd sg13cmos5l_decap_8
Xfanout387 fanout387/X fanout389/X vddd vssd sg13cmos5l_buf_1
XFILLER_28_964 vddd vssd sg13cmos5l_decap_8
XFILLER_32_2600 vddd vssd sg13cmos5l_decap_8
XFILLER_19_2499 vddd vssd sg13cmos5l_decap_8
XFILLER_14_168 vddd vssd sg13cmos5l_decap_4
XFILLER_11_842 vddd vssd sg13cmos5l_decap_8
XFILLER_32_1965 vddd vssd sg13cmos5l_decap_8
XFILLER_11_897 vddd vssd sg13cmos5l_decap_8
XFILLER_7_879 vddd vssd sg13cmos5l_decap_8
XFILLER_26_2437 vddd vssd sg13cmos5l_decap_8
XFILLER_28_7 vddd vssd sg13cmos5l_decap_4
XFILLER_26_1769 vddd vssd sg13cmos5l_decap_8
XFILLER_19_920 vddd vssd sg13cmos5l_decap_8
XFILLER_20_1324 vddd vssd sg13cmos5l_decap_8
X_4840_ _4840_/Y _4832_/Y _4839_/Y hold614/X vddd vssd sg13cmos5l_o21ai_1
Xoutbuffers\[110\] dbus_out[13] _5680_/Y vddd vssd sg13cmos5l_buf_16
XFILLER_20_105 vddd vssd sg13cmos5l_decap_8
X_4771_ _4771_/Y _4771_/A1 _3596_/Y _4771_/B1 _4765_/Y vddd vssd sg13cmos5l_a22oi_1
X_6510_ _7207_/D _6510_/A1 _6512_/B _6509_/Y vddd vssd sg13cmos5l_o21ai_1
X_3722_ _3722_/Y _7135_/Q _3842_/B _6346_/A vddd vssd sg13cmos5l_a21oi_1
X_3653_ _3653_/Y _3654_/C vddd vssd sg13cmos5l_inv_1
XFILLER_9_194 vddd vssd sg13cmos5l_decap_4
X_6441_ _6441_/Y _6464_/A _6444_/S vddd vssd sg13cmos5l_nor2_1
X_6372_ _6372_/X hold804/X _6344_/A _6372_/S vddd vssd sg13cmos5l_mux2_1
X_5323_ _5323_/Y _5484_/A _5327_/A _5320_/B vddd vssd sg13cmos5l_o21ai_1
XFILLER_6_890 vddd vssd sg13cmos5l_decap_8
XFILLER_9_2100 vddd vssd sg13cmos5l_decap_8
X_3584_ _5813_/C _3584_/A vddd vssd sg13cmos5l_inv_1
Xoutbuffers\[68\] idac1_value[0] _7040_/Q vddd vssd sg13cmos5l_buf_16
XFILLER_29_2094 vddd vssd sg13cmos5l_decap_8
X_5254_ _5254_/Y _5254_/A _6250_/B _5254_/C _5254_/D vddd vssd sg13cmos5l_nand4_1
XFILLER_9_1410 vddd vssd sg13cmos5l_decap_8
XFILLER_9_1432 vddd vssd sg13cmos5l_decap_8
X_4205_ _6276_/A dbus_in_left[0] dbus_in_right[0] vddd vssd sg13cmos5l_or2_1
X_5185_ _5186_/D _7297_/Q _5185_/B _5185_/C _5185_/D vddd vssd sg13cmos5l_nor4_1
XFILLER_9_1465 vddd vssd sg13cmos5l_decap_8
XFILLER_9_2199 vddd vssd sg13cmos5l_decap_8
XFILLER_29_728 vddd vssd sg13cmos5l_decap_8
X_4136_ _4136_/Y _5569_/B _6468_/A _6461_/A vddd vssd sg13cmos5l_a21oi_1
X_4067_ _4067_/Y _4065_/Y _4067_/B vddd vssd sg13cmos5l_nand2b_1
XFILLER_20_2570 vddd vssd sg13cmos5l_decap_8
XFILLER_25_912 vddd vssd sg13cmos5l_decap_8
XFILLER_25_978 vddd vssd sg13cmos5l_decap_4
Xwire75 wire75/X wire75/A vddd vssd sg13cmos5l_buf_2
X_4969_ _4969_/Y _4968_/B _4965_/Y _4968_/Y _5988_/A vddd vssd sg13cmos5l_a22oi_1
XFILLER_32_1228 vddd vssd sg13cmos5l_decap_4
X_6708_ _6708_/X _6708_/A0 _6661_/A _6709_/S vddd vssd sg13cmos5l_mux2_1
XFILLER_20_661 vddd vssd sg13cmos5l_decap_8
X_6639_ _6639_/X hold919/X _6645_/A1 _6639_/S vddd vssd sg13cmos5l_mux2_1
XFILLER_22_56 vddd vssd sg13cmos5l_decap_8
XFILLER_10_2205 vddd vssd sg13cmos5l_decap_8
XFILLER_14_1684 vddd vssd sg13cmos5l_decap_8
XFILLER_10_2249 vddd vssd sg13cmos5l_decap_4
XFILLER_3_315 vddd vssd sg13cmos5l_decap_8
XFILLER_4_827 vddd vssd sg13cmos5l_decap_8
XFILLER_10_1559 vddd vssd sg13cmos5l_decap_8
Xfanout140 _3874_/C _4009_/A vddd vssd sg13cmos5l_buf_1
Xfanout151 _5271_/A _4991_/Y vddd vssd sg13cmos5l_buf_1
Xfanout173 _6801_/A hold1450/X vddd vssd sg13cmos5l_buf_1
Xfanout162 _5279_/A hold865/X vddd vssd sg13cmos5l_buf_1
Xfanout195 _6650_/A fanout198/X vddd vssd sg13cmos5l_buf_1
XFILLER_5_2575 vddd vssd sg13cmos5l_decap_8
Xfanout184 _6581_/A _6796_/A vddd vssd sg13cmos5l_buf_1
XFILLER_19_2230 vddd vssd sg13cmos5l_decap_4
XFILLER_16_989 vddd vssd sg13cmos5l_decap_8
XFILLER_19_1551 vddd vssd sg13cmos5l_decap_8
XFILLER_8_14 vddd vssd sg13cmos5l_decap_8
XFILLER_15_1437 vddd vssd sg13cmos5l_decap_8
XFILLER_32_2474 vddd vssd sg13cmos5l_decap_8
XFILLER_32_1740 vddd vssd sg13cmos5l_decap_8
XFILLER_26_2212 vddd vssd sg13cmos5l_decap_8
XFILLER_26_1566 vddd vssd sg13cmos5l_decap_8
XFILLER_4_2063 vddd vssd sg13cmos5l_decap_8
X_6990_ _6990_/Q _7336_/CLK _6990_/D _6937_/Y vddd vssd sg13cmos5l_dfrbpq_1
XFILLER_25_208 vddd vssd sg13cmos5l_decap_8
X_5941_ _5944_/B _5942_/A _5942_/B vddd vssd sg13cmos5l_nand2_1
XFILLER_20_1132 vddd vssd sg13cmos5l_decap_4
XFILLER_0_1215 vddd vssd sg13cmos5l_decap_8
XFILLER_22_904 vddd vssd sg13cmos5l_decap_8
X_5872_ _5872_/Y _5875_/B _5873_/C _5870_/Y vddd vssd sg13cmos5l_a21oi_1
X_4823_ _4823_/Y _4484_/B _4813_/X _4821_/Y _4822_/Y _4486_/C vddd vssd sg13cmos5l_a221oi_1
XFILLER_18_1061 vddd vssd sg13cmos5l_decap_8
X_4754_ _4754_/Y _4754_/A _4778_/A vddd vssd sg13cmos5l_nor2b_1
X_3705_ _3705_/Y _3662_/B _3705_/B vddd vssd sg13cmos5l_nand2b_1
XFILLER_15_1960 vddd vssd sg13cmos5l_decap_8
XFILLER_11_2514 vddd vssd sg13cmos5l_decap_8
X_4685_ _4685_/Y _4685_/A _4685_/B _4685_/C vddd vssd sg13cmos5l_nor3_1
X_3636_ _4963_/B _4972_/A _4965_/B vddd vssd sg13cmos5l_nor2_1
X_6424_ _6430_/S _6424_/A _6753_/B vddd vssd sg13cmos5l_nand2_1
Xclkbuf_leaf_13_SCK_regs _7201_/CLK clkload9/A vddd vssd sg13cmos5l_buf_8
X_3567_ _5606_/B _3567_/A vddd vssd sg13cmos5l_inv_1
X_6355_ _6355_/Y _6355_/A _6359_/B vddd vssd sg13cmos5l_nand2_1
X_6286_ _6287_/B _7078_/Q _7079_/Q vddd vssd sg13cmos5l_nand2_1
X_5306_ _5306_/Y _5306_/A _5303_/D vddd vssd sg13cmos5l_nor2b_1
X_5237_ _5237_/Y _5237_/A _5237_/B _5237_/C _5237_/D vddd vssd sg13cmos5l_nand4_1
XFILLER_25_1010 vddd vssd sg13cmos5l_decap_8
X_3498_ _4630_/A _4616_/A vddd vssd sg13cmos5l_inv_1
XFILLER_25_1065 vddd vssd sg13cmos5l_decap_8
XFILLER_25_1054 vddd vssd sg13cmos5l_decap_8
X_5168_ _5169_/D _5168_/A _5168_/B _5168_/C _6137_/A vddd vssd sg13cmos5l_nor4_1
X_5099_ _5103_/B _6069_/B _5099_/B _6060_/C vddd vssd sg13cmos5l_nand3_1
X_4119_ _4119_/Y _7239_/Q _6568_/A _4112_/Y _4115_/Y _4118_/Y vddd vssd sg13cmos5l_a221oi_1
XFILLER_22_1986 vddd vssd sg13cmos5l_decap_4
XFILLER_17_56 vddd vssd sg13cmos5l_decap_8
XFILLER_0_2461 vddd vssd sg13cmos5l_decap_8
XFILLER_25_786 vddd vssd sg13cmos5l_decap_4
XFILLER_16_2414 vddd vssd sg13cmos5l_decap_8
XFILLER_12_425 vddd vssd sg13cmos5l_decap_8
XFILLER_16_1746 vddd vssd sg13cmos5l_decap_8
XFILLER_32_1025 vddd vssd sg13cmos5l_decap_8
XFILLER_21_970 vddd vssd sg13cmos5l_decap_4
XFILLER_10_2002 vddd vssd sg13cmos5l_decap_8
XFILLER_4_635 vddd vssd sg13cmos5l_decap_8
XFILLER_27_2576 vddd vssd sg13cmos5l_decap_8
XFILLER_27_1875 vddd vssd sg13cmos5l_decap_4
XFILLER_30_233 vddd vssd sg13cmos5l_decap_8
XFILLER_15_1245 vddd vssd sg13cmos5l_decap_4
XFILLER_32_2293 vddd vssd sg13cmos5l_decap_8
XFILLER_11_480 vddd vssd sg13cmos5l_decap_8
X_4470_ _4628_/A _5542_/A _4674_/A _4674_/B vddd vssd sg13cmos5l_nor3_1
X_6140_ _6140_/Y _7296_/Q _6138_/Y _6139_/Y vddd vssd sg13cmos5l_o21ai_1
XFILLER_6_1413 vddd vssd sg13cmos5l_decap_8
X_6071_ _6073_/B _5101_/A _6070_/Y _6059_/Y vddd vssd sg13cmos5l_o21ai_1
Xhold1129 _6755_/A1 _3611_/Y vddd vssd sg13cmos5l_dlygate4sd3_1
X_5022_ _5219_/A _7283_/Q _7282_/Q vddd vssd sg13cmos5l_nand2b_1
Xhold1107 _7038_/D _6709_/X vddd vssd sg13cmos5l_dlygate4sd3_1
Xhold1118 _7253_/D _6596_/X vddd vssd sg13cmos5l_dlygate4sd3_1
XFILLER_17_0 vddd vssd sg13cmos5l_decap_8
X_6973_ _6973_/Q _7357_/CLK _6973_/D _6920_/Y vddd vssd sg13cmos5l_dfrbpq_1
XFILLER_0_70 vddd vssd sg13cmos5l_decap_8
XFILLER_4_1192 vddd vssd sg13cmos5l_decap_4
X_5924_ _5924_/Y _3495_/Y _5926_/B _5926_/A vddd vssd sg13cmos5l_o21ai_1
XFILLER_22_723 vddd vssd sg13cmos5l_decap_8
X_5855_ _5855_/Y _6211_/A _7226_/Q _7227_/Q vddd vssd sg13cmos5l_nor3_1
X_4806_ _4806_/Y _4806_/A _4806_/B vddd vssd sg13cmos5l_nand2_1
X_5786_ _5786_/Y _5786_/A _5786_/B _5786_/C vddd vssd sg13cmos5l_nor3_1
Xtiedowns\[3\] sram_odata[3] vddd vssd sg13cmos5l_antennanp
X_4737_ _4737_/Y _4712_/B _4737_/B vddd vssd sg13cmos5l_nand2b_1
X_4668_ _4668_/Y _4668_/A _4668_/B vddd vssd sg13cmos5l_nor2_1
XFILLER_11_2355 vddd vssd sg13cmos5l_decap_4
X_3619_ _3619_/Y _3619_/A vddd vssd sg13cmos5l_inv_1
X_6407_ _6407_/X _6722_/A _6407_/A1 _6408_/B vddd vssd sg13cmos5l_mux2_1
Xhold930 hold930/X _6425_/Y vddd vssd sg13cmos5l_dlygate4sd3_1
X_4599_ _4600_/B _4698_/B _3603_/Y _4598_/Y vddd vssd sg13cmos5l_a21oi_1
Xhold963 hold963/X _6432_/Y vddd vssd sg13cmos5l_dlygate4sd3_1
Xhold941 hold941/X _6411_/Y vddd vssd sg13cmos5l_dlygate4sd3_1
Xhold952 _6439_/A _7170_/Q vddd vssd sg13cmos5l_dlygate4sd3_1
X_7387_ _7387_/Q _7403_/CLK _7387_/D _6901_/Y vddd vssd sg13cmos5l_dfrbpq_1
Xhold985 _7074_/D _6766_/Y vddd vssd sg13cmos5l_dlygate4sd3_1
X_6338_ _6338_/Y _6732_/A _6338_/B vddd vssd sg13cmos5l_nand2_1
Xhold974 _6610_/A _7262_/Q vddd vssd sg13cmos5l_dlygate4sd3_1
Xhold996 _4405_/A _3494_/Y vddd vssd sg13cmos5l_dlygate4sd3_1
X_6269_ _6269_/Y _6177_/A _6266_/A _6268_/Y vddd vssd sg13cmos5l_o21ai_1
XFILLER_28_44 vddd vssd sg13cmos5l_decap_8
XFILLER_2_2523 vddd vssd sg13cmos5l_decap_8
XFILLER_28_99 vddd vssd sg13cmos5l_decap_8
XFILLER_0_2291 vddd vssd sg13cmos5l_decap_8
XFILLER_25_583 vddd vssd sg13cmos5l_decap_8
Xtiedowns\[67\] mask_rev_in[23] vddd vssd sg13cmos5l_antennanp
XFILLER_29_1926 vddd vssd sg13cmos5l_decap_8
XFILLER_5_999 vddd vssd sg13cmos5l_decap_4
XFILLER_27_2373 vddd vssd sg13cmos5l_decap_8
XFILLER_7_1700 vddd vssd sg13cmos5l_decap_8
XFILLER_7_1733 vddd vssd sg13cmos5l_decap_8
XFILLER_3_1608 vddd vssd sg13cmos5l_decap_8
XFILLER_10_7 vddd vssd sg13cmos5l_decap_4
XFILLER_16_550 vddd vssd sg13cmos5l_decap_8
X_3970_ _3970_/Y _3965_/Y _3967_/X _3968_/Y vddd vssd sg13cmos5l_o21ai_1
XFILLER_1_1398 vddd vssd sg13cmos5l_decap_4
XFILLER_17_1329 vddd vssd sg13cmos5l_decap_8
X_5640_ _5641_/C _5640_/A _5640_/B vddd vssd sg13cmos5l_nand2_1
XFILLER_30_1518 vddd vssd sg13cmos5l_decap_8
XFILLER_15_1053 vddd vssd sg13cmos5l_decap_8
X_5571_ _5571_/Y _5748_/A _5569_/B vddd vssd sg13cmos5l_nor2b_1
X_4522_ _4522_/Y _4547_/A _4522_/B _4522_/C vddd vssd sg13cmos5l_nor3_1
X_7310_ _7310_/Q _7401_/CLK _7310_/D _6832_/Y vddd vssd sg13cmos5l_dfrbpq_1
X_4453_ _4453_/Y _4531_/A _4511_/C vddd vssd sg13cmos5l_nand2_1
X_7241_ _7241_/Q _7296_/CLK _7241_/D fanout373/X vddd vssd sg13cmos5l_dfrbpq_1
X_7172_ _7172_/Q _7189_/CLK _7172_/D fanout360/X vddd vssd sg13cmos5l_dfrbpq_1
X_4384_ _4390_/C _4662_/A _7128_/Q vddd vssd sg13cmos5l_xor2_1
X_6123_ _6123_/Y _6239_/A _6123_/B _6145_/C _6123_/D vddd vssd sg13cmos5l_nor4_1
Xclkbuf_4_0__f_clk_regs _7336_/CLK clkbuf_3_0_0_clk_regs/X vddd vssd sg13cmos5l_buf_8
Xoutbuffers\[50\] bandgap_trim[11] _6294_/Y vddd vssd sg13cmos5l_buf_16
X_6054_ _6054_/Y _6057_/B _5457_/A vddd vssd sg13cmos5l_nor2b_1
XFILLER_6_1232 vddd vssd sg13cmos5l_decap_8
X_5005_ _5008_/D _7266_/Q _7267_/Q _5208_/A _5209_/B vddd vssd sg13cmos5l_nor4_1
XFILLER_22_1057 vddd vssd sg13cmos5l_decap_8
X_6956_ _6956_/Y _6956_/A _6956_/B_N vddd vssd sg13cmos5l_nor2b_1
XFILLER_22_520 vddd vssd sg13cmos5l_decap_8
XFILLER_17_2520 vddd vssd sg13cmos5l_decap_8
X_5907_ _5926_/B _7086_/Q _7087_/Q vddd vssd sg13cmos5l_nand2b_1
X_6887_ _6887_/Y _6916_/A _6916_/B_N vddd vssd sg13cmos5l_nor2b_1
XFILLER_14_35 vddd vssd sg13cmos5l_decap_8
XFILLER_17_2597 vddd vssd sg13cmos5l_decap_8
X_5838_ _5838_/Y _5836_/X _5837_/X _5845_/C vddd vssd sg13cmos5l_a21oi_1
XFILLER_22_597 vddd vssd sg13cmos5l_decap_8
X_5769_ _5794_/C _7214_/Q _5778_/B vddd vssd sg13cmos5l_nand2_1
XFILLER_30_23 vddd vssd sg13cmos5l_decap_8
XFILLER_11_2163 vddd vssd sg13cmos5l_decap_8
XFILLER_2_903 vddd vssd sg13cmos5l_decap_4
XFILLER_2_914 vddd vssd sg13cmos5l_decap_4
Xhold782 _7365_/D _4335_/X vddd vssd sg13cmos5l_dlygate4sd3_1
Xhold760 _4353_/A _7360_/Q vddd vssd sg13cmos5l_dlygate4sd3_1
Xhold771 _3532_/A _7092_/Q vddd vssd sg13cmos5l_dlygate4sd3_1
XFILLER_24_2502 vddd vssd sg13cmos5l_decap_8
Xhold793 _7134_/D _6371_/X vddd vssd sg13cmos5l_dlygate4sd3_1
XFILLER_24_2579 vddd vssd sg13cmos5l_decap_8
XFILLER_24_1867 vddd vssd sg13cmos5l_decap_8
Xhold1460 hold1460/X _7347_/Q vddd vssd sg13cmos5l_dlygate4sd3_1
XFILLER_18_804 vddd vssd sg13cmos5l_decap_8
XFILLER_29_196 vddd vssd sg13cmos5l_decap_8
Xhold1482 _3614_/A _7078_/Q vddd vssd sg13cmos5l_dlygate4sd3_1
Xhold1471 _6730_/A1 _7052_/Q vddd vssd sg13cmos5l_dlygate4sd3_1
XFILLER_17_336 vddd vssd sg13cmos5l_decap_4
Xhold1493 _7008_/D _4733_/B vddd vssd sg13cmos5l_dlygate4sd3_1
XFILLER_32_317 vddd vssd sg13cmos5l_decap_8
XFILLER_26_881 vddd vssd sg13cmos5l_decap_8
XFILLER_18_1627 vddd vssd sg13cmos5l_decap_8
XFILLER_16_2030 vddd vssd sg13cmos5l_decap_4
XFILLER_31_2506 vddd vssd sg13cmos5l_decap_8
XFILLER_12_1259 vddd vssd sg13cmos5l_decap_8
XFILLER_29_2457 vddd vssd sg13cmos5l_decap_8
XFILLER_29_1767 vddd vssd sg13cmos5l_decap_8
XFILLER_1_991 vddd vssd sg13cmos5l_decap_4
XFILLER_7_1563 vddd vssd sg13cmos5l_decap_8
XFILLER_23_1344 vddd vssd sg13cmos5l_decap_8
X_6810_ _6810_/X _6810_/A vddd vssd sg13cmos5l_buf_1
X_6741_ _7058_/D _6748_/A1 _6745_/S _6741_/B1 vddd vssd sg13cmos5l_a21oi_1
X_3953_ _3953_/Y _7181_/Q _6453_/A _6445_/A vddd vssd sg13cmos5l_a21oi_1
X_6672_ _6672_/Y _6840_/A _6840_/B_N vddd vssd sg13cmos5l_nor2b_1
X_3884_ _3884_/Y _3884_/A _6603_/A _3884_/C vddd vssd sg13cmos5l_nand3_1
X_5623_ _5623_/Y _5623_/A _5647_/B vddd vssd sg13cmos5l_nor2b_1
Xoutbuffers\[98\] dbus_out[1] _5335_/Y vddd vssd sg13cmos5l_buf_16
X_5554_ _5554_/Y _5326_/A _5552_/B _5552_/Y _5546_/Y _5555_/B vddd vssd sg13cmos5l_a221oi_1
XFILLER_12_2472 vddd vssd sg13cmos5l_decap_8
X_5485_ _5486_/B _7174_/Q _7175_/Q vddd vssd sg13cmos5l_nand2_1
X_4505_ _4507_/B _4821_/A _4505_/B vddd vssd sg13cmos5l_nor2_1
XFILLER_12_1782 vddd vssd sg13cmos5l_decap_4
X_7224_ _7224_/Q _7229_/CLK _7224_/D fanout368/X vddd vssd sg13cmos5l_dfrbpq_1
X_4436_ _4437_/B hold659/X _4396_/C _5926_/A vddd vssd sg13cmos5l_o21ai_1
Xwire5 wire5/X wire5/A vddd vssd sg13cmos5l_buf_8
X_4367_ _4367_/Y _4410_/A _7093_/Q vddd vssd sg13cmos5l_nand2b_1
XFILLER_8_1316 vddd vssd sg13cmos5l_decap_8
X_7155_ _7155_/Q _7171_/CLK _7155_/D fanout356/X vddd vssd sg13cmos5l_dfrbpq_1
X_6106_ _6106_/Y _6263_/A1 _5149_/B _5149_/A vddd vssd sg13cmos5l_a21oi_1
X_4298_ _4298_/Y _6713_/A1 _4297_/B _4312_/A hold665/X vddd vssd sg13cmos5l_a22oi_1
X_7086_ _7086_/Q _7268_/CLK _7086_/D fanout387/X vddd vssd sg13cmos5l_dfrbpq_1
XFILLER_27_612 vddd vssd sg13cmos5l_decap_8
X_6037_ _6038_/B _6037_/A _6037_/B vddd vssd sg13cmos5l_nor2_1
XFILLER_26_111 vddd vssd sg13cmos5l_decap_8
XFILLER_15_818 vddd vssd sg13cmos5l_decap_8
XFILLER_26_188 vddd vssd sg13cmos5l_decap_8
XFILLER_25_23 vddd vssd sg13cmos5l_decap_8
X_6939_ _6939_/Y _6959_/A _6960_/B_N vddd vssd sg13cmos5l_nor2b_1
XFILLER_17_2361 vddd vssd sg13cmos5l_decap_8
XFILLER_29_1019 vddd vssd sg13cmos5l_decap_8
XFILLER_2_711 vddd vssd sg13cmos5l_decap_8
Xhold590 hold590/X _7368_/Q vddd vssd sg13cmos5l_dlygate4sd3_1
XFILLER_2_49 vddd vssd sg13cmos5l_decap_4
XFILLER_4_2448 vddd vssd sg13cmos5l_decap_8
XFILLER_24_1653 vddd vssd sg13cmos5l_decap_8
XFILLER_18_623 vddd vssd sg13cmos5l_decap_8
Xhold1290 _6547_/A1 _5863_/A vddd vssd sg13cmos5l_dlygate4sd3_1
XFILLER_18_2125 vddd vssd sg13cmos5l_decap_8
XFILLER_32_147 vddd vssd sg13cmos5l_decap_8
XFILLER_31_2303 vddd vssd sg13cmos5l_decap_8
XFILLER_18_1424 vddd vssd sg13cmos5l_decap_8
XFILLER_31_1635 vddd vssd sg13cmos5l_decap_8
XFILLER_9_398 vddd vssd sg13cmos5l_decap_8
XFILLER_12_1078 vddd vssd sg13cmos5l_decap_4
X_5270_ _5271_/D _6268_/A _5270_/B _6272_/B _5270_/D vddd vssd sg13cmos5l_nor4_1
XFILLER_29_2265 vddd vssd sg13cmos5l_decap_8
XFILLER_25_2107 vddd vssd sg13cmos5l_decap_4
X_4221_ _4222_/B _7202_/Q _6498_/A _6483_/A _5633_/B vddd vssd sg13cmos5l_a22oi_1
XFILLER_9_1636 vddd vssd sg13cmos5l_decap_8
XFILLER_29_1597 vddd vssd sg13cmos5l_decap_8
X_4152_ _4153_/C _7063_/Q _6746_/A wire70/X vddd vssd sg13cmos5l_a21oi_1
XFILLER_23_1141 vddd vssd sg13cmos5l_decap_8
X_4083_ _4083_/Y _3618_/Y wire85/X _4262_/A2 vddd vssd sg13cmos5l_a21oi_1
Xclkbuf_leaf_38_SCK_regs _7164_/CLK clkbuf_3_0_0_SCK_regs/X vddd vssd sg13cmos5l_buf_8
XFILLER_7_1393 vddd vssd sg13cmos5l_decap_8
XFILLER_23_1185 vddd vssd sg13cmos5l_decap_8
Xoutbuffers\[13\] proj_sel[0] _7024_/Q vddd vssd sg13cmos5l_buf_16
XFILLER_23_147 vddd vssd sg13cmos5l_decap_8
X_4985_ _4986_/B _5204_/A _7245_/Q vddd vssd sg13cmos5l_nor2_1
X_6724_ _6724_/X _6724_/A0 _6408_/A _6725_/S vddd vssd sg13cmos5l_mux2_1
X_3936_ _6490_/A _3938_/A _3936_/B _3961_/B vddd vssd sg13cmos5l_nor3_1
XFILLER_14_2512 vddd vssd sg13cmos5l_decap_8
XFILLER_31_191 vddd vssd sg13cmos5l_decap_8
X_3867_ wire92/A _3878_/A _3867_/B _3936_/B _4010_/C vddd vssd sg13cmos5l_nor4_1
X_6655_ _7290_/D _6667_/A1 _6663_/S _6655_/B1 vddd vssd sg13cmos5l_a21oi_1
XFILLER_14_2589 vddd vssd sg13cmos5l_decap_8
X_3798_ _3802_/B _7072_/Q _4241_/A2 _3797_/X _3694_/Y vddd vssd sg13cmos5l_a22oi_1
X_5606_ _5606_/Y _5752_/A _5606_/B vddd vssd sg13cmos5l_nand2_1
X_6586_ _6586_/Y _6636_/A _6589_/S vddd vssd sg13cmos5l_nand2_1
XFILLER_11_14 vddd vssd sg13cmos5l_decap_8
X_5537_ _5538_/B _3539_/A _5560_/C _5557_/B vddd vssd sg13cmos5l_o21ai_1
XFILLER_12_2280 vddd vssd sg13cmos5l_decap_4
X_5468_ _5470_/B _7170_/Q _7171_/Q _5468_/C vddd vssd sg13cmos5l_nor3_1
X_7207_ _7207_/Q _7231_/CLK _7207_/D fanout365/X vddd vssd sg13cmos5l_dfrbpq_1
Xfanout322 _6238_/A1 _3546_/Y vddd vssd sg13cmos5l_buf_1
Xfanout311 _4659_/A1 hold1282/X vddd vssd sg13cmos5l_buf_1
X_4419_ _4419_/Y _4419_/A _4419_/B _4419_/C vddd vssd sg13cmos5l_nor3_1
Xfanout300 _5441_/B hold1427/X vddd vssd sg13cmos5l_buf_1
X_5399_ _5416_/C _7163_/Q _7162_/Q vddd vssd sg13cmos5l_nor2b_1
Xfanout333 _6764_/A1 _3465_/Y vddd vssd sg13cmos5l_buf_1
X_7138_ _7138_/Q _7363_/CLK _7138_/D fanout352/X vddd vssd sg13cmos5l_dfrbpq_1
Xfanout355 _6819_/B_N fanout356/X vddd vssd sg13cmos5l_buf_1
Xfanout366 fanout366/X fanout367/X vddd vssd sg13cmos5l_buf_1
Xfanout344 _6874_/B_N fanout347/X vddd vssd sg13cmos5l_buf_1
Xfanout399 _6945_/B_N _6964_/B_N vddd vssd sg13cmos5l_buf_1
X_7069_ _7069_/Q _7190_/CLK _7069_/D fanout352/X vddd vssd sg13cmos5l_dfrbpq_1
Xfanout377 fanout377/X fanout379/X vddd vssd sg13cmos5l_buf_1
XFILLER_21_2549 vddd vssd sg13cmos5l_decap_8
Xfanout388 _6956_/B_N fanout389/X vddd vssd sg13cmos5l_buf_1
XFILLER_15_659 vddd vssd sg13cmos5l_decap_8
XFILLER_19_2478 vddd vssd sg13cmos5l_decap_8
XFILLER_23_681 vddd vssd sg13cmos5l_decap_8
XFILLER_19_1777 vddd vssd sg13cmos5l_decap_8
XFILLER_13_2033 vddd vssd sg13cmos5l_decap_8
XFILLER_32_1944 vddd vssd sg13cmos5l_decap_8
XFILLER_13_1354 vddd vssd sg13cmos5l_decap_8
XFILLER_26_2416 vddd vssd sg13cmos5l_decap_8
XFILLER_4_2256 vddd vssd sg13cmos5l_decap_8
XFILLER_24_1472 vddd vssd sg13cmos5l_decap_8
XFILLER_20_2059 vddd vssd sg13cmos5l_decap_8
XFILLER_20_1303 vddd vssd sg13cmos5l_decap_8
XFILLER_0_1419 vddd vssd sg13cmos5l_decap_4
XFILLER_19_987 vddd vssd sg13cmos5l_decap_8
XFILLER_21_629 vddd vssd sg13cmos5l_decap_8
XFILLER_18_1210 vddd vssd sg13cmos5l_decap_8
Xoutbuffers\[103\] dbus_out[6] _5478_/Y vddd vssd sg13cmos5l_buf_16
X_4770_ _4770_/Y _4806_/A _4769_/Y _4590_/A vddd vssd sg13cmos5l_a21oi_1
XFILLER_18_1287 vddd vssd sg13cmos5l_decap_4
X_3721_ _6363_/A _3984_/B _3962_/A vddd vssd sg13cmos5l_nand2_1
XFILLER_14_1118 vddd vssd sg13cmos5l_decap_8
XFILLER_31_1443 vddd vssd sg13cmos5l_decap_4
X_3652_ _3652_/Y _5947_/B _3652_/B _3652_/C _3652_/D vddd vssd sg13cmos5l_nand4_1
X_6440_ _7170_/D _6492_/A1 _6444_/S hold953/X vddd vssd sg13cmos5l_o21ai_1
X_6371_ _6371_/X hold792/X _6342_/A _6371_/S vddd vssd sg13cmos5l_mux2_1
X_3583_ _5812_/C _3583_/A vddd vssd sg13cmos5l_inv_1
X_5322_ _5322_/Y _5464_/A _7153_/Q vddd vssd sg13cmos5l_nor2_1
XFILLER_29_2062 vddd vssd sg13cmos5l_decap_8
X_5253_ _5254_/D _5253_/A _5253_/B _5253_/C _5253_/D vddd vssd sg13cmos5l_nor4_1
X_4204_ _6185_/C dbus_in_left[0] dbus_in_right[0] vddd vssd sg13cmos5l_nor2_1
X_5184_ _5185_/D _5184_/A _6147_/A _5184_/C _6158_/B vddd vssd sg13cmos5l_nand4_1
X_4135_ _4135_/Y _4132_/Y _4133_/Y _4134_/X vddd vssd sg13cmos5l_a21oi_1
XFILLER_9_1488 vddd vssd sg13cmos5l_decap_8
XFILLER_28_228 vddd vssd sg13cmos5l_decap_4
X_4066_ _4067_/B _7042_/Q _3836_/Y _4159_/B vddd vssd sg13cmos5l_a21oi_1
Xwire10 wire10/X wire11/X vddd vssd sg13cmos5l_buf_4
XFILLER_20_1870 vddd vssd sg13cmos5l_decap_8
Xwire21 wire21/X wire21/A vddd vssd sg13cmos5l_buf_4
XFILLER_3_1076 vddd vssd sg13cmos5l_decap_8
Xwire76 wire76/X wire76/A vddd vssd sg13cmos5l_buf_4
XFILLER_3_1098 vddd vssd sg13cmos5l_decap_4
XFILLER_0_1964 vddd vssd sg13cmos5l_decap_4
XFILLER_19_1029 vddd vssd sg13cmos5l_decap_8
Xwire98 wire98/X wire98/A vddd vssd sg13cmos5l_buf_4
X_4968_ _4968_/Y _4968_/A _4968_/B vddd vssd sg13cmos5l_nor2_1
XFILLER_32_1207 vddd vssd sg13cmos5l_decap_8
X_6707_ _6707_/X _6707_/A0 _6770_/A1 _6709_/S vddd vssd sg13cmos5l_mux2_1
XFILLER_20_640 vddd vssd sg13cmos5l_decap_8
X_3919_ _6529_/A _3919_/A wire95/A vddd vssd sg13cmos5l_nor2b_1
X_4899_ _4916_/B _4899_/A _4898_/Y vddd vssd sg13cmos5l_nor2b_1
X_6638_ _6638_/X hold708/X _6650_/A _6639_/S vddd vssd sg13cmos5l_mux2_1
XFILLER_22_35 vddd vssd sg13cmos5l_decap_8
XFILLER_14_1641 vddd vssd sg13cmos5l_decap_4
X_6569_ _6569_/Y _6569_/A _6574_/B vddd vssd sg13cmos5l_nand2_1
XFILLER_10_1538 vddd vssd sg13cmos5l_decap_8
Xfanout130 _4758_/B1 _4428_/Y vddd vssd sg13cmos5l_buf_1
XFILLER_25_2482 vddd vssd sg13cmos5l_decap_8
Xfanout141 _3874_/B _3902_/A vddd vssd sg13cmos5l_buf_1
Xfanout163 _4339_/C hold865/X vddd vssd sg13cmos5l_buf_1
Xfanout152 _4771_/B1 _4488_/A vddd vssd sg13cmos5l_buf_1
XFILLER_5_2554 vddd vssd sg13cmos5l_decap_8
Xfanout174 _6661_/A _6777_/A vddd vssd sg13cmos5l_buf_1
Xfanout185 _6645_/A1 _6796_/A vddd vssd sg13cmos5l_buf_1
Xfanout196 _6773_/A _6317_/A vddd vssd sg13cmos5l_buf_1
XFILLER_21_2379 vddd vssd sg13cmos5l_decap_8
XFILLER_21_1645 vddd vssd sg13cmos5l_decap_4
XFILLER_5_1864 vddd vssd sg13cmos5l_decap_8
XFILLER_30_426 vddd vssd sg13cmos5l_decap_8
XFILLER_32_2453 vddd vssd sg13cmos5l_decap_8
XFILLER_6_110 vddd vssd sg13cmos5l_decap_8
XFILLER_7_644 vddd vssd sg13cmos5l_decap_8
XFILLER_32_1796 vddd vssd sg13cmos5l_decap_8
XFILLER_7_699 vddd vssd sg13cmos5l_decap_8
XFILLER_13_1195 vddd vssd sg13cmos5l_decap_8
XFILLER_3_883 vddd vssd sg13cmos5l_decap_8
XFILLER_26_1589 vddd vssd sg13cmos5l_decap_4
XFILLER_4_1341 vddd vssd sg13cmos5l_decap_8
X_5940_ _5940_/Y _5945_/A _5942_/B _5940_/C vddd vssd sg13cmos5l_nor3_1
XFILLER_19_784 vddd vssd sg13cmos5l_decap_8
XFILLER_18_283 vddd vssd sg13cmos5l_decap_8
X_5871_ _5871_/Y _5871_/A _7226_/Q _7227_/Q _5875_/B vddd vssd sg13cmos5l_nand4_1
X_4822_ _4822_/Y _4822_/A _4459_/B vddd vssd sg13cmos5l_nor2b_1
X_4753_ _4753_/Y _4778_/A _4810_/B vddd vssd sg13cmos5l_nand2_1
X_3704_ _4010_/B _3693_/B _3928_/A vddd vssd sg13cmos5l_nand2b_1
X_6423_ _6423_/X _6459_/A hold874/X _6423_/S vddd vssd sg13cmos5l_mux2_1
XFILLER_15_1972 vddd vssd sg13cmos5l_decap_4
X_4684_ _4685_/C _4684_/A _4684_/B vddd vssd sg13cmos5l_nor2_1
X_3635_ _5279_/B _4305_/A _4293_/C _4287_/B vddd vssd sg13cmos5l_nand3_1
Xoutbuffers\[80\] io_oe[7] wire27/X vddd vssd sg13cmos5l_buf_16
X_3566_ _5601_/B _3566_/A vddd vssd sg13cmos5l_inv_1
X_6354_ _7123_/D _6336_/A _6359_/B hold670/X vddd vssd sg13cmos5l_o21ai_1
X_6285_ _6285_/Y _6285_/A _6285_/B _6287_/A vddd vssd sg13cmos5l_nand3_1
XFILLER_27_1309 vddd vssd sg13cmos5l_decap_8
X_5305_ _5305_/Y _5292_/Y _5302_/Y _5304_/Y vddd vssd sg13cmos5l_a21oi_1
X_3497_ _3497_/Y _4382_/A vddd vssd sg13cmos5l_inv_1
XFILLER_0_319 vddd vssd sg13cmos5l_decap_8
X_5236_ _5237_/D _6188_/D _5236_/B _5236_/C _5236_/D vddd vssd sg13cmos5l_nor4_1
XFILLER_5_1138 vddd vssd sg13cmos5l_decap_8
X_5167_ _6137_/A _5167_/A _5176_/B vddd vssd sg13cmos5l_nor2_1
X_5098_ _5100_/C _5223_/A _5224_/A _5262_/A vddd vssd sg13cmos5l_nor3_1
X_4118_ _4118_/Y _4206_/A _6136_/A _3908_/Y vddd vssd sg13cmos5l_o21ai_1
XFILLER_17_35 vddd vssd sg13cmos5l_decap_8
XFILLER_0_2440 vddd vssd sg13cmos5l_decap_8
X_4049_ _4049_/Y _5517_/A _6453_/A vddd vssd sg13cmos5l_nand2_1
XFILLER_25_743 vddd vssd sg13cmos5l_decap_8
XFILLER_12_404 vddd vssd sg13cmos5l_decap_8
XFILLER_32_1004 vddd vssd sg13cmos5l_decap_8
XFILLER_14_2161 vddd vssd sg13cmos5l_decap_8
XFILLER_4_603 vddd vssd sg13cmos5l_decap_4
XFILLER_10_2058 vddd vssd sg13cmos5l_decap_8
XFILLER_3_113 vddd vssd sg13cmos5l_decap_8
XFILLER_4_647 vddd vssd sg13cmos5l_decap_8
XFILLER_27_2555 vddd vssd sg13cmos5l_decap_8
XFILLER_23_2419 vddd vssd sg13cmos5l_decap_8
XFILLER_0_875 vddd vssd sg13cmos5l_decap_8
XFILLER_7_1959 vddd vssd sg13cmos5l_decap_4
XFILLER_21_2143 vddd vssd sg13cmos5l_decap_8
Xtiedowns\[12\] _5971_/A1 vddd vssd sg13cmos5l_antennanp
XFILLER_28_570 vddd vssd sg13cmos5l_decap_8
XFILLER_21_1486 vddd vssd sg13cmos5l_decap_8
XFILLER_31_713 vddd vssd sg13cmos5l_decap_8
XFILLER_30_212 vddd vssd sg13cmos5l_decap_8
XFILLER_32_2272 vddd vssd sg13cmos5l_decap_8
XFILLER_3_680 vddd vssd sg13cmos5l_decap_8
X_6070_ _6070_/Y _6067_/Y _6068_/Y _6069_/X vddd vssd sg13cmos5l_o21ai_1
X_5021_ _5024_/C _5223_/A _5224_/A _5223_/B vddd vssd sg13cmos5l_nor3_1
Xhold1119 _6770_/A0 _7077_/Q vddd vssd sg13cmos5l_dlygate4sd3_1
Xhold1108 _6618_/A0 _7267_/Q vddd vssd sg13cmos5l_dlygate4sd3_1
XFILLER_6_1425 vddd vssd sg13cmos5l_decap_8
XFILLER_22_1217 vddd vssd sg13cmos5l_decap_8
X_6972_ _6972_/Q _7348_/CLK _6972_/D _6919_/Y vddd vssd sg13cmos5l_dfrbpq_1
X_5923_ _5923_/Y _5927_/A _5926_/C vddd vssd sg13cmos5l_nand2b_1
XFILLER_0_1068 vddd vssd sg13cmos5l_decap_4
X_5854_ _5875_/C _5863_/A _7227_/Q vddd vssd sg13cmos5l_nor2_1
X_4805_ _4808_/B _4805_/A _4805_/B vddd vssd sg13cmos5l_nor2_1
X_5785_ _5786_/C _5783_/X _5784_/X _5791_/C vddd vssd sg13cmos5l_a21oi_1
X_4736_ _4736_/X _4713_/B _4737_/B _4736_/B1 vddd vssd sg13cmos5l_a21o_1
X_4667_ _4668_/B _4620_/B _3600_/Y _4666_/Y vddd vssd sg13cmos5l_a21oi_1
Xhold920 _7281_/D _6639_/X vddd vssd sg13cmos5l_dlygate4sd3_1
X_3618_ _3618_/Y mask_rev_in[10] vddd vssd sg13cmos5l_inv_1
Xhold931 _6569_/A _7238_/Q vddd vssd sg13cmos5l_dlygate4sd3_1
X_7386_ _7386_/Q _7386_/CLK _7386_/D _6900_/Y vddd vssd sg13cmos5l_dfrbpq_1
X_6406_ _7151_/D hold936/X _6408_/B _6405_/Y vddd vssd sg13cmos5l_a21oi_1
X_6337_ _7115_/D hold992/X _6338_/B _6336_/Y vddd vssd sg13cmos5l_o21ai_1
Xhold942 _6697_/A _7029_/Q vddd vssd sg13cmos5l_dlygate4sd3_1
X_4598_ _4598_/Y _4616_/A _4698_/B vddd vssd sg13cmos5l_nor2_1
Xhold964 _6523_/A _7214_/Q vddd vssd sg13cmos5l_dlygate4sd3_1
XFILLER_11_1677 vddd vssd sg13cmos5l_decap_8
Xhold953 hold953/X _6439_/Y vddd vssd sg13cmos5l_dlygate4sd3_1
XFILLER_27_1106 vddd vssd sg13cmos5l_decap_8
Xhold986 _3605_/A _7116_/Q vddd vssd sg13cmos5l_dlygate4sd3_1
XFILLER_0_127 vddd vssd sg13cmos5l_decap_8
X_3549_ _5348_/C _3549_/A vddd vssd sg13cmos5l_inv_1
Xhold975 hold975/X _6610_/Y vddd vssd sg13cmos5l_dlygate4sd3_1
Xhold997 _4406_/B _4405_/Y vddd vssd sg13cmos5l_dlygate4sd3_1
X_6268_ _6268_/Y _6268_/A _6268_/B vddd vssd sg13cmos5l_nor2_1
XFILLER_29_301 vddd vssd sg13cmos5l_decap_8
XFILLER_28_23 vddd vssd sg13cmos5l_decap_8
X_5219_ _6188_/D _5219_/A _5256_/B vddd vssd sg13cmos5l_nor2_1
X_6199_ _6201_/A _6199_/A _6199_/B vddd vssd sg13cmos5l_nor2_1
XFILLER_22_2485 vddd vssd sg13cmos5l_decap_8
XFILLER_2_2557 vddd vssd sg13cmos5l_decap_8
XFILLER_2_1867 vddd vssd sg13cmos5l_decap_8
XFILLER_25_562 vddd vssd sg13cmos5l_decap_8
XFILLER_9_706 vddd vssd sg13cmos5l_decap_8
XFILLER_16_1566 vddd vssd sg13cmos5l_decap_8
XFILLER_16_1599 vddd vssd sg13cmos5l_decap_8
XFILLER_4_477 vddd vssd sg13cmos5l_decap_8
XFILLER_5_49 vddd vssd sg13cmos5l_decap_8
XFILLER_10_1176 vddd vssd sg13cmos5l_decap_8
XFILLER_23_2216 vddd vssd sg13cmos5l_decap_4
XFILLER_23_2238 vddd vssd sg13cmos5l_decap_4
XFILLER_23_1526 vddd vssd sg13cmos5l_decap_8
XFILLER_5_2192 vddd vssd sg13cmos5l_decap_8
XFILLER_1_1366 vddd vssd sg13cmos5l_decap_8
X_5570_ _5570_/Y _6121_/A _5583_/B _5586_/B vddd vssd sg13cmos5l_a21oi_1
X_4521_ _4522_/C _4792_/A _4521_/B vddd vssd sg13cmos5l_nor2_1
X_4452_ _4452_/X _4524_/A _4524_/B vddd vssd sg13cmos5l_or2_1
X_7240_ _7240_/Q _7296_/CLK _7240_/D fanout373/X vddd vssd sg13cmos5l_dfrbpq_1
X_4383_ _4393_/C _5659_/A _7133_/Q vddd vssd sg13cmos5l_xor2_1
X_7171_ _7171_/Q _7171_/CLK _7171_/D fanout359/X vddd vssd sg13cmos5l_dfrbpq_1
X_6122_ _6122_/Y _5457_/A _6122_/A2 _6121_/Y vddd vssd sg13cmos5l_a21oi_1
XFILLER_6_1211 vddd vssd sg13cmos5l_decap_8
X_6053_ _6053_/Y _7292_/Q _6051_/Y _6052_/Y vddd vssd sg13cmos5l_o21ai_1
Xoutbuffers\[43\] bandgap_trim[4] _6289_/X vddd vssd sg13cmos5l_buf_16
X_5004_ _5011_/B _5125_/A _5076_/C vddd vssd sg13cmos5l_nand2_1
XFILLER_22_1036 vddd vssd sg13cmos5l_decap_8
X_6955_ _6955_/Y _6956_/A _6956_/B_N vddd vssd sg13cmos5l_nor2b_1
X_5906_ _5906_/Y _6238_/A1 _5901_/Y _5905_/Y vddd vssd sg13cmos5l_a21oi_1
XFILLER_22_543 vddd vssd sg13cmos5l_decap_8
X_6886_ _6886_/Y _6898_/A _6916_/B_N vddd vssd sg13cmos5l_nor2b_1
XFILLER_14_14 vddd vssd sg13cmos5l_decap_8
XFILLER_17_2576 vddd vssd sg13cmos5l_decap_8
XFILLER_13_2429 vddd vssd sg13cmos5l_decap_8
X_5837_ _5837_/X _6225_/A _5837_/B vddd vssd sg13cmos5l_or2_1
X_5768_ _5768_/Y _7214_/Q _7215_/Q _5794_/A _5791_/B vddd vssd sg13cmos5l_nor4_1
XFILLER_13_1739 vddd vssd sg13cmos5l_decap_8
X_4719_ _4719_/Y _4507_/X _4715_/Y _4718_/Y vddd vssd sg13cmos5l_a21oi_1
XFILLER_11_2142 vddd vssd sg13cmos5l_decap_8
X_5699_ _5699_/Y _7202_/Q _7203_/Q _5699_/C vddd vssd sg13cmos5l_nor3_1
XFILLER_11_1441 vddd vssd sg13cmos5l_decap_8
XFILLER_30_79 vddd vssd sg13cmos5l_decap_8
Xhold750 _6975_/D _5937_/Y vddd vssd sg13cmos5l_dlygate4sd3_1
Xhold761 _4349_/A _4347_/Y vddd vssd sg13cmos5l_dlygate4sd3_1
X_7369_ _7369_/Q _7380_/CLK _7369_/D _6883_/Y vddd vssd sg13cmos5l_dfrbpq_1
Xhold772 hold772/X _3532_/Y vddd vssd sg13cmos5l_dlygate4sd3_1
XFILLER_11_1496 vddd vssd sg13cmos5l_decap_8
Xhold794 _4653_/A _7341_/Q vddd vssd sg13cmos5l_dlygate4sd3_1
Xhold783 _6403_/A _7150_/Q vddd vssd sg13cmos5l_dlygate4sd3_1
XFILLER_24_2558 vddd vssd sg13cmos5l_decap_8
Xhold1461 _7347_/D _4494_/X vddd vssd sg13cmos5l_dlygate4sd3_1
Xhold1450 hold1450/X _7386_/Q vddd vssd sg13cmos5l_dlygate4sd3_1
Xhold1494 hold499/A _7015_/Q vddd vssd sg13cmos5l_dlygate4sd3_1
XFILLER_29_175 vddd vssd sg13cmos5l_decap_8
Xhold1483 _6772_/A1 _6285_/A vddd vssd sg13cmos5l_dlygate4sd3_1
Xhold1472 _7052_/D _6730_/X vddd vssd sg13cmos5l_dlygate4sd3_1
XFILLER_2_1664 vddd vssd sg13cmos5l_decap_8
XFILLER_18_1639 vddd vssd sg13cmos5l_decap_8
XFILLER_31_1828 vddd vssd sg13cmos5l_decap_4
XFILLER_29_2436 vddd vssd sg13cmos5l_decap_8
XFILLER_23_1312 vddd vssd sg13cmos5l_decap_8
X_6740_ _6740_/Y _6740_/A _6745_/S vddd vssd sg13cmos5l_nor2_1
Xclkbuf_3_4_0_SCK_regs clkload6/A clkbuf_0_SCK_regs/X vddd vssd sg13cmos5l_buf_8
X_3952_ _6445_/A _3984_/A _3966_/B vddd vssd sg13cmos5l_and2_1
XFILLER_32_885 vddd vssd sg13cmos5l_decap_8
X_6671_ _6671_/X _6671_/A0 _6581_/A _6671_/S vddd vssd sg13cmos5l_mux2_1
XFILLER_17_1116 vddd vssd sg13cmos5l_decap_8
X_3883_ _3884_/C _5209_/B wire90/X wire89/X _7273_/Q vddd vssd sg13cmos5l_a22oi_1
X_5622_ _5644_/C _5633_/B _5629_/A vddd vssd sg13cmos5l_nand2_1
X_5553_ _5555_/B _7182_/Q _7183_/Q _5553_/C vddd vssd sg13cmos5l_nor3_1
XFILLER_12_2451 vddd vssd sg13cmos5l_decap_8
X_4504_ _4504_/Y _4536_/A _4533_/B vddd vssd sg13cmos5l_nor2_1
X_5484_ _5488_/B _5484_/A _7174_/Q _5498_/B vddd vssd sg13cmos5l_nor3_1
X_7223_ _7223_/Q _7229_/CLK _7223_/D fanout368/X vddd vssd sg13cmos5l_dfrbpq_1
XFILLER_8_2018 vddd vssd sg13cmos5l_decap_4
X_4435_ _4437_/A _4433_/Y _4434_/Y _4421_/B vddd vssd sg13cmos5l_a21oi_1
Xwire6 wire6/X wire6/A vddd vssd sg13cmos5l_buf_4
X_4366_ _4366_/Y _4412_/A _3532_/Y _3533_/Y _4414_/A _4365_/Y vddd vssd sg13cmos5l_a221oi_1
X_7154_ _7154_/Q _7171_/CLK _7154_/D fanout356/X vddd vssd sg13cmos5l_dfrbpq_1
XFILLER_28_1256 vddd vssd sg13cmos5l_decap_4
X_6105_ _6105_/Y _6103_/Y _6105_/B vddd vssd sg13cmos5l_nand2b_1
X_7085_ _7085_/Q _7135_/CLK _7085_/D _6962_/B_N vddd vssd sg13cmos5l_dfrbpq_1
X_4297_ _4297_/Y _4297_/A _4297_/B vddd vssd sg13cmos5l_nor2_1
XFILLER_23_2580 vddd vssd sg13cmos5l_decap_8
X_6036_ _6036_/Y _6032_/Y _6034_/Y _6035_/Y vddd vssd sg13cmos5l_a21oi_1
XFILLER_27_635 vddd vssd sg13cmos5l_decap_8
XFILLER_26_167 vddd vssd sg13cmos5l_decap_8
XFILLER_19_1904 vddd vssd sg13cmos5l_decap_8
X_6938_ _6938_/Y _6959_/A _6958_/B_N vddd vssd sg13cmos5l_nor2b_1
XFILLER_25_79 vddd vssd sg13cmos5l_decap_8
X_6869_ _6869_/Y _6870_/A _6870_/B_N vddd vssd sg13cmos5l_nor2b_1
XFILLER_10_502 vddd vssd sg13cmos5l_decap_4
XFILLER_13_2215 vddd vssd sg13cmos5l_decap_8
XFILLER_10_513 vddd vssd sg13cmos5l_decap_8
XFILLER_13_1536 vddd vssd sg13cmos5l_decap_8
XFILLER_13_1514 vddd vssd sg13cmos5l_decap_8
XFILLER_6_528 vddd vssd sg13cmos5l_decap_4
XFILLER_30_2595 vddd vssd sg13cmos5l_decap_8
XFILLER_11_1260 vddd vssd sg13cmos5l_decap_8
Xclkbuf_leaf_8_SCK_regs _7146_/CLK clkload4/A vddd vssd sg13cmos5l_buf_8
Xhold580 _6807_/A _7005_/Q vddd vssd sg13cmos5l_dlygate4sd3_1
XFILLER_26_1919 vddd vssd sg13cmos5l_decap_8
XFILLER_24_2333 vddd vssd sg13cmos5l_decap_8
Xhold591 hold591/X _4314_/Y vddd vssd sg13cmos5l_dlygate4sd3_1
XFILLER_2_28 vddd vssd sg13cmos5l_decap_8
XFILLER_4_2427 vddd vssd sg13cmos5l_decap_8
XFILLER_8_2585 vddd vssd sg13cmos5l_decap_8
XFILLER_4_1704 vddd vssd sg13cmos5l_decap_8
XFILLER_24_1698 vddd vssd sg13cmos5l_decap_4
XFILLER_17_112 vddd vssd sg13cmos5l_decap_8
Xhold1280 _3557_/A _7174_/Q vddd vssd sg13cmos5l_dlygate4sd3_1
Xhold1291 hold1291/X _7303_/Q vddd vssd sg13cmos5l_dlygate4sd3_1
XFILLER_18_2104 vddd vssd sg13cmos5l_decap_8
XFILLER_32_126 vddd vssd sg13cmos5l_decap_8
XFILLER_18_1436 vddd vssd sg13cmos5l_decap_8
XFILLER_14_885 vddd vssd sg13cmos5l_decap_8
X_4220_ _4222_/A _7198_/Q _6490_/A _6475_/A vddd vssd sg13cmos5l_a21oi_1
XFILLER_9_2349 vddd vssd sg13cmos5l_decap_8
X_4151_ _4153_/B _7068_/Q _6753_/A vddd vssd sg13cmos5l_nand2_1
X_4082_ _4082_/Y _4080_/Y _4081_/Y _3679_/Y vddd vssd sg13cmos5l_o21ai_1
XFILLER_7_1350 vddd vssd sg13cmos5l_decap_8
XFILLER_7_1372 vddd vssd sg13cmos5l_decap_8
XFILLER_23_1164 vddd vssd sg13cmos5l_decap_8
XFILLER_3_1247 vddd vssd sg13cmos5l_decap_8
XFILLER_23_126 vddd vssd sg13cmos5l_decap_8
XFILLER_17_690 vddd vssd sg13cmos5l_decap_4
X_4984_ _4986_/A _7242_/Q _7243_/Q vddd vssd sg13cmos5l_nor2_1
X_6723_ _6723_/Y _6723_/A1 _6725_/S _6722_/Y vddd vssd sg13cmos5l_o21ai_1
XFILLER_20_800 vddd vssd sg13cmos5l_decap_4
X_3935_ _3935_/Y _5713_/B _3929_/Y _6498_/A vddd vssd sg13cmos5l_a21oi_1
XFILLER_31_170 vddd vssd sg13cmos5l_decap_8
X_6654_ _6654_/Y _6654_/A _6663_/S vddd vssd sg13cmos5l_nor2_1
XFILLER_18_1970 vddd vssd sg13cmos5l_decap_8
X_5605_ _5609_/B _5617_/C _5610_/C vddd vssd sg13cmos5l_nor2_1
X_3866_ _6646_/A _3876_/A _3940_/A _3878_/C _3876_/D vddd vssd sg13cmos5l_nor4_1
XFILLER_14_2568 vddd vssd sg13cmos5l_decap_8
X_3797_ _3797_/X dbus_in_left[5] dbus_in_right[5] vddd vssd sg13cmos5l_or2_1
X_6585_ _7246_/D _6704_/A1 _6589_/S _6584_/Y vddd vssd sg13cmos5l_a21oi_1
X_5536_ _5538_/A _5566_/A _7182_/Q _7183_/Q vddd vssd sg13cmos5l_nor3_1
X_5467_ _5467_/Y _5467_/A _5467_/B _5467_/C vddd vssd sg13cmos5l_nor3_1
X_4418_ _4418_/Y _5926_/A _7349_/Q _4400_/B vddd vssd sg13cmos5l_a21oi_1
X_7206_ _7206_/Q _7231_/CLK _7206_/D fanout362/X vddd vssd sg13cmos5l_dfrbpq_1
Xfanout312 _4169_/A _4501_/B vddd vssd sg13cmos5l_buf_1
Xfanout301 _5442_/A hold1429/X vddd vssd sg13cmos5l_buf_1
X_5398_ _5417_/A _5416_/B _5398_/B vddd vssd sg13cmos5l_and2_1
Xfanout323 _5795_/A1 _3545_/Y vddd vssd sg13cmos5l_buf_1
Xfanout334 _6704_/A1 _6667_/A1 vddd vssd sg13cmos5l_buf_1
Xfanout345 _6835_/B_N fanout347/X vddd vssd sg13cmos5l_buf_1
Xfanout356 fanout356/X fanout358/X vddd vssd sg13cmos5l_buf_1
X_4349_ _4349_/Y _4349_/A _4349_/B vddd vssd sg13cmos5l_nor2_1
X_7137_ _7137_/Q _7171_/CLK _7137_/D _6914_/B_N vddd vssd sg13cmos5l_dfrbpq_1
Xfanout367 fanout367/X fanout372/X vddd vssd sg13cmos5l_buf_1
Xfanout378 fanout378/X fanout379/X vddd vssd sg13cmos5l_buf_1
X_7068_ _7068_/Q _7071_/CLK _7068_/D fanout351/X vddd vssd sg13cmos5l_dfrbpq_1
XFILLER_21_2528 vddd vssd sg13cmos5l_decap_8
Xfanout389 fanout389/X fanout409/X vddd vssd sg13cmos5l_buf_1
X_6019_ _6019_/Y _6267_/A1 _5024_/B _6017_/Y _6018_/Y vddd vssd sg13cmos5l_a22oi_1
XFILLER_28_944 vddd vssd sg13cmos5l_decap_8
XFILLER_25_1974 vddd vssd sg13cmos5l_decap_4
XFILLER_21_1827 vddd vssd sg13cmos5l_decap_8
XFILLER_19_2457 vddd vssd sg13cmos5l_decap_8
XFILLER_23_660 vddd vssd sg13cmos5l_decap_8
XFILLER_19_1756 vddd vssd sg13cmos5l_decap_8
XFILLER_17_2170 vddd vssd sg13cmos5l_decap_8
XFILLER_15_1609 vddd vssd sg13cmos5l_decap_8
XFILLER_32_1923 vddd vssd sg13cmos5l_decap_8
XFILLER_7_815 vddd vssd sg13cmos5l_decap_4
XFILLER_7_826 vddd vssd sg13cmos5l_decap_8
XFILLER_30_2392 vddd vssd sg13cmos5l_decap_8
XFILLER_10_387 vddd vssd sg13cmos5l_decap_8
XFILLER_7_0 vddd vssd sg13cmos5l_decap_8
Xtiedowns\[42\] dbus_in_right[10] vddd vssd sg13cmos5l_antennanp
XFILLER_24_2130 vddd vssd sg13cmos5l_decap_8
XFILLER_4_2213 vddd vssd sg13cmos5l_decap_8
XFILLER_24_2174 vddd vssd sg13cmos5l_decap_8
XFILLER_4_1501 vddd vssd sg13cmos5l_decap_8
XFILLER_4_2224 vddd vssd sg13cmos5l_decap_4
XFILLER_24_1451 vddd vssd sg13cmos5l_decap_8
XFILLER_4_1545 vddd vssd sg13cmos5l_decap_8
XFILLER_24_1495 vddd vssd sg13cmos5l_decap_8
XFILLER_19_955 vddd vssd sg13cmos5l_decap_4
XFILLER_18_432 vddd vssd sg13cmos5l_decap_4
XFILLER_4_1589 vddd vssd sg13cmos5l_decap_8
X_3720_ _3842_/B _3846_/A _3961_/A vddd vssd sg13cmos5l_nor2_1
XFILLER_18_1266 vddd vssd sg13cmos5l_decap_8
XFILLER_9_141 vddd vssd sg13cmos5l_decap_4
X_3651_ _3652_/D _7323_/Q _5933_/A _5930_/A _5939_/A vddd vssd sg13cmos5l_nor4_1
X_6370_ _6370_/X hold833/X _6661_/A _6372_/S vddd vssd sg13cmos5l_mux2_1
XFILLER_13_2590 vddd vssd sg13cmos5l_decap_8
X_3582_ _5806_/B _3582_/A vddd vssd sg13cmos5l_inv_1
X_5321_ _5321_/Y _5321_/A _5321_/B vddd vssd sg13cmos5l_nand2_1
X_5252_ _5253_/D _5271_/A _5252_/B _5252_/C vddd vssd sg13cmos5l_nand3_1
X_5183_ _5185_/C _5183_/A _6156_/B _5183_/C vddd vssd sg13cmos5l_nand3_1
X_4203_ _4203_/Y _5065_/A _6576_/A _4115_/A vddd vssd sg13cmos5l_a21oi_1
X_4134_ _4134_/X _7191_/Q _6475_/A vddd vssd sg13cmos5l_and2_1
XFILLER_28_207 vddd vssd sg13cmos5l_decap_8
X_4065_ _4065_/Y _3620_/Y _3831_/X _4063_/Y _4064_/Y vddd vssd sg13cmos5l_a22oi_1
Xwire11 wire11/X wire11/A vddd vssd sg13cmos5l_buf_4
Xwire22 wire22/X wire23/X vddd vssd sg13cmos5l_buf_4
XFILLER_19_1008 vddd vssd sg13cmos5l_decap_8
Xwire88 wire88/X wire88/A vddd vssd sg13cmos5l_buf_2
X_4967_ _7303_/D _6713_/A1 _4968_/B _4967_/B1 vddd vssd sg13cmos5l_a21oi_1
X_6706_ _6706_/X _6706_/A0 _6550_/A _6706_/S vddd vssd sg13cmos5l_mux2_1
XFILLER_22_14 vddd vssd sg13cmos5l_decap_8
X_4898_ _4898_/Y _4874_/B _4889_/B _4891_/C _4897_/Y _4890_/B vddd vssd sg13cmos5l_a221oi_1
X_3918_ _3918_/Y _3912_/Y _3915_/Y _3917_/Y vddd vssd sg13cmos5l_o21ai_1
X_6637_ _6637_/Y _6637_/A1 _6639_/S _6636_/Y vddd vssd sg13cmos5l_o21ai_1
X_3849_ _3849_/Y _7108_/Q _6312_/A _3848_/Y vddd vssd sg13cmos5l_o21ai_1
X_6568_ _6574_/B _6568_/A _6726_/B vddd vssd sg13cmos5l_nand2_1
X_5519_ _5519_/Y _5627_/A _7180_/Q _5518_/Y vddd vssd sg13cmos5l_o21ai_1
X_6499_ _6499_/Y _6499_/A _6505_/S vddd vssd sg13cmos5l_nand2_1
XFILLER_0_7 vddd vssd sg13cmos5l_decap_8
Xfanout120 _6545_/B fanout122/X vddd vssd sg13cmos5l_buf_1
Xfanout131 _4536_/A _4428_/Y vddd vssd sg13cmos5l_buf_1
XFILLER_25_2461 vddd vssd sg13cmos5l_decap_8
XFILLER_21_2314 vddd vssd sg13cmos5l_decap_8
Xfanout142 _3878_/A _3665_/X vddd vssd sg13cmos5l_buf_1
Xfanout153 _4488_/A _4487_/Y vddd vssd sg13cmos5l_buf_1
Xfanout164 _3672_/S _3674_/S vddd vssd sg13cmos5l_buf_1
XFILLER_5_2533 vddd vssd sg13cmos5l_decap_8
XFILLER_19_229 vddd vssd sg13cmos5l_decap_8
Xfanout197 _6317_/A fanout198/X vddd vssd sg13cmos5l_buf_1
Xfanout186 _6336_/A _6796_/A vddd vssd sg13cmos5l_buf_1
Xfanout175 _6777_/A hold1478/X vddd vssd sg13cmos5l_buf_1
XFILLER_27_295 vddd vssd sg13cmos5l_decap_8
XFILLER_32_2432 vddd vssd sg13cmos5l_decap_8
XFILLER_8_49 vddd vssd sg13cmos5l_decap_8
XFILLER_32_1775 vddd vssd sg13cmos5l_decap_8
XFILLER_13_1163 vddd vssd sg13cmos5l_decap_8
XFILLER_8_2190 vddd vssd sg13cmos5l_decap_8
XFILLER_4_2043 vddd vssd sg13cmos5l_decap_4
X_5870_ _5870_/Y _6230_/A _5868_/Y _5869_/Y _5867_/Y vddd vssd sg13cmos5l_a22oi_1
X_4821_ _4821_/Y _4821_/A _4821_/B vddd vssd sg13cmos5l_nand2_1
XFILLER_18_1041 vddd vssd sg13cmos5l_decap_8
X_4752_ _4752_/Y _4685_/A _4751_/Y _4752_/B1 vddd vssd sg13cmos5l_o21ai_1
XFILLER_30_983 vddd vssd sg13cmos5l_decap_8
X_3703_ _4057_/B _3727_/B _3835_/B vddd vssd sg13cmos5l_nand2_1
X_4683_ _4684_/B _4771_/A1 _3600_/Y _4771_/B1 _4678_/B vddd vssd sg13cmos5l_a22oi_1
X_6422_ _7160_/D _6472_/A _6422_/A1 _6423_/S vddd vssd sg13cmos5l_mux2_1
X_3634_ _4315_/B _4305_/A _4293_/C _4287_/B vddd vssd sg13cmos5l_and3_1
XFILLER_11_2549 vddd vssd sg13cmos5l_decap_8
XFILLER_11_1837 vddd vssd sg13cmos5l_decap_4
X_3565_ _3565_/Y _5583_/B vddd vssd sg13cmos5l_inv_1
X_6353_ _6353_/Y _6353_/A _6359_/B vddd vssd sg13cmos5l_nand2_1
X_6284_ _6284_/Y _6285_/B _6287_/A vddd vssd sg13cmos5l_nand2_1
X_5304_ _5304_/Y _5304_/A _5303_/D vddd vssd sg13cmos5l_nor2b_1
X_3496_ _4524_/A _5659_/A vddd vssd sg13cmos5l_inv_1
Xoutbuffers\[73\] io_oe[0] _5013_/Y vddd vssd sg13cmos5l_buf_16
X_5235_ _5236_/D _6188_/B _6188_/C _5218_/X vddd vssd sg13cmos5l_o21ai_1
XFILLER_9_1231 vddd vssd sg13cmos5l_decap_8
XFILLER_29_1170 vddd vssd sg13cmos5l_decap_8
XFILLER_5_1106 vddd vssd sg13cmos5l_decap_8
X_5166_ _5168_/C _5246_/A _5166_/B vddd vssd sg13cmos5l_nor2_1
X_5097_ _5262_/A _7278_/Q _7279_/Q vddd vssd sg13cmos5l_nand2_1
X_4117_ _6049_/A dbus_in_left[1] dbus_in_right[1] vddd vssd sg13cmos5l_or2_1
XFILLER_17_14 vddd vssd sg13cmos5l_decap_8
X_4048_ _4048_/Y _4045_/Y _4046_/Y _4047_/Y vddd vssd sg13cmos5l_o21ai_1
Xclkbuf_leaf_22_SCK_regs _7135_/CLK clkload7/A vddd vssd sg13cmos5l_buf_8
XFILLER_24_210 vddd vssd sg13cmos5l_decap_8
XFILLER_0_1740 vddd vssd sg13cmos5l_decap_8
XFILLER_0_2496 vddd vssd sg13cmos5l_decap_8
XFILLER_0_1773 vddd vssd sg13cmos5l_decap_4
XFILLER_13_917 vddd vssd sg13cmos5l_decap_8
X_5999_ _5999_/Y _5125_/A _5076_/C _5008_/D _6088_/A _5998_/Y vddd vssd sg13cmos5l_a221oi_1
XFILLER_16_2449 vddd vssd sg13cmos5l_decap_8
XFILLER_16_1726 vddd vssd sg13cmos5l_decap_8
XFILLER_21_994 vddd vssd sg13cmos5l_decap_8
XFILLER_27_2534 vddd vssd sg13cmos5l_decap_8
XFILLER_27_1833 vddd vssd sg13cmos5l_decap_8
XFILLER_27_1800 vddd vssd sg13cmos5l_decap_8
XFILLER_0_854 vddd vssd sg13cmos5l_decap_8
XFILLER_7_1938 vddd vssd sg13cmos5l_decap_8
XFILLER_23_1719 vddd vssd sg13cmos5l_decap_8
XFILLER_21_2122 vddd vssd sg13cmos5l_decap_8
XFILLER_5_1673 vddd vssd sg13cmos5l_decap_8
XFILLER_16_744 vddd vssd sg13cmos5l_decap_8
XFILLER_16_788 vddd vssd sg13cmos5l_decap_8
XFILLER_19_2095 vddd vssd sg13cmos5l_decap_8
XFILLER_32_2240 vddd vssd sg13cmos5l_decap_8
XFILLER_8_932 vddd vssd sg13cmos5l_decap_8
XFILLER_10_2582 vddd vssd sg13cmos5l_decap_8
X_5020_ _5223_/B _7278_/Q _5020_/B vddd vssd sg13cmos5l_nand2_1
Xhold1109 _7267_/D _6618_/X vddd vssd sg13cmos5l_dlygate4sd3_1
XFILLER_6_1437 vddd vssd sg13cmos5l_decap_4
XFILLER_4_1150 vddd vssd sg13cmos5l_decap_8
X_6971_ _6971_/Q _7348_/CLK _6971_/D _6918_/Y vddd vssd sg13cmos5l_dfrbpq_1
X_5922_ _5926_/C _3527_/A _3593_/Y _5920_/Y _5921_/Y vddd vssd sg13cmos5l_a22oi_1
XFILLER_0_1047 vddd vssd sg13cmos5l_decap_8
XFILLER_21_202 vddd vssd sg13cmos5l_decap_8
X_5853_ _5877_/S _7226_/Q _7227_/Q _7228_/Q _7229_/Q vddd vssd sg13cmos5l_nor4_1
X_5784_ _5784_/X _5784_/A _5794_/A vddd vssd sg13cmos5l_or2_1
X_4804_ _4805_/B _4799_/Y _4802_/Y _4804_/B1 vddd vssd sg13cmos5l_o21ai_1
X_4735_ _4737_/B _4465_/B _4743_/A vddd vssd sg13cmos5l_nand2b_1
XFILLER_15_2493 vddd vssd sg13cmos5l_decap_8
X_4666_ _4666_/Y _4670_/B _4762_/B vddd vssd sg13cmos5l_nor2_1
X_4597_ _4597_/Y _4597_/A vddd vssd sg13cmos5l_inv_1
X_6405_ _6405_/Y _6405_/A _6408_/B vddd vssd sg13cmos5l_nor2_1
Xhold921 _4287_/B hold921/A vddd vssd sg13cmos5l_dlygate4sd3_1
X_7385_ _7385_/Q _7403_/CLK _7385_/D _6899_/Y vddd vssd sg13cmos5l_dfrbpq_1
XFILLER_11_1645 vddd vssd sg13cmos5l_decap_8
Xhold910 hold910/X _3505_/Y vddd vssd sg13cmos5l_dlygate4sd3_1
X_3617_ _5968_/B _3617_/A vddd vssd sg13cmos5l_inv_1
X_6336_ _6336_/Y _6336_/A _6338_/B vddd vssd sg13cmos5l_nand2_1
Xhold954 _6491_/A _7198_/Q vddd vssd sg13cmos5l_dlygate4sd3_1
Xhold943 hold943/X _6697_/Y vddd vssd sg13cmos5l_dlygate4sd3_1
X_3548_ _5327_/B _3548_/A vddd vssd sg13cmos5l_inv_1
Xhold932 hold932/X _6569_/Y vddd vssd sg13cmos5l_dlygate4sd3_1
Xhold976 _6634_/A _7278_/Q vddd vssd sg13cmos5l_dlygate4sd3_1
Xhold987 hold987/X _3605_/Y vddd vssd sg13cmos5l_dlygate4sd3_1
Xhold965 hold965/X _6523_/Y vddd vssd sg13cmos5l_dlygate4sd3_1
XFILLER_1_618 vddd vssd sg13cmos5l_decap_4
Xhold998 _7356_/D _4406_/Y vddd vssd sg13cmos5l_dlygate4sd3_1
X_3479_ _3479_/Y _4540_/B vddd vssd sg13cmos5l_inv_1
X_6267_ _6268_/B _6267_/A1 _5260_/B _6266_/Y vddd vssd sg13cmos5l_a21oi_1
X_5218_ _5218_/X _5218_/A _5265_/B vddd vssd sg13cmos5l_or2_1
X_6198_ _6199_/B _6156_/A _5237_/C _5221_/A vddd vssd sg13cmos5l_o21ai_1
XFILLER_2_2503 vddd vssd sg13cmos5l_decap_8
XFILLER_9_1050 vddd vssd sg13cmos5l_decap_4
XFILLER_22_2464 vddd vssd sg13cmos5l_decap_8
X_5149_ _5152_/B _5149_/A _5149_/B _5149_/C _5149_/D vddd vssd sg13cmos5l_nor4_1
XFILLER_29_357 vddd vssd sg13cmos5l_decap_8
XFILLER_2_1813 vddd vssd sg13cmos5l_decap_8
XFILLER_22_1785 vddd vssd sg13cmos5l_decap_4
XFILLER_0_1581 vddd vssd sg13cmos5l_decap_8
XFILLER_16_2235 vddd vssd sg13cmos5l_decap_8
XFILLER_12_213 vddd vssd sg13cmos5l_decap_8
XFILLER_13_747 vddd vssd sg13cmos5l_decap_8
XFILLER_16_1545 vddd vssd sg13cmos5l_decap_8
XFILLER_5_28 vddd vssd sg13cmos5l_decap_8
XFILLER_10_1111 vddd vssd sg13cmos5l_decap_8
XFILLER_4_456 vddd vssd sg13cmos5l_decap_8
XFILLER_10_1144 vddd vssd sg13cmos5l_decap_8
XFILLER_0_651 vddd vssd sg13cmos5l_decap_4
XFILLER_0_684 vddd vssd sg13cmos5l_decap_8
XFILLER_31_555 vddd vssd sg13cmos5l_decap_4
XFILLER_31_588 vddd vssd sg13cmos5l_decap_8
X_4520_ _4521_/B _4566_/A1 _3607_/Y _4488_/A _4515_/B vddd vssd sg13cmos5l_a22oi_1
XFILLER_32_1380 vddd vssd sg13cmos5l_decap_8
X_4451_ _4511_/C _4524_/A _4524_/B vddd vssd sg13cmos5l_nor2_1
XFILLER_8_784 vddd vssd sg13cmos5l_decap_4
X_7170_ _7170_/Q _7171_/CLK _7170_/D fanout359/X vddd vssd sg13cmos5l_dfrbpq_1
X_4382_ _4394_/A _4382_/A _7131_/Q vddd vssd sg13cmos5l_xnor2_1
X_6121_ _6121_/Y _6121_/A _6121_/B vddd vssd sg13cmos5l_nor2_1
XFILLER_22_0 vddd vssd sg13cmos5l_decap_8
X_6052_ _6052_/Y _7292_/Q _3585_/Y _5193_/B vddd vssd sg13cmos5l_a21oi_1
XFILLER_22_1015 vddd vssd sg13cmos5l_decap_8
X_5003_ _5076_/C _7264_/Q _7265_/Q vddd vssd sg13cmos5l_nor2_1
Xoutbuffers\[36\] biasgen_fine _7060_/Q vddd vssd sg13cmos5l_buf_16
X_6954_ _6954_/Y _6954_/A _6954_/B_N vddd vssd sg13cmos5l_nor2b_1
X_5905_ _5905_/Y _5905_/A _5905_/B _5905_/C vddd vssd sg13cmos5l_nor3_1
XFILLER_22_533 vddd vssd sg13cmos5l_decap_4
XFILLER_17_2555 vddd vssd sg13cmos5l_decap_8
X_6885_ _6885_/Y _6898_/A _6916_/B_N vddd vssd sg13cmos5l_nor2b_1
XFILLER_13_2408 vddd vssd sg13cmos5l_decap_8
X_5836_ _5836_/X _6224_/A _7225_/Q vddd vssd sg13cmos5l_or2_1
XFILLER_13_1718 vddd vssd sg13cmos5l_decap_8
XFILLER_10_739 vddd vssd sg13cmos5l_decap_8
X_5767_ _5767_/Y _5797_/A1 _5740_/X _5766_/Y vddd vssd sg13cmos5l_a21oi_1
X_5698_ _5698_/Y _5690_/Y _5697_/Y _5695_/Y vddd vssd sg13cmos5l_a21oi_1
XFILLER_5_209 vddd vssd sg13cmos5l_decap_8
X_4718_ _4718_/Y _5457_/A _4716_/Y _4717_/Y vddd vssd sg13cmos5l_a21oi_1
X_4649_ _4650_/B _4628_/B _4651_/B _4736_/B1 vddd vssd sg13cmos5l_a21oi_1
XFILLER_30_58 vddd vssd sg13cmos5l_decap_8
XFILLER_11_1475 vddd vssd sg13cmos5l_decap_8
Xhold762 _7361_/D _4349_/Y vddd vssd sg13cmos5l_dlygate4sd3_1
Xhold751 _4348_/A _7361_/Q vddd vssd sg13cmos5l_dlygate4sd3_1
Xhold773 _7092_/D _6799_/Y vddd vssd sg13cmos5l_dlygate4sd3_1
X_7368_ _7368_/Q _7404_/CLK _7368_/D _6882_/Y vddd vssd sg13cmos5l_dfrbpq_1
Xhold740 _7095_/D _6804_/Y vddd vssd sg13cmos5l_dlygate4sd3_1
Xhold795 _4640_/B _4639_/Y vddd vssd sg13cmos5l_dlygate4sd3_1
X_7299_ _7299_/Q _7300_/CLK _7299_/D fanout377/X vddd vssd sg13cmos5l_dfrbpq_1
X_6319_ _6319_/Y _6796_/A _6321_/B vddd vssd sg13cmos5l_nand2_1
Xhold784 hold784/X _6403_/Y vddd vssd sg13cmos5l_dlygate4sd3_1
XFILLER_24_2537 vddd vssd sg13cmos5l_decap_8
XFILLER_6_2480 vddd vssd sg13cmos5l_decap_8
XFILLER_29_154 vddd vssd sg13cmos5l_decap_8
Xhold1451 _7386_/D _4274_/X vddd vssd sg13cmos5l_dlygate4sd3_1
Xhold1440 _4787_/A1 _7334_/Q vddd vssd sg13cmos5l_dlygate4sd3_1
Xhold1473 hold1473/X _7343_/Q vddd vssd sg13cmos5l_dlygate4sd3_1
Xhold1462 _6731_/A1 _7053_/Q vddd vssd sg13cmos5l_dlygate4sd3_1
XFILLER_18_828 vddd vssd sg13cmos5l_decap_8
Xhold1495 hold500/A _7008_/Q vddd vssd sg13cmos5l_dlygate4sd3_1
XFILLER_6_1790 vddd vssd sg13cmos5l_decap_8
Xhold1484 _6787_/A0 _7086_/Q vddd vssd sg13cmos5l_dlygate4sd3_1
XFILLER_26_894 vddd vssd sg13cmos5l_decap_8
XFILLER_9_515 vddd vssd sg13cmos5l_decap_4
Xtiedowns\[72\] mask_rev_in[28] vddd vssd sg13cmos5l_antennanp
XFILLER_29_2415 vddd vssd sg13cmos5l_decap_8
XFILLER_20_91 vddd vssd sg13cmos5l_decap_8
XFILLER_27_2183 vddd vssd sg13cmos5l_decap_4
XFILLER_23_2003 vddd vssd sg13cmos5l_decap_8
XFILLER_7_2233 vddd vssd sg13cmos5l_decap_4
XFILLER_23_2058 vddd vssd sg13cmos5l_decap_8
XFILLER_0_481 vddd vssd sg13cmos5l_decap_8
XFILLER_23_319 vddd vssd sg13cmos5l_decap_8
X_3951_ _3951_/Y _5557_/B _3947_/Y _3950_/Y vddd vssd sg13cmos5l_o21ai_1
XFILLER_16_393 vddd vssd sg13cmos5l_decap_8
XFILLER_32_864 vddd vssd sg13cmos5l_decap_8
X_3882_ _3882_/Y _7277_/Q wire88/X vddd vssd sg13cmos5l_nand2b_1
X_6670_ _6670_/X _6670_/A0 _6650_/A _6671_/S vddd vssd sg13cmos5l_mux2_1
X_5621_ _5649_/A _5633_/B _5629_/A _7196_/Q _5647_/B vddd vssd sg13cmos5l_nor4_1
XFILLER_30_1306 vddd vssd sg13cmos5l_decap_8
X_5552_ _5552_/Y _5552_/A _5552_/B _5552_/C vddd vssd sg13cmos5l_nor3_1
X_4503_ _4533_/B _4503_/A _4508_/B vddd vssd sg13cmos5l_nor2b_1
XFILLER_12_1740 vddd vssd sg13cmos5l_decap_8
X_5483_ _5483_/Y _7174_/Q _5498_/B vddd vssd sg13cmos5l_nor2_1
XFILLER_6_60 vddd vssd sg13cmos5l_decap_8
X_7222_ _7222_/Q _7229_/CLK _7222_/D fanout366/X vddd vssd sg13cmos5l_dfrbpq_1
XFILLER_6_82 vddd vssd sg13cmos5l_decap_8
X_4434_ _4434_/Y _4812_/B _4492_/A vddd vssd sg13cmos5l_nor2_1
X_7153_ _7153_/Q _7363_/CLK _7153_/D fanout357/X vddd vssd sg13cmos5l_dfrbpq_1
Xwire7 wire7/X wire7/A vddd vssd sg13cmos5l_buf_4
X_4365_ _4365_/Y _4361_/Y _4362_/Y _4364_/Y vddd vssd sg13cmos5l_a21oi_1
X_6104_ _6105_/B _6146_/A _6103_/D _5149_/B vddd vssd sg13cmos5l_a21oi_1
X_7084_ _7084_/Q _7135_/CLK _7084_/D _6962_/B_N vddd vssd sg13cmos5l_dfrbpq_1
X_6035_ _6035_/Y _6263_/A1 _5068_/A _6037_/B vddd vssd sg13cmos5l_o21ai_1
X_4296_ _4312_/A _4309_/B _4964_/A _4299_/C vddd vssd sg13cmos5l_nand3_1
XFILLER_26_146 vddd vssd sg13cmos5l_decap_8
XFILLER_15_809 vddd vssd sg13cmos5l_decap_4
XFILLER_25_58 vddd vssd sg13cmos5l_decap_8
XFILLER_19_1938 vddd vssd sg13cmos5l_decap_8
X_6937_ _6937_/Y _6956_/A _6957_/B_N vddd vssd sg13cmos5l_nor2b_1
X_6868_ _6868_/Y _6870_/A _6870_/B_N vddd vssd sg13cmos5l_nor2b_1
XFILLER_17_1651 vddd vssd sg13cmos5l_decap_8
X_5819_ _5819_/X _5819_/A _5819_/B vddd vssd sg13cmos5l_and2_1
X_6799_ _6799_/Y hold772/X _6803_/B _6798_/Y vddd vssd sg13cmos5l_o21ai_1
XFILLER_6_507 vddd vssd sg13cmos5l_decap_8
XFILLER_10_547 vddd vssd sg13cmos5l_decap_4
XFILLER_30_2574 vddd vssd sg13cmos5l_decap_8
XFILLER_30_1862 vddd vssd sg13cmos5l_decap_8
Xhold570 hold570/X _3860_/Y vddd vssd sg13cmos5l_dlygate4sd3_1
Xhold581 _7006_/D _6807_/X vddd vssd sg13cmos5l_dlygate4sd3_1
XFILLER_2_768 vddd vssd sg13cmos5l_decap_8
Xhold592 _7368_/D _4316_/Y vddd vssd sg13cmos5l_dlygate4sd3_1
XFILLER_8_2564 vddd vssd sg13cmos5l_decap_8
XFILLER_24_2356 vddd vssd sg13cmos5l_decap_8
XFILLER_24_2389 vddd vssd sg13cmos5l_decap_4
XFILLER_4_1716 vddd vssd sg13cmos5l_decap_8
XFILLER_24_1677 vddd vssd sg13cmos5l_decap_8
Xhold1270 _6421_/A1 _5380_/B vddd vssd sg13cmos5l_dlygate4sd3_1
XFILLER_18_669 vddd vssd sg13cmos5l_decap_8
Xhold1281 _6447_/A1 _5498_/A vddd vssd sg13cmos5l_dlygate4sd3_1
Xhold1292 _4966_/B1 _4920_/A vddd vssd sg13cmos5l_dlygate4sd3_1
XFILLER_32_105 vddd vssd sg13cmos5l_decap_8
XFILLER_14_864 vddd vssd sg13cmos5l_decap_8
XFILLER_9_334 vddd vssd sg13cmos5l_decap_8
XFILLER_9_323 vddd vssd sg13cmos5l_decap_4
XFILLER_9_2317 vddd vssd sg13cmos5l_decap_8
X_4150_ _4153_/A _4147_/Y _4148_/X _4149_/Y vddd vssd sg13cmos5l_o21ai_1
XFILLER_7_2041 vddd vssd sg13cmos5l_decap_8
XFILLER_9_1616 vddd vssd sg13cmos5l_decap_8
XFILLER_7_2063 vddd vssd sg13cmos5l_decap_8
XFILLER_23_1121 vddd vssd sg13cmos5l_decap_4
X_4081_ _4081_/Y mask_rev_in[2] _4081_/B vddd vssd sg13cmos5l_nor2_1
XFILLER_23_105 vddd vssd sg13cmos5l_decap_8
XFILLER_17_680 vddd vssd sg13cmos5l_decap_4
X_4983_ _5008_/A _5130_/A _7247_/Q _7248_/Q _7249_/Q vddd vssd sg13cmos5l_nor4_1
X_6722_ _6722_/Y _6722_/A _6725_/S vddd vssd sg13cmos5l_nand2_1
X_3934_ _3934_/Y _3934_/A _3934_/B vddd vssd sg13cmos5l_nand2_1
XFILLER_32_683 vddd vssd sg13cmos5l_decap_8
X_3865_ _3865_/Y _3876_/A _3874_/C _3940_/B _3876_/D vddd vssd sg13cmos5l_nor4_1
X_6653_ _6664_/S _6653_/A _6726_/B vddd vssd sg13cmos5l_and2_1
X_5604_ _5610_/C _5613_/A _5606_/B vddd vssd sg13cmos5l_nand2_1
XFILLER_14_2547 vddd vssd sg13cmos5l_decap_8
X_3796_ _6154_/A dbus_in_left[5] dbus_in_right[5] vddd vssd sg13cmos5l_nor2_1
XFILLER_14_1868 vddd vssd sg13cmos5l_decap_8
X_6584_ _6584_/Y _6584_/A _6589_/S vddd vssd sg13cmos5l_nor2_1
XFILLER_30_1147 vddd vssd sg13cmos5l_decap_8
X_5535_ _5560_/C _7182_/Q _5544_/B vddd vssd sg13cmos5l_nand2_1
XFILLER_11_49 vddd vssd sg13cmos5l_decap_8
X_5466_ _5467_/C _5464_/X _5465_/X _5472_/C vddd vssd sg13cmos5l_a21oi_1
XFILLER_12_1592 vddd vssd sg13cmos5l_decap_8
X_7205_ _7205_/Q _7301_/CLK _7205_/D fanout367/X vddd vssd sg13cmos5l_dfrbpq_1
X_4417_ _4417_/Y _4419_/A _4417_/B _4417_/C vddd vssd sg13cmos5l_nor3_1
Xfanout302 _5374_/B _7161_/Q vddd vssd sg13cmos5l_buf_1
Xfanout313 _4501_/B hold1487/X vddd vssd sg13cmos5l_buf_1
X_5397_ _5398_/B _7162_/Q _7163_/Q vddd vssd sg13cmos5l_nor2_1
XFILLER_8_1115 vddd vssd sg13cmos5l_decap_4
Xfanout335 _6635_/A1 _6738_/A1 vddd vssd sg13cmos5l_buf_1
Xfanout357 fanout357/X fanout358/X vddd vssd sg13cmos5l_buf_1
Xfanout346 fanout346/X fanout347/X vddd vssd sg13cmos5l_buf_1
XFILLER_21_2507 vddd vssd sg13cmos5l_decap_8
X_4348_ _4349_/B _4348_/A _4357_/B vddd vssd sg13cmos5l_nor2_1
Xfanout324 _5873_/A _3545_/Y vddd vssd sg13cmos5l_buf_1
X_7136_ _7136_/Q _7171_/CLK _7136_/D _6914_/B_N vddd vssd sg13cmos5l_dfrbpq_1
X_7067_ _7067_/Q _7077_/CLK _7067_/D fanout351/X vddd vssd sg13cmos5l_dfrbpq_1
Xfanout379 fanout379/X fanout380/X vddd vssd sg13cmos5l_buf_1
XFILLER_28_1098 vddd vssd sg13cmos5l_decap_8
XFILLER_28_901 vddd vssd sg13cmos5l_decap_4
Xfanout368 fanout368/X fanout371/X vddd vssd sg13cmos5l_buf_1
X_4279_ _4279_/Y _6765_/A _4279_/B vddd vssd sg13cmos5l_nand2_1
X_6018_ _6018_/Y _6037_/A _5032_/A _5024_/B vddd vssd sg13cmos5l_a21oi_1
XFILLER_28_923 vddd vssd sg13cmos5l_decap_8
XFILLER_3_2483 vddd vssd sg13cmos5l_decap_8
XFILLER_28_978 vddd vssd sg13cmos5l_decap_4
XFILLER_19_1713 vddd vssd sg13cmos5l_decap_8
XFILLER_15_639 vddd vssd sg13cmos5l_decap_8
XFILLER_32_1902 vddd vssd sg13cmos5l_decap_8
XFILLER_22_193 vddd vssd sg13cmos5l_decap_8
XFILLER_17_2193 vddd vssd sg13cmos5l_decap_8
XFILLER_10_355 vddd vssd sg13cmos5l_decap_4
XFILLER_30_2371 vddd vssd sg13cmos5l_decap_8
XFILLER_30_1681 vddd vssd sg13cmos5l_decap_4
XFILLER_11_1080 vddd vssd sg13cmos5l_decap_4
XFILLER_26_1728 vddd vssd sg13cmos5l_decap_8
Xtiedowns\[35\] dbus_in_right[3] vddd vssd sg13cmos5l_antennanp
XFILLER_19_934 vddd vssd sg13cmos5l_decap_8
XFILLER_20_1338 vddd vssd sg13cmos5l_decap_8
XFILLER_4_1568 vddd vssd sg13cmos5l_decap_8
XFILLER_26_90 vddd vssd sg13cmos5l_decap_8
XFILLER_18_1256 vddd vssd sg13cmos5l_decap_4
XFILLER_14_694 vddd vssd sg13cmos5l_decap_8
X_3650_ _3652_/C _6971_/Q _5927_/B vddd vssd sg13cmos5l_nor2_1
X_3581_ _3581_/Y _3581_/A vddd vssd sg13cmos5l_inv_1
X_5320_ _5321_/B _5320_/A _5320_/B _5320_/C vddd vssd sg13cmos5l_nor3_1
X_5251_ _5252_/C _5251_/A _5251_/B _6251_/A _5251_/D vddd vssd sg13cmos5l_nor4_1
XFILLER_9_2114 vddd vssd sg13cmos5l_decap_8
X_4202_ _4202_/Y _4199_/Y _4200_/Y _4201_/Y vddd vssd sg13cmos5l_o21ai_1
X_5182_ _5183_/C _5182_/A _6146_/B vddd vssd sg13cmos5l_nor2_1
XFILLER_9_1424 vddd vssd sg13cmos5l_decap_4
XFILLER_9_1446 vddd vssd sg13cmos5l_decap_8
XFILLER_9_2169 vddd vssd sg13cmos5l_decap_8
X_4133_ _4133_/Y _5629_/A _6483_/A vddd vssd sg13cmos5l_nand2b_1
XFILLER_3_72 vddd vssd sg13cmos5l_decap_8
X_4064_ _4064_/Y _7052_/Q _4244_/A2 _3831_/X vddd vssd sg13cmos5l_a21oi_1
XFILLER_20_2584 vddd vssd sg13cmos5l_decap_8
Xwire23 wire23/X wire23/A vddd vssd sg13cmos5l_buf_4
Xwire12 wire12/X wire12/A vddd vssd sg13cmos5l_buf_4
XFILLER_20_1894 vddd vssd sg13cmos5l_decap_8
XFILLER_0_1933 vddd vssd sg13cmos5l_decap_8
Xwire89 wire89/X wire89/A vddd vssd sg13cmos5l_buf_2
X_6705_ _6705_/X _6705_/A0 _6668_/A _6706_/S vddd vssd sg13cmos5l_mux2_1
X_4966_ _4966_/Y _4968_/B _4965_/Y _4966_/B1 vddd vssd sg13cmos5l_a21oi_1
X_4897_ _4897_/Y _4942_/A _7142_/Q _4896_/Y vddd vssd sg13cmos5l_o21ai_1
X_3917_ _3917_/Y _7229_/Q _6545_/A _6538_/A vddd vssd sg13cmos5l_a21oi_1
X_6636_ _6636_/Y _6636_/A _6639_/S vddd vssd sg13cmos5l_nand2_1
XFILLER_20_675 vddd vssd sg13cmos5l_decap_8
X_3848_ _3848_/Y _3848_/A _3848_/B _6779_/A vddd vssd sg13cmos5l_nor3_1
X_6567_ _7237_/D _6581_/A _6567_/A1 _6567_/S vddd vssd sg13cmos5l_mux2_1
XFILLER_10_1507 vddd vssd sg13cmos5l_decap_8
X_3779_ _3781_/B _7102_/Q _4256_/B _4172_/B1 vddd vssd sg13cmos5l_a21oi_1
XFILLER_14_1698 vddd vssd sg13cmos5l_decap_4
X_5518_ _5518_/Y _5752_/A _5518_/B vddd vssd sg13cmos5l_nand2_1
X_6498_ _6505_/S _6498_/A _6545_/B vddd vssd sg13cmos5l_nand2_1
XFILLER_3_329 vddd vssd sg13cmos5l_decap_8
X_5449_ _5449_/Y _7170_/Q _7171_/Q _5465_/B _5472_/B vddd vssd sg13cmos5l_nor4_1
XFILLER_25_2440 vddd vssd sg13cmos5l_decap_8
XFILLER_5_2512 vddd vssd sg13cmos5l_decap_8
Xfanout121 _6702_/B fanout122/X vddd vssd sg13cmos5l_buf_1
Xfanout154 _4590_/A _4808_/A vddd vssd sg13cmos5l_buf_1
X_7119_ _7119_/Q _7119_/CLK _7119_/D _6945_/B_N vddd vssd sg13cmos5l_dfrbpq_1
Xfanout143 _3876_/A _3665_/X vddd vssd sg13cmos5l_buf_1
Xfanout132 _4656_/A _4803_/A vddd vssd sg13cmos5l_buf_1
Xfanout165 _3674_/S hold865/X vddd vssd sg13cmos5l_buf_1
Xfanout198 fanout198/X hold1479/X vddd vssd sg13cmos5l_buf_1
XFILLER_5_2589 vddd vssd sg13cmos5l_decap_8
Xfanout176 _6759_/A _6770_/A1 vddd vssd sg13cmos5l_buf_1
Xfanout187 _6796_/A fanout188/X vddd vssd sg13cmos5l_buf_1
XFILLER_21_2359 vddd vssd sg13cmos5l_decap_8
XFILLER_19_2244 vddd vssd sg13cmos5l_decap_4
XFILLER_32_2411 vddd vssd sg13cmos5l_decap_8
XFILLER_24_970 vddd vssd sg13cmos5l_decap_8
XFILLER_19_1565 vddd vssd sg13cmos5l_decap_4
XFILLER_8_28 vddd vssd sg13cmos5l_decap_8
XFILLER_32_2488 vddd vssd sg13cmos5l_decap_8
XFILLER_32_1754 vddd vssd sg13cmos5l_decap_8
XFILLER_26_7 vddd vssd sg13cmos5l_decap_8
XFILLER_19_720 vddd vssd sg13cmos5l_decap_8
XFILLER_4_2077 vddd vssd sg13cmos5l_decap_8
XFILLER_8_1490 vddd vssd sg13cmos5l_decap_8
XFILLER_20_1146 vddd vssd sg13cmos5l_decap_4
XFILLER_0_1229 vddd vssd sg13cmos5l_decap_8
X_4820_ _4821_/B _7083_/Q _4820_/B vddd vssd sg13cmos5l_xnor2_1
X_4751_ _4751_/Y _4590_/A _4734_/Y _4747_/Y _4750_/Y vddd vssd sg13cmos5l_a22oi_1
X_4682_ _4685_/B _4808_/A _4682_/B vddd vssd sg13cmos5l_nor2_1
X_3702_ _3922_/B _4009_/B _3936_/B vddd vssd sg13cmos5l_nor2_1
X_6421_ _7159_/D _6421_/A1 _6423_/S _6420_/Y vddd vssd sg13cmos5l_a21oi_1
X_3633_ _3633_/Y _4293_/C _4287_/B vddd vssd sg13cmos5l_nand2_1
XFILLER_11_2528 vddd vssd sg13cmos5l_decap_8
X_3564_ _3564_/Y _3564_/A vddd vssd sg13cmos5l_inv_1
X_6352_ _7122_/D _6773_/A _6359_/B hold656/X vddd vssd sg13cmos5l_o21ai_1
X_6283_ _6283_/Y _6287_/A vddd vssd sg13cmos5l_inv_1
X_5303_ _5303_/Y _7146_/Q _7147_/Q _5526_/A _5303_/D vddd vssd sg13cmos5l_nand4_1
X_3495_ _3495_/Y _3495_/A vddd vssd sg13cmos5l_inv_1
Xoutbuffers\[66\] idac2_value[3] _7048_/Q vddd vssd sg13cmos5l_buf_16
X_5234_ _5236_/C _5234_/A _5234_/B _5234_/C _5234_/D vddd vssd sg13cmos5l_nand4_1
XFILLER_25_1024 vddd vssd sg13cmos5l_decap_8
X_5165_ _5168_/B _5239_/A _5170_/B vddd vssd sg13cmos5l_nor2_1
X_4116_ _6136_/A dbus_in_left[1] dbus_in_right[1] vddd vssd sg13cmos5l_nor2_1
XFILLER_9_1287 vddd vssd sg13cmos5l_decap_8
X_5096_ _6060_/C _7286_/Q _7287_/Q _5096_/C vddd vssd sg13cmos5l_nand3_1
X_4047_ _4047_/Y _5557_/A _6461_/A _6453_/A vddd vssd sg13cmos5l_a21oi_1
XFILLER_0_2475 vddd vssd sg13cmos5l_decap_8
XFILLER_24_244 vddd vssd sg13cmos5l_decap_8
XFILLER_16_2428 vddd vssd sg13cmos5l_decap_8
X_5998_ _5998_/Y _6267_/A1 _5010_/A _5996_/Y _5997_/Y _5008_/D vddd vssd sg13cmos5l_a221oi_1
XFILLER_24_288 vddd vssd sg13cmos5l_decap_8
X_4949_ _4949_/Y _4949_/A _4949_/B _4949_/C vddd vssd sg13cmos5l_nor3_1
XFILLER_16_1705 vddd vssd sg13cmos5l_decap_8
XFILLER_32_1039 vddd vssd sg13cmos5l_decap_8
X_6619_ _6619_/X hold685/X _6773_/A _6620_/S vddd vssd sg13cmos5l_mux2_1
XFILLER_14_1473 vddd vssd sg13cmos5l_decap_8
XFILLER_27_2513 vddd vssd sg13cmos5l_decap_8
XFILLER_21_2178 vddd vssd sg13cmos5l_decap_8
XFILLER_21_1466 vddd vssd sg13cmos5l_decap_8
XFILLER_15_244 vddd vssd sg13cmos5l_decap_8
XFILLER_12_962 vddd vssd sg13cmos5l_decap_4
XFILLER_23_91 vddd vssd sg13cmos5l_decap_8
XFILLER_7_410 vddd vssd sg13cmos5l_decap_8
XFILLER_32_1562 vddd vssd sg13cmos5l_decap_8
XFILLER_11_494 vddd vssd sg13cmos5l_decap_4
XFILLER_10_2561 vddd vssd sg13cmos5l_decap_8
XFILLER_26_2056 vddd vssd sg13cmos5l_decap_8
XFILLER_6_2139 vddd vssd sg13cmos5l_decap_8
X_5921_ _5921_/Y _5944_/A _7103_/Q _7102_/Q _3528_/Y vddd vssd sg13cmos5l_a22oi_1
XFILLER_0_1026 vddd vssd sg13cmos5l_decap_8
XFILLER_0_84 vddd vssd sg13cmos5l_decap_8
X_5852_ _5875_/B _7228_/Q _7229_/Q vddd vssd sg13cmos5l_nor2_1
XFILLER_22_737 vddd vssd sg13cmos5l_decap_8
X_5783_ _5783_/X _5783_/A _5791_/B vddd vssd sg13cmos5l_or2_1
X_4803_ _4805_/A _4803_/A _4803_/B vddd vssd sg13cmos5l_nor2_1
XFILLER_21_269 vddd vssd sg13cmos5l_decap_8
X_4734_ _4734_/Y _4771_/A1 _3597_/Y _4771_/B1 _4733_/Y vddd vssd sg13cmos5l_a22oi_1
XFILLER_15_2472 vddd vssd sg13cmos5l_decap_8
X_4665_ _4665_/Y _4642_/B _4673_/B vddd vssd sg13cmos5l_nand2b_1
XFILLER_11_1624 vddd vssd sg13cmos5l_decap_8
X_4596_ _4597_/A _4572_/B _4595_/X _4668_/A vddd vssd sg13cmos5l_o21ai_1
Xhold922 _4281_/C _3633_/Y vddd vssd sg13cmos5l_dlygate4sd3_1
X_3616_ _6219_/B _3616_/A vddd vssd sg13cmos5l_inv_1
Xhold900 _6530_/A _7218_/Q vddd vssd sg13cmos5l_dlygate4sd3_1
X_7384_ _7384_/Q _7403_/CLK _7384_/D _6898_/Y vddd vssd sg13cmos5l_dfrbpq_1
Xhold911 _7314_/D _4917_/Y vddd vssd sg13cmos5l_dlygate4sd3_1
X_6404_ _7150_/D _6748_/A1 _6408_/B hold784/X vddd vssd sg13cmos5l_o21ai_1
Xhold955 hold955/X _6491_/Y vddd vssd sg13cmos5l_dlygate4sd3_1
Xhold933 _6703_/A _7033_/Q vddd vssd sg13cmos5l_dlygate4sd3_1
X_6335_ _7114_/D hold836/X _6338_/B _6334_/Y vddd vssd sg13cmos5l_o21ai_1
X_3547_ _5318_/B _3547_/A vddd vssd sg13cmos5l_inv_1
Xhold944 _6454_/A _7178_/Q vddd vssd sg13cmos5l_dlygate4sd3_1
Xhold977 hold977/X _6634_/Y vddd vssd sg13cmos5l_dlygate4sd3_1
Xhold988 _7116_/D _6339_/Y vddd vssd sg13cmos5l_dlygate4sd3_1
Xhold966 _6616_/A _7266_/Q vddd vssd sg13cmos5l_dlygate4sd3_1
X_3478_ _3478_/Y _4514_/B vddd vssd sg13cmos5l_inv_1
Xhold999 _3607_/A _7118_/Q vddd vssd sg13cmos5l_dlygate4sd3_1
X_6266_ _6266_/Y _6266_/A _6266_/B vddd vssd sg13cmos5l_nand2_1
X_6197_ _6199_/A _5232_/A _5241_/B _5233_/D _3797_/X _6196_/Y vddd vssd sg13cmos5l_a221oi_1
X_5217_ _5217_/Y _5217_/A _6177_/B _5217_/C _5217_/D vddd vssd sg13cmos5l_nand4_1
XFILLER_29_336 vddd vssd sg13cmos5l_decap_8
XFILLER_22_2443 vddd vssd sg13cmos5l_decap_8
X_5148_ _5152_/A _5148_/A _5148_/B _5148_/C vddd vssd sg13cmos5l_nor3_1
XFILLER_28_58 vddd vssd sg13cmos5l_decap_8
XFILLER_2_2537 vddd vssd sg13cmos5l_decap_4
X_5079_ _5267_/A _5245_/A _7251_/Q vddd vssd sg13cmos5l_nand2_1
XFILLER_16_1535 vddd vssd sg13cmos5l_decap_4
XFILLER_9_719 vddd vssd sg13cmos5l_decap_8
XFILLER_12_247 vddd vssd sg13cmos5l_decap_4
XFILLER_27_2387 vddd vssd sg13cmos5l_decap_8
XFILLER_27_1653 vddd vssd sg13cmos5l_decap_8
XFILLER_23_1506 vddd vssd sg13cmos5l_decap_4
XFILLER_7_1714 vddd vssd sg13cmos5l_decap_8
XFILLER_7_2459 vddd vssd sg13cmos5l_decap_8
XFILLER_7_1747 vddd vssd sg13cmos5l_decap_8
XFILLER_5_1493 vddd vssd sg13cmos5l_decap_8
XFILLER_18_91 vddd vssd sg13cmos5l_decap_8
XFILLER_16_564 vddd vssd sg13cmos5l_decap_8
XFILLER_8_730 vddd vssd sg13cmos5l_decap_4
XFILLER_15_1067 vddd vssd sg13cmos5l_decap_8
XFILLER_8_763 vddd vssd sg13cmos5l_decap_8
X_4450_ _4524_/B _5623_/A _4577_/A _4572_/B vddd vssd sg13cmos5l_nand3_1
X_4381_ _4392_/B _7342_/Q _7130_/Q vddd vssd sg13cmos5l_xnor2_1
XFILLER_12_1977 vddd vssd sg13cmos5l_decap_8
X_6120_ _6120_/Y _6118_/Y _6119_/Y _6102_/Y vddd vssd sg13cmos5l_o21ai_1
X_6051_ _6051_/Y _6185_/C _6050_/A _6048_/Y _6050_/Y vddd vssd sg13cmos5l_a22oi_1
XFILLER_6_1246 vddd vssd sg13cmos5l_decap_8
X_5002_ _5125_/A _7262_/Q _7263_/Q vddd vssd sg13cmos5l_nor2_1
XFILLER_15_0 vddd vssd sg13cmos5l_decap_8
XFILLER_26_328 vddd vssd sg13cmos5l_decap_8
Xoutbuffers\[29\] voltgen_sink1[2] _7069_/Q vddd vssd sg13cmos5l_buf_16
X_6953_ _6953_/Y _6962_/A _6957_/B_N vddd vssd sg13cmos5l_nor2b_1
X_5904_ _5905_/C _5871_/A _5899_/Y _5901_/Y vddd vssd sg13cmos5l_a21o_1
X_6884_ _6884_/Y _6917_/A _6893_/B_N vddd vssd sg13cmos5l_nor2b_1
XFILLER_17_2534 vddd vssd sg13cmos5l_decap_8
X_5835_ _5842_/B _7225_/Q _5837_/B vddd vssd sg13cmos5l_nor2b_1
XFILLER_22_567 vddd vssd sg13cmos5l_decap_8
XFILLER_10_718 vddd vssd sg13cmos5l_decap_8
XFILLER_10_707 vddd vssd sg13cmos5l_decap_4
XFILLER_14_49 vddd vssd sg13cmos5l_decap_8
Xtiedowns\[1\] sram_odata[1] vddd vssd sg13cmos5l_antennanp
X_5766_ _5766_/Y _5758_/A _5764_/A _5764_/X _5502_/A _5765_/Y vddd vssd sg13cmos5l_a221oi_1
X_5697_ _5697_/Y _6225_/A _7204_/Q _5696_/X vddd vssd sg13cmos5l_o21ai_1
X_4717_ _4717_/Y _4698_/A _4716_/Y _4460_/B vddd vssd sg13cmos5l_o21ai_1
XFILLER_30_37 vddd vssd sg13cmos5l_decap_8
X_4648_ _4651_/B _4674_/A _4674_/B vddd vssd sg13cmos5l_nand2_1
Xhold730 hold730/X _4841_/Y vddd vssd sg13cmos5l_dlygate4sd3_1
X_4579_ _4579_/Y _4581_/A vddd vssd sg13cmos5l_inv_1
X_7367_ _7367_/Q _7367_/CLK _7367_/D _6881_/Y vddd vssd sg13cmos5l_dfrbpq_1
Xhold763 hold763/X _7233_/Q vddd vssd sg13cmos5l_dlygate4sd3_1
Xhold741 _6382_/A _7140_/Q vddd vssd sg13cmos5l_dlygate4sd3_1
Xhold752 hold752/X _4342_/Y vddd vssd sg13cmos5l_dlygate4sd3_1
Xhold796 _7341_/D _4640_/Y vddd vssd sg13cmos5l_dlygate4sd3_1
XFILLER_24_2516 vddd vssd sg13cmos5l_decap_8
Xhold785 _3606_/A _7117_/Q vddd vssd sg13cmos5l_dlygate4sd3_1
Xhold774 _4616_/A _7342_/Q vddd vssd sg13cmos5l_dlygate4sd3_1
X_7298_ _7298_/Q _7300_/CLK _7298_/D fanout377/X vddd vssd sg13cmos5l_dfrbpq_1
X_6318_ _6318_/Y hold896/X _6321_/B _6317_/Y vddd vssd sg13cmos5l_o21ai_1
X_6249_ _6251_/B _6246_/Y _6247_/Y _6248_/Y vddd vssd sg13cmos5l_a21oi_1
XFILLER_29_133 vddd vssd sg13cmos5l_decap_8
Xhold1452 hold1452/X _7335_/Q vddd vssd sg13cmos5l_dlygate4sd3_1
Xhold1430 _6436_/A1 _5442_/A vddd vssd sg13cmos5l_dlygate4sd3_1
Xhold1441 _4788_/B _4787_/Y vddd vssd sg13cmos5l_dlygate4sd3_1
Xhold1474 _7343_/D _4594_/X vddd vssd sg13cmos5l_dlygate4sd3_1
Xhold1463 _7053_/D _6731_/X vddd vssd sg13cmos5l_dlygate4sd3_1
XFILLER_22_1561 vddd vssd sg13cmos5l_decap_8
Xhold1485 _6788_/A0 _7087_/Q vddd vssd sg13cmos5l_dlygate4sd3_1
Xhold1496 hold501/A _7014_/Q vddd vssd sg13cmos5l_dlygate4sd3_1
XFILLER_16_2055 vddd vssd sg13cmos5l_decap_8
XFILLER_16_1310 vddd vssd sg13cmos5l_decap_8
XFILLER_16_1332 vddd vssd sg13cmos5l_decap_8
XFILLER_5_700 vddd vssd sg13cmos5l_decap_8
Xtiedowns\[65\] mask_rev_in[21] vddd vssd sg13cmos5l_antennanp
XFILLER_5_766 vddd vssd sg13cmos5l_decap_8
XFILLER_20_70 vddd vssd sg13cmos5l_decap_8
XFILLER_27_2140 vddd vssd sg13cmos5l_decap_8
XFILLER_23_1303 vddd vssd sg13cmos5l_decap_4
XFILLER_0_460 vddd vssd sg13cmos5l_decap_8
XFILLER_17_840 vddd vssd sg13cmos5l_decap_4
XFILLER_5_1290 vddd vssd sg13cmos5l_decap_4
XFILLER_21_1093 vddd vssd sg13cmos5l_decap_8
X_3950_ _3950_/Y _6453_/A vddd vssd sg13cmos5l_inv_1
XFILLER_32_843 vddd vssd sg13cmos5l_decap_8
Xoutbuffers\[119\] dbus_out[22] _6238_/Y vddd vssd sg13cmos5l_buf_16
X_3881_ _3881_/Y _3881_/A _3881_/B _3881_/C _3881_/D vddd vssd sg13cmos5l_nand4_1
X_5620_ _5620_/Y _5797_/A1 _5591_/Y _5619_/Y vddd vssd sg13cmos5l_a21oi_1
X_5551_ _5552_/C _5549_/X _5550_/X _5557_/C vddd vssd sg13cmos5l_a21oi_1
X_4502_ _4508_/B _4531_/A _4534_/A vddd vssd sg13cmos5l_nand2_1
XFILLER_12_2486 vddd vssd sg13cmos5l_decap_8
X_5482_ _5488_/A _5828_/B2 _5495_/D _5498_/D vddd vssd sg13cmos5l_a21o_1
X_7221_ _7221_/Q _7296_/CLK _7221_/D fanout366/X vddd vssd sg13cmos5l_dfrbpq_1
X_4433_ _4433_/Y _7083_/Q _4792_/A _4818_/A vddd vssd sg13cmos5l_o21ai_1
Xwire8 wire8/X wire8/A vddd vssd sg13cmos5l_buf_4
X_7152_ _7152_/Q _7363_/CLK _7152_/D fanout357/X vddd vssd sg13cmos5l_dfrbpq_1
X_4364_ _4364_/Y _7090_/Q _4416_/A _4363_/Y vddd vssd sg13cmos5l_o21ai_1
X_6103_ _6103_/Y _6239_/A _6188_/B _6145_/C _6103_/D vddd vssd sg13cmos5l_nor4_1
X_7083_ _7083_/Q _7268_/CLK _7083_/D _6957_/B_N vddd vssd sg13cmos5l_dfrbpq_1
X_4295_ _4299_/C _4972_/A _4309_/A _4963_/A _4965_/B vddd vssd sg13cmos5l_nor4_1
X_6034_ _6034_/Y _6034_/A vddd vssd sg13cmos5l_inv_1
XFILLER_6_1076 vddd vssd sg13cmos5l_decap_4
XFILLER_26_125 vddd vssd sg13cmos5l_decap_8
X_6936_ _6936_/Y _6956_/A _6956_/B_N vddd vssd sg13cmos5l_nor2b_1
XFILLER_25_37 vddd vssd sg13cmos5l_decap_8
XFILLER_23_810 vddd vssd sg13cmos5l_decap_8
X_6867_ _6867_/Y _6870_/A _6870_/B_N vddd vssd sg13cmos5l_nor2b_1
XFILLER_23_887 vddd vssd sg13cmos5l_decap_8
X_6798_ _6798_/Y _6798_/A _6803_/B vddd vssd sg13cmos5l_nand2_1
X_5818_ _5818_/Y _5811_/Y _5814_/Y _5817_/Y vddd vssd sg13cmos5l_o21ai_1
X_5749_ _5749_/Y _5779_/A1 _7213_/Q _5747_/Y vddd vssd sg13cmos5l_o21ai_1
XFILLER_30_2553 vddd vssd sg13cmos5l_decap_8
XFILLER_11_1284 vddd vssd sg13cmos5l_decap_8
Xhold560 _6809_/A _7003_/Q vddd vssd sg13cmos5l_dlygate4sd3_1
Xhold571 _7393_/D _3861_/Y vddd vssd sg13cmos5l_dlygate4sd3_1
XFILLER_28_2482 vddd vssd sg13cmos5l_decap_8
Xhold593 _4329_/A _7367_/Q vddd vssd sg13cmos5l_dlygate4sd3_1
Xhold582 _4089_/A _7391_/Q vddd vssd sg13cmos5l_dlygate4sd3_1
XFILLER_8_2543 vddd vssd sg13cmos5l_decap_8
XFILLER_8_1864 vddd vssd sg13cmos5l_decap_4
XFILLER_20_1509 vddd vssd sg13cmos5l_decap_8
Xhold1260 _4968_/B _4964_/X vddd vssd sg13cmos5l_dlygate4sd3_1
Xhold1282 hold1282/X _7085_/Q vddd vssd sg13cmos5l_dlygate4sd3_1
Xhold1271 _6657_/A0 _7292_/Q vddd vssd sg13cmos5l_dlygate4sd3_1
Xhold1293 _4967_/B1 _4966_/Y vddd vssd sg13cmos5l_dlygate4sd3_1
XFILLER_26_670 vddd vssd sg13cmos5l_decap_8
XFILLER_25_180 vddd vssd sg13cmos5l_decap_8
XFILLER_14_843 vddd vssd sg13cmos5l_decap_8
XFILLER_15_70 vddd vssd sg13cmos5l_decap_8
XFILLER_31_1649 vddd vssd sg13cmos5l_decap_8
XFILLER_16_1184 vddd vssd sg13cmos5l_decap_8
XFILLER_12_1015 vddd vssd sg13cmos5l_decap_8
XFILLER_12_1048 vddd vssd sg13cmos5l_decap_4
XFILLER_29_1523 vddd vssd sg13cmos5l_decap_8
XFILLER_7_2031 vddd vssd sg13cmos5l_decap_4
XFILLER_23_1100 vddd vssd sg13cmos5l_decap_8
XFILLER_7_2086 vddd vssd sg13cmos5l_decap_8
X_4080_ _4080_/Y _4077_/Y _4078_/Y _4079_/Y vddd vssd sg13cmos5l_a21oi_1
X_4982_ _6049_/B _7248_/Q _7249_/Q vddd vssd sg13cmos5l_nor2_1
X_6721_ _6721_/X _6721_/A0 _6405_/A _6725_/S vddd vssd sg13cmos5l_mux2_1
X_3933_ _6498_/A _3933_/A _3961_/B vddd vssd sg13cmos5l_nor2_1
XFILLER_32_662 vddd vssd sg13cmos5l_decap_8
X_6652_ _6652_/X _6652_/A0 _6581_/A _6652_/S vddd vssd sg13cmos5l_mux2_1
X_3864_ _3881_/A _7030_/Q _6696_/A _6687_/A _7027_/Q vddd vssd sg13cmos5l_a22oi_1
XFILLER_14_2526 vddd vssd sg13cmos5l_decap_8
X_5603_ _5603_/Y _5601_/Y _5602_/Y _5614_/C vddd vssd sg13cmos5l_o21ai_1
XFILLER_14_1825 vddd vssd sg13cmos5l_decap_8
XFILLER_30_1126 vddd vssd sg13cmos5l_decap_8
X_3795_ _3795_/Y _6762_/B _3933_/A vddd vssd sg13cmos5l_nor2_1
X_6583_ _6589_/S _6583_/A _6736_/B vddd vssd sg13cmos5l_nor2_1
Xoutbuffers\[96\] io_out[11] _6278_/X vddd vssd sg13cmos5l_buf_16
X_5534_ _5534_/Y _7182_/Q _7183_/Q _5557_/A _5557_/B vddd vssd sg13cmos5l_nor4_1
XFILLER_9_891 vddd vssd sg13cmos5l_decap_8
XFILLER_11_28 vddd vssd sg13cmos5l_decap_8
X_5465_ _5465_/X _5484_/A _5465_/B vddd vssd sg13cmos5l_or2_1
X_7204_ _7204_/Q _7301_/CLK _7204_/D fanout369/X vddd vssd sg13cmos5l_dfrbpq_1
X_4416_ _4416_/Y _4416_/A _4419_/B vddd vssd sg13cmos5l_nor2_1
Xfanout303 _5386_/A _5389_/A vddd vssd sg13cmos5l_buf_1
Xclkbuf_leaf_16_SCK_regs _7300_/CLK clkload8/A vddd vssd sg13cmos5l_buf_8
X_7135_ _7135_/Q _7135_/CLK _7135_/D fanout390/X vddd vssd sg13cmos5l_dfrbpq_1
X_5396_ _5416_/B _7164_/Q _7165_/Q vddd vssd sg13cmos5l_nor2_1
Xfanout314 _6037_/A _4208_/X vddd vssd sg13cmos5l_buf_1
Xfanout336 _6738_/A1 _6667_/A1 vddd vssd sg13cmos5l_buf_1
Xfanout347 fanout347/X fanout411/X vddd vssd sg13cmos5l_buf_1
X_4347_ _4347_/Y _4353_/A _3672_/S _4346_/Y vddd vssd sg13cmos5l_a21oi_1
XFILLER_8_1149 vddd vssd sg13cmos5l_decap_8
Xfanout325 _5789_/A _3543_/Y vddd vssd sg13cmos5l_buf_1
Xfanout358 fanout358/X fanout411/X vddd vssd sg13cmos5l_buf_1
X_7066_ _7066_/Q _7077_/CLK _7066_/D fanout352/X vddd vssd sg13cmos5l_dfrbpq_1
Xfanout369 fanout369/X fanout371/X vddd vssd sg13cmos5l_buf_1
X_4278_ _7382_/D _6765_/A _6722_/A _4279_/B vddd vssd sg13cmos5l_mux2_1
X_6017_ _6017_/Y _6015_/Y _6017_/B vddd vssd sg13cmos5l_nand2b_1
XFILLER_19_1747 vddd vssd sg13cmos5l_decap_4
X_6919_ _6919_/Y _6948_/A _6969_/B_N vddd vssd sg13cmos5l_nor2b_1
XFILLER_11_802 vddd vssd sg13cmos5l_decap_4
XFILLER_11_835 vddd vssd sg13cmos5l_decap_8
XFILLER_32_1958 vddd vssd sg13cmos5l_decap_8
XFILLER_20_2007 vddd vssd sg13cmos5l_decap_4
Xtiedowns\[28\] dbus_in_left[8] vddd vssd sg13cmos5l_antennanp
XFILLER_19_913 vddd vssd sg13cmos5l_decap_8
XFILLER_8_1672 vddd vssd sg13cmos5l_decap_8
XFILLER_20_1317 vddd vssd sg13cmos5l_decap_8
Xhold1090 _6513_/A1 _5713_/B vddd vssd sg13cmos5l_dlygate4sd3_1
XFILLER_14_673 vddd vssd sg13cmos5l_decap_8
XFILLER_31_1413 vddd vssd sg13cmos5l_decap_4
X_3580_ _5778_/B _3580_/A vddd vssd sg13cmos5l_inv_1
XFILLER_9_187 vddd vssd sg13cmos5l_decap_8
X_5250_ _5254_/C _5250_/A _6239_/B vddd vssd sg13cmos5l_nor2_1
XFILLER_6_883 vddd vssd sg13cmos5l_decap_8
X_4201_ _4201_/Y _5130_/A _3892_/Y _6576_/A vddd vssd sg13cmos5l_a21oi_1
X_5181_ _5185_/B _6145_/B _6145_/C _6154_/B vddd vssd sg13cmos5l_o21ai_1
X_4132_ _4132_/Y _4129_/Y _4130_/X _4131_/Y vddd vssd sg13cmos5l_o21ai_1
XFILLER_3_51 vddd vssd sg13cmos5l_decap_8
X_4063_ _4063_/Y _7079_/Q _6736_/A _4062_/Y vddd vssd sg13cmos5l_o21ai_1
XFILLER_7_1171 vddd vssd sg13cmos5l_decap_8
XFILLER_20_2563 vddd vssd sg13cmos5l_decap_8
Xwire13 wire13/X wire13/A vddd vssd sg13cmos5l_buf_4
Xoutbuffers\[11\] proj_dig_ena _7030_/Q vddd vssd sg13cmos5l_buf_16
X_4965_ _4965_/Y _4972_/A _4965_/B vddd vssd sg13cmos5l_nand2_1
X_6704_ _7033_/D _6704_/A1 _6706_/S hold934/X vddd vssd sg13cmos5l_a21oi_1
X_3916_ _3916_/Y _3919_/A _6597_/B vddd vssd sg13cmos5l_nor2_1
X_4896_ _4896_/Y _4874_/A _4895_/Y _4883_/Y vddd vssd sg13cmos5l_o21ai_1
X_6635_ _7278_/D _6635_/A1 _6639_/S hold977/X vddd vssd sg13cmos5l_a21oi_1
XFILLER_22_49 vddd vssd sg13cmos5l_decap_8
XFILLER_20_654 vddd vssd sg13cmos5l_decap_8
X_3847_ _3847_/Y _3848_/B _6779_/A vddd vssd sg13cmos5l_nor2_1
X_3778_ _3778_/Y _3607_/Y _3863_/B _3775_/Y _3777_/Y vddd vssd sg13cmos5l_a22oi_1
XFILLER_14_1677 vddd vssd sg13cmos5l_decap_8
X_6566_ _7236_/D _6550_/A _6566_/A1 _6567_/S vddd vssd sg13cmos5l_mux2_1
X_5517_ _5523_/B _5517_/A _7181_/Q vddd vssd sg13cmos5l_nor2_1
X_6497_ _6497_/Y _6497_/A1 _6496_/B _6496_/Y vddd vssd sg13cmos5l_a21oi_1
X_5448_ _5448_/Y _5590_/A1 _5419_/Y _5447_/Y vddd vssd sg13cmos5l_a21oi_1
Xfanout100 _3846_/A _6786_/B vddd vssd sg13cmos5l_buf_1
X_5379_ _5379_/Y _5386_/C _5378_/Y _5386_/A vddd vssd sg13cmos5l_o21ai_1
Xfanout122 fanout122/X _6779_/B vddd vssd sg13cmos5l_buf_1
X_7118_ _7118_/Q _7276_/CLK _7118_/D fanout392/X vddd vssd sg13cmos5l_dfrbpq_1
Xfanout155 _4808_/A _4431_/Y vddd vssd sg13cmos5l_buf_1
Xfanout144 _7023_/D _4267_/A vddd vssd sg13cmos5l_buf_1
Xfanout133 _4803_/A _4424_/Y vddd vssd sg13cmos5l_buf_1
XFILLER_25_2496 vddd vssd sg13cmos5l_decap_8
X_7049_ _7049_/Q _7146_/CLK _7049_/D fanout350/X vddd vssd sg13cmos5l_dfrbpq_1
Xfanout199 _6405_/A _6765_/A vddd vssd sg13cmos5l_buf_1
XFILLER_21_1604 vddd vssd sg13cmos5l_decap_4
Xfanout188 fanout188/X hold1454/X vddd vssd sg13cmos5l_buf_1
Xfanout166 _4315_/A _5280_/A1 vddd vssd sg13cmos5l_buf_1
XFILLER_5_2568 vddd vssd sg13cmos5l_decap_8
Xfanout177 _6770_/A1 hold1515/X vddd vssd sg13cmos5l_buf_1
XFILLER_19_1511 vddd vssd sg13cmos5l_decap_8
XFILLER_32_2467 vddd vssd sg13cmos5l_decap_8
XFILLER_32_1733 vddd vssd sg13cmos5l_decap_8
XFILLER_19_1599 vddd vssd sg13cmos5l_decap_8
XFILLER_10_131 vddd vssd sg13cmos5l_decap_4
XFILLER_11_665 vddd vssd sg13cmos5l_decap_8
XFILLER_6_124 vddd vssd sg13cmos5l_decap_8
XFILLER_7_658 vddd vssd sg13cmos5l_decap_4
XFILLER_3_897 vddd vssd sg13cmos5l_decap_8
XFILLER_19_7 vddd vssd sg13cmos5l_decap_8
XFILLER_4_1322 vddd vssd sg13cmos5l_decap_4
XFILLER_20_1125 vddd vssd sg13cmos5l_decap_8
XFILLER_19_765 vddd vssd sg13cmos5l_decap_8
XFILLER_19_798 vddd vssd sg13cmos5l_decap_8
XFILLER_18_264 vddd vssd sg13cmos5l_decap_8
XFILLER_18_1010 vddd vssd sg13cmos5l_decap_8
Xoutbuffers\[101\] dbus_out[4] _5418_/Y vddd vssd sg13cmos5l_buf_16
X_4750_ _4750_/Y _4647_/B _4749_/Y _4590_/A vddd vssd sg13cmos5l_a21oi_1
XFILLER_18_1098 vddd vssd sg13cmos5l_decap_8
X_3701_ _3936_/B _3753_/C _3753_/D vddd vssd sg13cmos5l_nand2b_1
X_4681_ _4682_/B _4647_/B _4669_/X _4680_/Y vddd vssd sg13cmos5l_a21oi_1
XFILLER_11_2507 vddd vssd sg13cmos5l_decap_8
X_3632_ _3632_/Y _4482_/A _3632_/B vddd vssd sg13cmos5l_xnor2_1
X_6420_ _6420_/Y _6464_/A _6423_/S vddd vssd sg13cmos5l_nor2_1
XFILLER_15_1953 vddd vssd sg13cmos5l_decap_8
X_6351_ _6351_/Y _6351_/A _6359_/B vddd vssd sg13cmos5l_nand2_1
X_5302_ _5302_/Y _5302_/A _5302_/B _5303_/D _5302_/D vddd vssd sg13cmos5l_nor4_1
X_3563_ _5544_/B _3563_/A vddd vssd sg13cmos5l_inv_1
X_6282_ _6287_/A _7080_/Q _6282_/B vddd vssd sg13cmos5l_nor2_1
X_3494_ _3494_/Y _3494_/A vddd vssd sg13cmos5l_inv_1
X_5233_ _5234_/D _5233_/A _5233_/B _5233_/C _5233_/D vddd vssd sg13cmos5l_nor4_1
Xoutbuffers\[59\] voltgen_high _7053_/Q vddd vssd sg13cmos5l_buf_16
X_5164_ _5168_/A _5243_/A _5178_/B vddd vssd sg13cmos5l_and2_1
XFILLER_9_1244 vddd vssd sg13cmos5l_decap_4
XFILLER_25_1047 vddd vssd sg13cmos5l_decap_8
X_4115_ _4115_/Y _4115_/A _4115_/B vddd vssd sg13cmos5l_nand2_1
X_5095_ _6145_/B _5212_/A _5212_/B vddd vssd sg13cmos5l_nand2_1
X_4046_ _4046_/Y _7188_/Q _3944_/Y _3947_/Y vddd vssd sg13cmos5l_o21ai_1
XFILLER_20_2393 vddd vssd sg13cmos5l_decap_8
XFILLER_17_49 vddd vssd sg13cmos5l_decap_8
XFILLER_0_2454 vddd vssd sg13cmos5l_decap_8
XFILLER_16_2407 vddd vssd sg13cmos5l_decap_8
X_5997_ _5997_/Y _6037_/A _5012_/C _5010_/A vddd vssd sg13cmos5l_a21oi_1
XFILLER_0_1786 vddd vssd sg13cmos5l_decap_8
XFILLER_12_418 vddd vssd sg13cmos5l_decap_8
X_4948_ _4949_/C _4925_/A _4932_/A _4925_/B vddd vssd sg13cmos5l_a21oi_1
XFILLER_32_1018 vddd vssd sg13cmos5l_decap_8
XFILLER_21_952 vddd vssd sg13cmos5l_decap_8
X_4879_ _4894_/A _4952_/A _7139_/Q _7138_/Q _4955_/A vddd vssd sg13cmos5l_a22oi_1
X_6618_ _6618_/X _6618_/A0 _6788_/A1 _6620_/S vddd vssd sg13cmos5l_mux2_1
Xclkbuf_leaf_31_SCK_regs _7291_/CLK clkload8/A vddd vssd sg13cmos5l_buf_8
X_6549_ _6549_/Y _6549_/A1 _6552_/B _6548_/Y vddd vssd sg13cmos5l_a21oi_1
XFILLER_3_127 vddd vssd sg13cmos5l_decap_4
XFILLER_27_2569 vddd vssd sg13cmos5l_decap_8
XFILLER_27_1868 vddd vssd sg13cmos5l_decap_8
XFILLER_21_2102 vddd vssd sg13cmos5l_decap_4
XFILLER_25_1592 vddd vssd sg13cmos5l_decap_8
XFILLER_21_1445 vddd vssd sg13cmos5l_decap_4
XFILLER_30_226 vddd vssd sg13cmos5l_decap_8
XFILLER_19_1341 vddd vssd sg13cmos5l_decap_8
XFILLER_12_941 vddd vssd sg13cmos5l_decap_8
XFILLER_32_2286 vddd vssd sg13cmos5l_decap_8
XFILLER_23_70 vddd vssd sg13cmos5l_decap_8
XFILLER_11_473 vddd vssd sg13cmos5l_decap_8
XFILLER_8_967 vddd vssd sg13cmos5l_decap_4
Xmax_cap108 _6786_/A _4057_/B vddd vssd sg13cmos5l_buf_4
XFILLER_10_2540 vddd vssd sg13cmos5l_decap_8
XFILLER_3_694 vddd vssd sg13cmos5l_decap_8
X_5920_ _5920_/Y _3528_/Y _7102_/Q _5919_/Y vddd vssd sg13cmos5l_o21ai_1
XFILLER_0_63 vddd vssd sg13cmos5l_decap_8
X_5851_ _5851_/Y _6238_/A1 _5826_/X _5850_/Y vddd vssd sg13cmos5l_a21oi_1
X_5782_ _5786_/B _5794_/C _5787_/C vddd vssd sg13cmos5l_nor2_1
X_4802_ _4802_/Y _4821_/A _4802_/B vddd vssd sg13cmos5l_nor2_1
XFILLER_15_2451 vddd vssd sg13cmos5l_decap_8
X_4733_ _4733_/Y _4733_/A _4733_/B vddd vssd sg13cmos5l_xnor2_1
X_4664_ _4673_/B _6057_/A _4664_/B vddd vssd sg13cmos5l_nand2_1
XFILLER_11_2348 vddd vssd sg13cmos5l_decap_8
X_6403_ _6403_/Y _6403_/A _6408_/B vddd vssd sg13cmos5l_nand2_1
X_3615_ _3615_/Y _3615_/A vddd vssd sg13cmos5l_inv_1
X_4595_ _4595_/X _6121_/A _4619_/A vddd vssd sg13cmos5l_and2_1
Xhold912 _5927_/B _6972_/Q vddd vssd sg13cmos5l_dlygate4sd3_1
Xhold901 hold901/X _6530_/Y vddd vssd sg13cmos5l_dlygate4sd3_1
X_7383_ _7383_/Q _7386_/CLK _7383_/D _6897_/Y vddd vssd sg13cmos5l_dfrbpq_1
Xhold934 hold934/X _6703_/Y vddd vssd sg13cmos5l_dlygate4sd3_1
X_3546_ _3546_/Y io_in[0] vddd vssd sg13cmos5l_inv_1
X_6334_ _6334_/Y _6773_/A _6338_/B vddd vssd sg13cmos5l_nand2_1
Xhold923 _4283_/S _4284_/B vddd vssd sg13cmos5l_dlygate4sd3_1
Xhold945 hold945/X _6454_/Y vddd vssd sg13cmos5l_dlygate4sd3_1
Xhold978 _6499_/A _7202_/Q vddd vssd sg13cmos5l_dlygate4sd3_1
Xhold989 _6396_/A _7146_/Q vddd vssd sg13cmos5l_dlygate4sd3_1
Xhold956 _6622_/A _7270_/Q vddd vssd sg13cmos5l_dlygate4sd3_1
X_6265_ _6266_/B _4207_/Y _5269_/B _6264_/Y vddd vssd sg13cmos5l_o21ai_1
Xhold967 hold967/X _6616_/Y vddd vssd sg13cmos5l_dlygate4sd3_1
X_3477_ _3477_/Y _4482_/A vddd vssd sg13cmos5l_inv_1
X_5216_ _5217_/D _6178_/A _5216_/B _5216_/C _5216_/D vddd vssd sg13cmos5l_nor4_1
XFILLER_26_2591 vddd vssd sg13cmos5l_decap_8
X_6196_ _6196_/Y _5234_/C _6194_/Y _6195_/Y vddd vssd sg13cmos5l_a21oi_1
XFILLER_28_37 vddd vssd sg13cmos5l_decap_8
X_5147_ _5149_/D _5232_/A _5175_/B vddd vssd sg13cmos5l_and2_1
XFILLER_22_2499 vddd vssd sg13cmos5l_decap_8
XFILLER_22_1743 vddd vssd sg13cmos5l_decap_4
X_5078_ _5101_/A _7256_/Q _7257_/Q _5263_/A vddd vssd sg13cmos5l_nor3_1
X_4029_ _4030_/B _5972_/A _6568_/A _6240_/A1 _4115_/A vddd vssd sg13cmos5l_a22oi_1
XFILLER_25_532 vddd vssd sg13cmos5l_decap_8
XFILLER_0_2284 vddd vssd sg13cmos5l_decap_8
XFILLER_25_576 vddd vssd sg13cmos5l_decap_8
XFILLER_16_1525 vddd vssd sg13cmos5l_decap_4
XFILLER_27_1632 vddd vssd sg13cmos5l_decap_8
XFILLER_27_1687 vddd vssd sg13cmos5l_decap_8
XFILLER_21_1242 vddd vssd sg13cmos5l_decap_8
XFILLER_18_70 vddd vssd sg13cmos5l_decap_8
Xtiedowns\[10\] _5733_/A vddd vssd sg13cmos5l_antennanp
XFILLER_16_543 vddd vssd sg13cmos5l_decap_8
XFILLER_19_1160 vddd vssd sg13cmos5l_decap_8
XFILLER_15_1046 vddd vssd sg13cmos5l_decap_8
XFILLER_15_1035 vddd vssd sg13cmos5l_decap_8
XFILLER_12_782 vddd vssd sg13cmos5l_decap_4
XFILLER_12_1923 vddd vssd sg13cmos5l_decap_8
X_4380_ _4390_/B _5623_/A _7132_/Q vddd vssd sg13cmos5l_xor2_1
XFILLER_10_2381 vddd vssd sg13cmos5l_decap_4
XFILLER_4_981 vddd vssd sg13cmos5l_decap_8
XFILLER_10_1680 vddd vssd sg13cmos5l_decap_8
X_6050_ _6050_/Y _6050_/A _6049_/Y vddd vssd sg13cmos5l_nor2b_1
X_5001_ _5012_/C _7274_/Q _7275_/Q _7276_/Q _7277_/Q vddd vssd sg13cmos5l_nor4_1
XFILLER_6_1225 vddd vssd sg13cmos5l_decap_8
XFILLER_19_392 vddd vssd sg13cmos5l_decap_8
X_6952_ _6952_/Y _6952_/A _6952_/B_N vddd vssd sg13cmos5l_nor2b_1
XFILLER_17_2513 vddd vssd sg13cmos5l_decap_8
X_6883_ _6883_/Y _6917_/A _6893_/B_N vddd vssd sg13cmos5l_nor2b_1
X_5903_ _5905_/B _7232_/Q _7233_/Q _5903_/C vddd vssd sg13cmos5l_nor3_1
XFILLER_22_513 vddd vssd sg13cmos5l_decap_8
XFILLER_17_1801 vddd vssd sg13cmos5l_decap_4
X_5834_ _5834_/Y _5837_/B _5832_/Y _5833_/Y vddd vssd sg13cmos5l_o21ai_1
XFILLER_14_28 vddd vssd sg13cmos5l_decap_8
X_5765_ _5765_/Y _5795_/A1 _5762_/Y _5763_/Y _5761_/Y _5764_/X vddd vssd sg13cmos5l_a221oi_1
X_5696_ _5696_/X _6224_/A _7205_/Q vddd vssd sg13cmos5l_or2_1
X_4716_ _4716_/Y _4757_/A _4444_/B _6012_/A vddd vssd sg13cmos5l_o21ai_1
XFILLER_30_16 vddd vssd sg13cmos5l_decap_8
X_4647_ _4647_/Y _4646_/Y _4647_/B vddd vssd sg13cmos5l_nand2b_1
XFILLER_11_2156 vddd vssd sg13cmos5l_decap_8
Xhold720 _7366_/D _4332_/Y vddd vssd sg13cmos5l_dlygate4sd3_1
X_7366_ _7366_/Q _7367_/CLK _7366_/D _6880_/Y vddd vssd sg13cmos5l_dfrbpq_1
X_4578_ _4581_/A _4578_/A _4577_/Y vddd vssd sg13cmos5l_nor2b_1
Xhold764 _7233_/D _6560_/X vddd vssd sg13cmos5l_dlygate4sd3_1
Xhold742 hold742/X _6382_/Y vddd vssd sg13cmos5l_dlygate4sd3_1
Xhold731 _7329_/D _4845_/Y vddd vssd sg13cmos5l_dlygate4sd3_1
X_6317_ _6317_/Y _6317_/A _6321_/B vddd vssd sg13cmos5l_nand2_1
Xhold753 _7362_/D _4344_/Y vddd vssd sg13cmos5l_dlygate4sd3_1
Xhold786 hold786/X _3606_/Y vddd vssd sg13cmos5l_dlygate4sd3_1
Xhold775 _4617_/B _4616_/Y vddd vssd sg13cmos5l_dlygate4sd3_1
Xhold797 hold797/X _7130_/Q vddd vssd sg13cmos5l_dlygate4sd3_1
X_3529_ _4396_/C _4431_/A vddd vssd sg13cmos5l_inv_1
X_7297_ _7297_/Q _7297_/CLK _7297_/D fanout377/X vddd vssd sg13cmos5l_dfrbpq_1
X_6248_ _6248_/Y _6156_/A _5254_/A _6250_/B vddd vssd sg13cmos5l_o21ai_1
XFILLER_29_112 vddd vssd sg13cmos5l_decap_8
X_6179_ _6179_/Y _6154_/A _6178_/A _6176_/Y _6178_/Y _5214_/C vddd vssd sg13cmos5l_a221oi_1
Xhold1420 hold1420/X _7286_/Q vddd vssd sg13cmos5l_dlygate4sd3_1
Xhold1431 hold1431/X _7172_/Q vddd vssd sg13cmos5l_dlygate4sd3_1
Xhold1442 _4794_/A2 _4793_/Y vddd vssd sg13cmos5l_dlygate4sd3_1
Xhold1464 hold1464/X _7346_/Q vddd vssd sg13cmos5l_dlygate4sd3_1
Xhold1475 _6776_/A0 _7081_/Q vddd vssd sg13cmos5l_dlygate4sd3_1
Xhold1486 _3621_/A _7079_/Q vddd vssd sg13cmos5l_dlygate4sd3_1
Xhold1453 _7335_/D _4773_/Y vddd vssd sg13cmos5l_dlygate4sd3_1
XFILLER_29_189 vddd vssd sg13cmos5l_decap_8
XFILLER_22_1595 vddd vssd sg13cmos5l_decap_8
Xhold1497 hold502/A _7009_/Q vddd vssd sg13cmos5l_dlygate4sd3_1
XFILLER_25_373 vddd vssd sg13cmos5l_decap_8
XFILLER_16_2023 vddd vssd sg13cmos5l_decap_8
XFILLER_0_1391 vddd vssd sg13cmos5l_decap_8
XFILLER_13_557 vddd vssd sg13cmos5l_decap_4
XFILLER_9_539 vddd vssd sg13cmos5l_decap_8
Xtiedowns\[58\] mask_rev_in[14] vddd vssd sg13cmos5l_antennanp
XFILLER_1_984 vddd vssd sg13cmos5l_decap_8
XFILLER_23_1337 vddd vssd sg13cmos5l_decap_8
XFILLER_7_1556 vddd vssd sg13cmos5l_decap_8
XFILLER_29_91 vddd vssd sg13cmos5l_decap_8
XFILLER_7_1589 vddd vssd sg13cmos5l_decap_8
XFILLER_21_1072 vddd vssd sg13cmos5l_decap_8
XFILLER_1_1111 vddd vssd sg13cmos5l_decap_4
XFILLER_32_822 vddd vssd sg13cmos5l_decap_8
X_3880_ _3881_/D _7293_/Q _6653_/A _6646_/A _7289_/Q vddd vssd sg13cmos5l_a22oi_1
XFILLER_32_899 vddd vssd sg13cmos5l_decap_8
X_5550_ _5550_/X _5627_/A _5557_/A vddd vssd sg13cmos5l_or2_1
X_4501_ _4501_/Y _4476_/Y _4501_/B vddd vssd sg13cmos5l_nand2b_1
X_5481_ _5495_/D _5498_/A _7175_/Q vddd vssd sg13cmos5l_nor2_1
XFILLER_12_2465 vddd vssd sg13cmos5l_decap_8
X_4432_ _4432_/Y _5947_/B _4432_/B vddd vssd sg13cmos5l_nand2_1
XFILLER_12_1775 vddd vssd sg13cmos5l_decap_8
X_7220_ _7220_/Q _7231_/CLK _7220_/D fanout365/X vddd vssd sg13cmos5l_dfrbpq_1
X_7151_ _7151_/Q _7171_/CLK _7151_/D _6819_/B_N vddd vssd sg13cmos5l_dfrbpq_1
X_4363_ _4363_/Y _4414_/A _7091_/Q vddd vssd sg13cmos5l_nand2b_1
X_7082_ _7082_/Q _7119_/CLK _7082_/D _6958_/B_N vddd vssd sg13cmos5l_dfrbpq_1
Xwire9 wire9/X wire9/A vddd vssd sg13cmos5l_buf_4
X_4294_ _4310_/C _4315_/A _4297_/A _4301_/A _5279_/B vddd vssd sg13cmos5l_nor4_1
XFILLER_8_1309 vddd vssd sg13cmos5l_decap_8
X_6102_ _6102_/Y _5542_/A _6122_/A2 _6101_/Y vddd vssd sg13cmos5l_o21ai_1
X_6033_ _6034_/A _6146_/A _5071_/A _5068_/A vddd vssd sg13cmos5l_o21ai_1
Xoutbuffers\[41\] bandgap_trim[2] _6287_/Y vddd vssd sg13cmos5l_buf_16
XFILLER_27_605 vddd vssd sg13cmos5l_decap_8
XFILLER_23_2594 vddd vssd sg13cmos5l_decap_8
XFILLER_26_104 vddd vssd sg13cmos5l_decap_8
XFILLER_25_16 vddd vssd sg13cmos5l_decap_8
X_6935_ _6935_/Y _6956_/A _6956_/B_N vddd vssd sg13cmos5l_nor2b_1
X_6866_ _6866_/Y _6870_/A _6870_/B_N vddd vssd sg13cmos5l_nor2b_1
XFILLER_23_899 vddd vssd sg13cmos5l_decap_8
X_6797_ _6797_/Y hold778/X _6803_/B _6796_/Y vddd vssd sg13cmos5l_o21ai_1
X_5817_ _5817_/Y _6230_/A _5812_/Y _5816_/Y vddd vssd sg13cmos5l_a21oi_1
XFILLER_30_2532 vddd vssd sg13cmos5l_decap_8
XFILLER_22_387 vddd vssd sg13cmos5l_decap_4
X_5748_ _5748_/Y _5748_/A _5748_/B _7212_/Q vddd vssd sg13cmos5l_nor3_1
X_5679_ _5679_/Y _5875_/A _5677_/Y _5678_/Y _5676_/Y _5651_/Y vddd vssd sg13cmos5l_a221oi_1
XFILLER_2_704 vddd vssd sg13cmos5l_decap_8
Xhold550 _4482_/A _6998_/Q vddd vssd sg13cmos5l_dlygate4sd3_1
X_7349_ _7349_/Q _7355_/CLK _7349_/D _6863_/Y vddd vssd sg13cmos5l_dfrbpq_1
Xhold572 _4182_/A _7389_/Q vddd vssd sg13cmos5l_dlygate4sd3_1
Xhold561 _7004_/D _6809_/X vddd vssd sg13cmos5l_dlygate4sd3_1
XFILLER_8_2522 vddd vssd sg13cmos5l_decap_8
XFILLER_28_2461 vddd vssd sg13cmos5l_decap_8
XFILLER_24_2314 vddd vssd sg13cmos5l_decap_4
Xhold594 hold594/X _4328_/Y vddd vssd sg13cmos5l_dlygate4sd3_1
Xhold583 hold583/X _4089_/Y vddd vssd sg13cmos5l_dlygate4sd3_1
XFILLER_24_2347 vddd vssd sg13cmos5l_decap_4
XFILLER_24_1646 vddd vssd sg13cmos5l_decap_8
XFILLER_8_2599 vddd vssd sg13cmos5l_decap_8
Xhold1250 _6751_/A1 _7065_/Q vddd vssd sg13cmos5l_dlygate4sd3_1
Xhold1261 _4970_/A _4969_/Y vddd vssd sg13cmos5l_dlygate4sd3_1
Xhold1294 _3568_/A _7196_/Q vddd vssd sg13cmos5l_dlygate4sd3_1
XFILLER_22_2093 vddd vssd sg13cmos5l_decap_8
XFILLER_22_1370 vddd vssd sg13cmos5l_decap_8
Xhold1283 _6784_/A _4659_/A1 vddd vssd sg13cmos5l_dlygate4sd3_1
Xhold1272 _7292_/D _6657_/X vddd vssd sg13cmos5l_dlygate4sd3_1
XFILLER_2_1453 vddd vssd sg13cmos5l_decap_8
XFILLER_18_2118 vddd vssd sg13cmos5l_decap_8
XFILLER_14_833 vddd vssd sg13cmos5l_decap_4
XFILLER_14_899 vddd vssd sg13cmos5l_decap_8
XFILLER_31_1606 vddd vssd sg13cmos5l_decap_4
XFILLER_0_291 vddd vssd sg13cmos5l_decap_8
XFILLER_7_1331 vddd vssd sg13cmos5l_decap_8
XFILLER_23_1134 vddd vssd sg13cmos5l_decap_8
XFILLER_3_1228 vddd vssd sg13cmos5l_decap_4
XFILLER_7_1386 vddd vssd sg13cmos5l_decap_8
XFILLER_23_1178 vddd vssd sg13cmos5l_decap_8
X_4981_ sram_read _4979_/B _7368_/Q _5988_/A vddd vssd sg13cmos5l_a21o_1
XFILLER_32_641 vddd vssd sg13cmos5l_decap_8
X_6720_ _7045_/D _6748_/A1 _6725_/S _6720_/B1 vddd vssd sg13cmos5l_a21oi_1
X_3932_ _3932_/Y _3923_/Y _3926_/Y _3931_/Y vddd vssd sg13cmos5l_o21ai_1
X_6651_ _6651_/Y _6651_/A1 _6652_/S _6650_/Y vddd vssd sg13cmos5l_o21ai_1
X_3863_ _3863_/Y _3863_/A _3863_/B vddd vssd sg13cmos5l_nand2_1
XFILLER_14_2505 vddd vssd sg13cmos5l_decap_8
XFILLER_31_184 vddd vssd sg13cmos5l_decap_8
X_5602_ _5602_/Y _5319_/A _7193_/Q _5600_/Y vddd vssd sg13cmos5l_o21ai_1
XFILLER_18_1984 vddd vssd sg13cmos5l_decap_4
X_6582_ _7245_/D _6582_/A1 _6581_/B _6581_/Y vddd vssd sg13cmos5l_a21oi_1
X_3794_ _3802_/A _7037_/Q _6696_/A _4189_/B1 _7295_/Q vddd vssd sg13cmos5l_a22oi_1
X_5533_ _5533_/Y _5590_/A1 _5508_/X _5532_/Y vddd vssd sg13cmos5l_a21oi_1
X_5464_ _5464_/X _5464_/A _5472_/B vddd vssd sg13cmos5l_or2_1
Xoutbuffers\[89\] io_out[4] _6100_/Y vddd vssd sg13cmos5l_buf_16
X_5395_ _5395_/Y _5590_/A1 _5394_/A _5392_/Y _5394_/Y vddd vssd sg13cmos5l_a22oi_1
X_7203_ _7203_/Q _7301_/CLK _7203_/D fanout369/X vddd vssd sg13cmos5l_dfrbpq_1
X_4415_ _4415_/Y _4419_/A _4415_/B _4415_/C vddd vssd sg13cmos5l_nor3_1
Xfanout304 _5389_/A hold1339/X vddd vssd sg13cmos5l_buf_1
XFILLER_25_2601 vddd vssd sg13cmos5l_decap_4
X_7134_ _7134_/Q _7135_/CLK _7134_/D _6958_/B_N vddd vssd sg13cmos5l_dfrbpq_1
X_4346_ _4346_/Y _4346_/A _4346_/B vddd vssd sg13cmos5l_nor2_1
Xfanout337 _6667_/A1 _3465_/Y vddd vssd sg13cmos5l_buf_1
XFILLER_25_1922 vddd vssd sg13cmos5l_decap_8
Xfanout326 _6230_/A _3543_/Y vddd vssd sg13cmos5l_buf_1
Xfanout315 _6263_/A1 _4115_/B vddd vssd sg13cmos5l_buf_1
Xfanout348 _6914_/B_N _6913_/B_N vddd vssd sg13cmos5l_buf_1
X_7065_ _7065_/Q _7077_/CLK _7065_/D fanout352/X vddd vssd sg13cmos5l_dfrbpq_1
Xfanout359 fanout359/X fanout361/X vddd vssd sg13cmos5l_buf_1
X_4277_ _4277_/X _6722_/A _6408_/A _4279_/B vddd vssd sg13cmos5l_mux2_1
X_6016_ _6017_/B _6263_/A1 _5024_/C _5032_/A vddd vssd sg13cmos5l_a21oi_1
XFILLER_3_1795 vddd vssd sg13cmos5l_decap_4
X_6918_ _6918_/Y _6965_/A _6945_/B_N vddd vssd sg13cmos5l_nor2b_1
XFILLER_23_674 vddd vssd sg13cmos5l_decap_8
X_6849_ _6849_/Y _6962_/A _6957_/B_N vddd vssd sg13cmos5l_nor2b_1
XFILLER_17_2184 vddd vssd sg13cmos5l_decap_4
XFILLER_13_2026 vddd vssd sg13cmos5l_decap_8
XFILLER_32_1937 vddd vssd sg13cmos5l_decap_8
XFILLER_17_1472 vddd vssd sg13cmos5l_decap_8
XFILLER_6_306 vddd vssd sg13cmos5l_decap_8
XFILLER_13_1336 vddd vssd sg13cmos5l_decap_4
XFILLER_26_2409 vddd vssd sg13cmos5l_decap_8
XFILLER_11_1071 vddd vssd sg13cmos5l_decap_4
Xclkbuf_3_3_0_SCK_regs clkload5/A clkbuf_0_SCK_regs/X vddd vssd sg13cmos5l_buf_8
XFILLER_24_2100 vddd vssd sg13cmos5l_decap_8
XFILLER_24_2188 vddd vssd sg13cmos5l_decap_4
XFILLER_24_1465 vddd vssd sg13cmos5l_decap_8
XFILLER_4_2249 vddd vssd sg13cmos5l_decap_8
Xhold1091 _7209_/D _6513_/Y vddd vssd sg13cmos5l_dlygate4sd3_1
Xhold1080 _6427_/A1 _7163_/Q vddd vssd sg13cmos5l_dlygate4sd3_1
XFILLER_18_1203 vddd vssd sg13cmos5l_decap_8
XFILLER_14_652 vddd vssd sg13cmos5l_decap_8
X_4200_ _4200_/Y _5245_/A _6590_/A _6583_/A vddd vssd sg13cmos5l_o21ai_1
X_5180_ _6144_/B _5267_/A _5180_/B vddd vssd sg13cmos5l_nand2b_1
X_4131_ _4131_/Y _7199_/Q _6490_/A _6483_/A vddd vssd sg13cmos5l_a21oi_1
Xclkbuf_regs_1_SCK clkbuf_regs_1_SCK/X SCK vddd vssd sg13cmos5l_buf_8
X_4062_ _4062_/Y _4004_/Y _4061_/Y _6736_/A vddd vssd sg13cmos5l_o21ai_1
XFILLER_7_1150 vddd vssd sg13cmos5l_decap_8
XFILLER_20_2542 vddd vssd sg13cmos5l_decap_8
XFILLER_3_1069 vddd vssd sg13cmos5l_decap_8
Xwire14 wire14/X wire14/A vddd vssd sg13cmos5l_buf_4
XFILLER_0_1957 vddd vssd sg13cmos5l_decap_8
X_4964_ _4964_/X _4964_/A _4964_/B _4964_/C vddd vssd sg13cmos5l_and3_1
X_6703_ _6703_/Y _6703_/A _6706_/S vddd vssd sg13cmos5l_nor2_1
X_3915_ _3915_/Y _5901_/D _3911_/Y _3914_/Y vddd vssd sg13cmos5l_o21ai_1
XFILLER_32_482 vddd vssd sg13cmos5l_decap_8
XFILLER_20_633 vddd vssd sg13cmos5l_decap_8
XFILLER_18_2493 vddd vssd sg13cmos5l_decap_8
X_4895_ _4895_/Y _4895_/A _4895_/B _4895_/C vddd vssd sg13cmos5l_nor3_1
X_6634_ _6634_/Y _6634_/A _6639_/S vddd vssd sg13cmos5l_nor2_1
XFILLER_22_28 vddd vssd sg13cmos5l_decap_8
XFILLER_18_1781 vddd vssd sg13cmos5l_decap_8
X_3846_ _6779_/A _3846_/A _6395_/A vddd vssd sg13cmos5l_nor2_1
XFILLER_14_1634 vddd vssd sg13cmos5l_decap_8
X_3777_ _3777_/Y _7134_/Q _3842_/B _3776_/Y vddd vssd sg13cmos5l_a21oi_1
X_6565_ _6565_/Y _6565_/A1 _6567_/S _6564_/Y vddd vssd sg13cmos5l_a21oi_1
X_6496_ _6496_/Y _6552_/A _6496_/B vddd vssd sg13cmos5l_nor2_1
X_5516_ _5516_/Y _5807_/A1 _5518_/B _5514_/Y _7180_/Q _5515_/Y vddd vssd sg13cmos5l_a221oi_1
X_5447_ _5447_/Y _5416_/A _5445_/Y _5446_/Y _5444_/Y _5419_/Y vddd vssd sg13cmos5l_a221oi_1
X_5378_ _5378_/Y _7335_/Q _5374_/B vddd vssd sg13cmos5l_nor2b_1
Xfanout101 _3984_/B _3712_/Y vddd vssd sg13cmos5l_buf_1
Xfanout112 _3786_/A _3683_/A vddd vssd sg13cmos5l_buf_1
XFILLER_25_2475 vddd vssd sg13cmos5l_decap_8
XFILLER_25_1730 vddd vssd sg13cmos5l_decap_8
X_7117_ _7117_/Q _7119_/CLK _7117_/D _6966_/B_N vddd vssd sg13cmos5l_dfrbpq_1
Xfanout134 _4010_/C _3705_/Y vddd vssd sg13cmos5l_buf_1
X_4329_ _4330_/B _4329_/A _4339_/C vddd vssd sg13cmos5l_nor2_1
Xfanout156 _4355_/B _4321_/Y vddd vssd sg13cmos5l_buf_1
Xfanout123 _6726_/B _6779_/B vddd vssd sg13cmos5l_buf_1
X_7048_ _7048_/Q _7367_/CLK _7048_/D fanout346/X vddd vssd sg13cmos5l_dfrbpq_1
Xfanout189 _6722_/A fanout198/X vddd vssd sg13cmos5l_buf_1
XFILLER_5_2547 vddd vssd sg13cmos5l_decap_8
Xfanout167 _4342_/A hold1046/X vddd vssd sg13cmos5l_buf_1
XFILLER_9_1993 vddd vssd sg13cmos5l_decap_8
Xfanout178 _6732_/A _7384_/Q vddd vssd sg13cmos5l_buf_1
XFILLER_21_1638 vddd vssd sg13cmos5l_decap_8
XFILLER_27_254 vddd vssd sg13cmos5l_decap_8
XFILLER_15_438 vddd vssd sg13cmos5l_decap_8
XFILLER_32_2446 vddd vssd sg13cmos5l_decap_8
XFILLER_6_103 vddd vssd sg13cmos5l_decap_8
XFILLER_32_1789 vddd vssd sg13cmos5l_decap_8
XFILLER_12_72 vddd vssd sg13cmos5l_decap_8
XFILLER_5_0 vddd vssd sg13cmos5l_decap_8
Xtiedowns\[40\] dbus_in_right[8] vddd vssd sg13cmos5l_antennanp
XFILLER_3_876 vddd vssd sg13cmos5l_decap_8
XFILLER_24_1240 vddd vssd sg13cmos5l_decap_8
XFILLER_20_1159 vddd vssd sg13cmos5l_decap_8
XFILLER_19_777 vddd vssd sg13cmos5l_decap_8
Xclkbuf_leaf_1_SCK_regs _7403_/CLK clkbuf_3_0_0_SCK_regs/X vddd vssd sg13cmos5l_buf_8
X_3700_ _3835_/B _3753_/C _3753_/D vddd vssd sg13cmos5l_nor2b_1
X_4680_ _4680_/Y _4680_/A _4680_/B vddd vssd sg13cmos5l_nor2_1
XFILLER_30_997 vddd vssd sg13cmos5l_decap_8
X_3631_ _3631_/Y _6898_/A _6916_/B_N vddd vssd sg13cmos5l_nor2b_1
X_3562_ _5518_/B _3562_/A vddd vssd sg13cmos5l_inv_1
X_6350_ _7121_/D _6788_/A1 _6361_/B hold658/X vddd vssd sg13cmos5l_o21ai_1
X_5301_ _5302_/D _7146_/Q _7147_/Q _5308_/D _5727_/A vddd vssd sg13cmos5l_nor4_1
X_6281_ _6291_/B _7079_/Q _7080_/Q _7082_/Q vddd vssd sg13cmos5l_nor3_1
X_3493_ _3493_/Y _5988_/A vddd vssd sg13cmos5l_inv_1
X_5232_ _5237_/C _5232_/A _5241_/B vddd vssd sg13cmos5l_nand2_1
XFILLER_9_1212 vddd vssd sg13cmos5l_decap_8
X_5163_ _6136_/B _6049_/C _5179_/B vddd vssd sg13cmos5l_nand2_1
X_4114_ _4114_/X dbus_in_left[9] dbus_in_right[9] vddd vssd sg13cmos5l_or2_1
X_5094_ _6074_/B _5130_/A _7247_/Q _6049_/B vddd vssd sg13cmos5l_nand3_1
X_4045_ _4045_/Y _5613_/A _6475_/A _4043_/Y _4044_/Y _6468_/A vddd vssd sg13cmos5l_a221oi_1
XFILLER_17_28 vddd vssd sg13cmos5l_decap_8
XFILLER_0_2422 vddd vssd sg13cmos5l_decap_8
XFILLER_4_2580 vddd vssd sg13cmos5l_decap_8
XFILLER_25_703 vddd vssd sg13cmos5l_decap_4
XFILLER_20_2372 vddd vssd sg13cmos5l_decap_8
XFILLER_20_1660 vddd vssd sg13cmos5l_decap_8
XFILLER_25_736 vddd vssd sg13cmos5l_decap_8
X_5996_ _5996_/Y _5008_/C _5994_/Y _5995_/Y vddd vssd sg13cmos5l_o21ai_1
X_4947_ _4947_/Y _4943_/B _4946_/Y _4945_/Y vddd vssd sg13cmos5l_o21ai_1
X_4878_ _4895_/A _4925_/A _7140_/Q vddd vssd sg13cmos5l_and2_1
X_3829_ _3829_/Y _7081_/Q wire70/X _6746_/A _7066_/Q _4244_/A2 vddd vssd sg13cmos5l_a221oi_1
XFILLER_20_485 vddd vssd sg13cmos5l_decap_4
XFILLER_20_463 vddd vssd sg13cmos5l_decap_8
X_6617_ _7266_/D _6635_/A1 _6620_/S hold967/X vddd vssd sg13cmos5l_a21oi_1
XFILLER_14_1431 vddd vssd sg13cmos5l_decap_8
XFILLER_20_496 vddd vssd sg13cmos5l_decap_8
X_6548_ _6548_/Y _6690_/A _6552_/B vddd vssd sg13cmos5l_nor2_1
X_6479_ _6479_/Y _6479_/A1 _6481_/B _6478_/Y vddd vssd sg13cmos5l_a21oi_1
XFILLER_27_2548 vddd vssd sg13cmos5l_decap_8
XFILLER_27_1814 vddd vssd sg13cmos5l_decap_8
XFILLER_27_1847 vddd vssd sg13cmos5l_decap_4
XFILLER_0_868 vddd vssd sg13cmos5l_decap_8
XFILLER_25_1571 vddd vssd sg13cmos5l_decap_8
XFILLER_21_2136 vddd vssd sg13cmos5l_decap_8
XFILLER_28_563 vddd vssd sg13cmos5l_decap_8
XFILLER_16_725 vddd vssd sg13cmos5l_decap_8
XFILLER_5_1687 vddd vssd sg13cmos5l_decap_4
XFILLER_31_706 vddd vssd sg13cmos5l_decap_8
XFILLER_19_1320 vddd vssd sg13cmos5l_decap_8
XFILLER_30_205 vddd vssd sg13cmos5l_decap_8
XFILLER_32_2254 vddd vssd sg13cmos5l_decap_8
XFILLER_32_1597 vddd vssd sg13cmos5l_decap_8
XFILLER_3_640 vddd vssd sg13cmos5l_decap_8
XFILLER_10_2596 vddd vssd sg13cmos5l_decap_8
XFILLER_31_7 vddd vssd sg13cmos5l_decap_4
XFILLER_24_1070 vddd vssd sg13cmos5l_decap_8
XFILLER_0_42 vddd vssd sg13cmos5l_decap_8
XFILLER_4_1164 vddd vssd sg13cmos5l_decap_4
XFILLER_0_97 vddd vssd sg13cmos5l_decap_8
X_5850_ _5850_/Y _5842_/A _5848_/A _5848_/X _5875_/A _5849_/Y vddd vssd sg13cmos5l_a221oi_1
XFILLER_21_216 vddd vssd sg13cmos5l_decap_4
X_5781_ _5787_/C _5791_/B _5794_/A vddd vssd sg13cmos5l_nand2b_1
X_4801_ _4802_/B _4815_/A _3594_/Y _4800_/Y vddd vssd sg13cmos5l_a21oi_1
XFILLER_15_2430 vddd vssd sg13cmos5l_decap_8
X_4732_ _4732_/Y _4743_/A _4732_/B vddd vssd sg13cmos5l_nand2_1
X_4663_ _4663_/Y _4663_/A _4663_/B vddd vssd sg13cmos5l_nand2_1
XFILLER_11_2327 vddd vssd sg13cmos5l_decap_4
X_3614_ _6285_/A _3614_/A vddd vssd sg13cmos5l_inv_1
X_6402_ _6408_/B _6402_/A _6753_/B vddd vssd sg13cmos5l_nand2_1
XFILLER_15_1773 vddd vssd sg13cmos5l_decap_4
X_4594_ _4594_/X _4382_/A _4732_/B _4593_/Y vddd vssd sg13cmos5l_a21o_1
Xhold913 _5928_/A _3652_/C vddd vssd sg13cmos5l_dlygate4sd3_1
Xhold902 _7218_/D _6531_/Y vddd vssd sg13cmos5l_dlygate4sd3_1
X_7382_ _7382_/Q _7403_/CLK _7382_/D _6896_/Y vddd vssd sg13cmos5l_dfrbpq_1
X_6333_ _6333_/Y _6333_/A1 _6344_/B _6332_/Y vddd vssd sg13cmos5l_o21ai_1
Xhold935 _3547_/A _7151_/Q vddd vssd sg13cmos5l_dlygate4sd3_1
Xhold946 _3600_/A _7111_/Q vddd vssd sg13cmos5l_dlygate4sd3_1
Xhold924 _7379_/D _4283_/X vddd vssd sg13cmos5l_dlygate4sd3_1
X_3545_ _3545_/Y _5530_/A vddd vssd sg13cmos5l_inv_1
XFILLER_11_1659 vddd vssd sg13cmos5l_decap_4
Xoutbuffers\[71\] idac1_value[3] _7043_/Q vddd vssd sg13cmos5l_buf_16
X_3476_ _3476_/Y _3476_/A vddd vssd sg13cmos5l_inv_1
Xhold979 hold979/X _6499_/Y vddd vssd sg13cmos5l_dlygate4sd3_1
Xhold957 hold957/X _6622_/Y vddd vssd sg13cmos5l_dlygate4sd3_1
X_6264_ _6264_/Y _5269_/B _6263_/Y _5260_/B vddd vssd sg13cmos5l_a21oi_1
Xhold968 _6780_/A _7083_/Q vddd vssd sg13cmos5l_dlygate4sd3_1
X_5215_ _5216_/D _5215_/A _5215_/B vddd vssd sg13cmos5l_nand2_1
XFILLER_26_2570 vddd vssd sg13cmos5l_decap_8
X_6195_ _6195_/Y _6088_/A _5234_/C _5229_/Y vddd vssd sg13cmos5l_o21ai_1
XFILLER_28_16 vddd vssd sg13cmos5l_decap_8
X_5146_ _5148_/C _6188_/B _6145_/C vddd vssd sg13cmos5l_nor2_1
XFILLER_22_2478 vddd vssd sg13cmos5l_decap_8
X_5077_ _5263_/A _7254_/Q _7255_/Q vddd vssd sg13cmos5l_nand2_1
X_4028_ _4028_/X dbus_in_left[10] dbus_in_right[10] vddd vssd sg13cmos5l_or2_1
XFILLER_0_2241 vddd vssd sg13cmos5l_decap_8
XFILLER_25_555 vddd vssd sg13cmos5l_decap_8
X_5979_ _5979_/X hold916/X _3753_/D _5991_/S vddd vssd sg13cmos5l_mux2_1
XFILLER_0_1595 vddd vssd sg13cmos5l_decap_8
XFILLER_16_1559 vddd vssd sg13cmos5l_decap_8
XFILLER_21_794 vddd vssd sg13cmos5l_decap_8
XFILLER_10_1158 vddd vssd sg13cmos5l_decap_8
XFILLER_10_1169 vddd vssd sg13cmos5l_decap_8
XFILLER_23_2209 vddd vssd sg13cmos5l_decap_8
XFILLER_23_1519 vddd vssd sg13cmos5l_decap_8
XFILLER_1_2027 vddd vssd sg13cmos5l_decap_8
XFILLER_5_2185 vddd vssd sg13cmos5l_decap_8
XFILLER_1_1359 vddd vssd sg13cmos5l_decap_8
XFILLER_12_794 vddd vssd sg13cmos5l_decap_8
XFILLER_32_1394 vddd vssd sg13cmos5l_decap_8
X_5000_ _5009_/B _7282_/Q _7283_/Q _7284_/Q _7285_/Q vddd vssd sg13cmos5l_nor4_1
XFILLER_22_1029 vddd vssd sg13cmos5l_decap_8
X_6951_ _6951_/Y _6951_/A _6952_/B_N vddd vssd sg13cmos5l_nor2b_1
X_6882_ _6882_/Y _6898_/A _6916_/B_N vddd vssd sg13cmos5l_nor2b_1
X_5902_ _5903_/C _5875_/A _5878_/Y _5889_/A _5733_/A vddd vssd sg13cmos5l_a22oi_1
X_5833_ _5833_/Y _3541_/Y _3920_/A _5831_/Y _5837_/B vddd vssd sg13cmos5l_a22oi_1
XFILLER_17_2569 vddd vssd sg13cmos5l_decap_8
X_5764_ _5764_/X _5764_/A _5764_/B vddd vssd sg13cmos5l_and2_1
X_5695_ _5695_/Y _5693_/Y _5694_/Y _5690_/Y vddd vssd sg13cmos5l_a21oi_1
X_4715_ _4715_/Y _4694_/B _4713_/B _4745_/A1 vddd vssd sg13cmos5l_o21ai_1
XFILLER_11_2135 vddd vssd sg13cmos5l_decap_8
X_4646_ _4646_/Y _4575_/A _4642_/Y _4645_/Y vddd vssd sg13cmos5l_a21oi_1
X_4577_ _4577_/Y _4577_/A _4577_/B vddd vssd sg13cmos5l_nand2_1
Xhold710 _6393_/A _7145_/Q vddd vssd sg13cmos5l_dlygate4sd3_1
X_7365_ _7365_/Q _7367_/CLK _7365_/D _6879_/Y vddd vssd sg13cmos5l_dfrbpq_1
Xhold721 _6391_/A _7144_/Q vddd vssd sg13cmos5l_dlygate4sd3_1
Xhold732 _6378_/A _7138_/Q vddd vssd sg13cmos5l_dlygate4sd3_1
Xhold743 _4309_/A _7380_/Q vddd vssd sg13cmos5l_dlygate4sd3_1
Xhold754 _6794_/A _7090_/Q vddd vssd sg13cmos5l_dlygate4sd3_1
X_6316_ _6316_/Y hold807/X _6327_/B _6315_/Y vddd vssd sg13cmos5l_o21ai_1
XFILLER_11_1489 vddd vssd sg13cmos5l_decap_8
Xhold765 _5939_/A _6976_/Q vddd vssd sg13cmos5l_dlygate4sd3_1
Xhold776 _7342_/D _4617_/Y vddd vssd sg13cmos5l_dlygate4sd3_1
Xhold787 _5933_/A _6974_/Q vddd vssd sg13cmos5l_dlygate4sd3_1
X_3528_ _3528_/Y _5942_/A vddd vssd sg13cmos5l_inv_1
X_7296_ _7296_/Q _7296_/CLK _7296_/D fanout375/X vddd vssd sg13cmos5l_dfrbpq_1
Xhold798 _7130_/D _6367_/X vddd vssd sg13cmos5l_dlygate4sd3_1
X_6247_ _6247_/Y _5241_/A _5241_/B _5250_/A _3797_/X vddd vssd sg13cmos5l_a22oi_1
Xhold1410 hold1410/X _7195_/Q vddd vssd sg13cmos5l_dlygate4sd3_1
X_6178_ _6178_/Y _6178_/A _6178_/B vddd vssd sg13cmos5l_nor2_1
Xhold1421 _6647_/A _5212_/A vddd vssd sg13cmos5l_dlygate4sd3_1
Xhold1432 _6443_/A1 _5465_/B vddd vssd sg13cmos5l_dlygate4sd3_1
Xhold1443 _4730_/A _7337_/Q vddd vssd sg13cmos5l_dlygate4sd3_1
XFILLER_6_2494 vddd vssd sg13cmos5l_decap_8
X_5129_ _5144_/B _7249_/Q _7248_/Q vddd vssd sg13cmos5l_nand2b_1
XFILLER_29_168 vddd vssd sg13cmos5l_decap_8
Xhold1476 _7081_/D _6776_/X vddd vssd sg13cmos5l_dlygate4sd3_1
Xhold1465 _7346_/D _4523_/X vddd vssd sg13cmos5l_dlygate4sd3_1
XFILLER_22_1530 vddd vssd sg13cmos5l_decap_8
Xhold1454 hold1454/X _7383_/Q vddd vssd sg13cmos5l_dlygate4sd3_1
Xhold1498 hold503/A _7013_/Q vddd vssd sg13cmos5l_dlygate4sd3_1
Xhold1487 hold1487/X _7084_/Q vddd vssd sg13cmos5l_dlygate4sd3_1
XFILLER_0_2093 vddd vssd sg13cmos5l_decap_8
XFILLER_16_2046 vddd vssd sg13cmos5l_decap_4
XFILLER_14_1091 vddd vssd sg13cmos5l_decap_4
XFILLER_29_2429 vddd vssd sg13cmos5l_decap_8
XFILLER_23_2017 vddd vssd sg13cmos5l_decap_8
XFILLER_1_941 vddd vssd sg13cmos5l_decap_4
XFILLER_7_1546 vddd vssd sg13cmos5l_decap_4
XFILLER_29_70 vddd vssd sg13cmos5l_decap_8
XFILLER_0_495 vddd vssd sg13cmos5l_decap_4
XFILLER_16_330 vddd vssd sg13cmos5l_decap_8
XFILLER_32_801 vddd vssd sg13cmos5l_decap_8
XFILLER_17_1109 vddd vssd sg13cmos5l_decap_8
XFILLER_32_878 vddd vssd sg13cmos5l_decap_8
X_4500_ _4500_/Y _4499_/Y _4806_/A vddd vssd sg13cmos5l_nand2b_1
X_5480_ _5480_/Y _7174_/Q _7175_/Q _5498_/C _7177_/Q vddd vssd sg13cmos5l_nor4_1
X_4431_ _4431_/Y _4431_/A _5947_/B vddd vssd sg13cmos5l_nor2b_1
XANTENNA_1 SDI vddd vssd sg13cmos5l_antennanp
XFILLER_6_30 vddd vssd sg13cmos5l_decap_8
X_7150_ _7150_/Q _7386_/CLK _7150_/D _6819_/B_N vddd vssd sg13cmos5l_dfrbpq_1
X_4362_ _4362_/Y _7090_/Q _4416_/A _4400_/B _7089_/Q vddd vssd sg13cmos5l_a22oi_1
XFILLER_6_96 vddd vssd sg13cmos5l_decap_8
X_7081_ _7081_/Q _7276_/CLK _7081_/D fanout392/X vddd vssd sg13cmos5l_dfrbpq_1
X_4293_ _4297_/B _4315_/A _4305_/A _4293_/C _4308_/A vddd vssd sg13cmos5l_nor4_1
X_6101_ _6101_/Y _6012_/A _6122_/A2 _6167_/B1 vddd vssd sg13cmos5l_a21oi_1
X_6032_ _6032_/Y _6239_/A _5069_/A _5071_/A vddd vssd sg13cmos5l_o21ai_1
XFILLER_20_0 vddd vssd sg13cmos5l_decap_8
XFILLER_6_1034 vddd vssd sg13cmos5l_decap_8
XFILLER_23_2573 vddd vssd sg13cmos5l_decap_8
Xoutbuffers\[34\] bandgap_sink1[2] _7064_/Q vddd vssd sg13cmos5l_buf_16
X_6934_ _6934_/Y _6954_/A _6954_/B_N vddd vssd sg13cmos5l_nor2b_1
XFILLER_17_2300 vddd vssd sg13cmos5l_decap_4
XFILLER_22_333 vddd vssd sg13cmos5l_decap_4
XFILLER_17_2333 vddd vssd sg13cmos5l_decap_8
X_6865_ _6865_/Y _6870_/A _6865_/B_N vddd vssd sg13cmos5l_nor2b_1
XFILLER_13_2208 vddd vssd sg13cmos5l_decap_8
X_6796_ _6796_/Y _6796_/A _6803_/B vddd vssd sg13cmos5l_nand2_1
X_5816_ _5816_/Y _5816_/A _5819_/B vddd vssd sg13cmos5l_nor2b_1
XFILLER_30_2511 vddd vssd sg13cmos5l_decap_8
XFILLER_17_2399 vddd vssd sg13cmos5l_decap_8
X_5747_ _5747_/Y _5760_/C _5746_/Y _5762_/A vddd vssd sg13cmos5l_o21ai_1
XFILLER_15_2090 vddd vssd sg13cmos5l_decap_4
XFILLER_30_2588 vddd vssd sg13cmos5l_decap_8
X_5678_ _5678_/Y _5873_/A _5674_/Y _5677_/Y vddd vssd sg13cmos5l_a21oi_1
XFILLER_30_1876 vddd vssd sg13cmos5l_decap_4
X_4629_ _4629_/Y _4169_/A _4604_/Y _4758_/B1 vddd vssd sg13cmos5l_a21oi_1
XFILLER_11_1253 vddd vssd sg13cmos5l_decap_8
Xhold540 _6811_/A _6994_/Q vddd vssd sg13cmos5l_dlygate4sd3_1
XFILLER_28_2440 vddd vssd sg13cmos5l_decap_8
Xhold551 _6999_/D _3477_/Y vddd vssd sg13cmos5l_dlygate4sd3_1
X_7348_ _7348_/Q _7348_/CLK _7348_/D _6862_/Y vddd vssd sg13cmos5l_dfrbpq_1
Xhold562 _4765_/A _7006_/Q vddd vssd sg13cmos5l_dlygate4sd3_1
XFILLER_8_2501 vddd vssd sg13cmos5l_decap_8
XFILLER_9_7 vddd vssd sg13cmos5l_decap_8
X_7279_ _7279_/Q _7285_/CLK _7279_/D fanout383/X vddd vssd sg13cmos5l_dfrbpq_1
Xhold595 _7367_/D _4331_/Y vddd vssd sg13cmos5l_dlygate4sd3_1
Xhold584 _7391_/D _4090_/Y vddd vssd sg13cmos5l_dlygate4sd3_1
Xhold573 hold573/X _4182_/Y vddd vssd sg13cmos5l_dlygate4sd3_1
XFILLER_8_2578 vddd vssd sg13cmos5l_decap_8
Xhold1251 _7065_/D _6751_/X vddd vssd sg13cmos5l_dlygate4sd3_1
Xhold1240 _6559_/A1 _5886_/C vddd vssd sg13cmos5l_dlygate4sd3_1
XFILLER_17_105 vddd vssd sg13cmos5l_decap_8
Xhold1284 _7085_/D _6785_/Y vddd vssd sg13cmos5l_dlygate4sd3_1
Xhold1273 _6656_/A0 _7291_/Q vddd vssd sg13cmos5l_dlygate4sd3_1
Xhold1262 _3516_/A _7251_/Q vddd vssd sg13cmos5l_dlygate4sd3_1
Xhold1295 _6488_/A1 _3568_/Y vddd vssd sg13cmos5l_dlygate4sd3_1
XFILLER_32_119 vddd vssd sg13cmos5l_decap_8
XFILLER_14_878 vddd vssd sg13cmos5l_decap_8
XFILLER_16_1153 vddd vssd sg13cmos5l_decap_8
XFILLER_13_399 vddd vssd sg13cmos5l_decap_4
Xtiedowns\[70\] mask_rev_in[26] vddd vssd sg13cmos5l_antennanp
XFILLER_5_521 vddd vssd sg13cmos5l_decap_8
XFILLER_31_93 vddd vssd sg13cmos5l_decap_8
XFILLER_5_576 vddd vssd sg13cmos5l_decap_4
XFILLER_7_2000 vddd vssd sg13cmos5l_decap_8
XFILLER_0_270 vddd vssd sg13cmos5l_decap_8
XFILLER_7_1365 vddd vssd sg13cmos5l_decap_8
XFILLER_23_119 vddd vssd sg13cmos5l_decap_8
X_4980_ sram_write _7388_/Q _4980_/B vddd vssd sg13cmos5l_and2_1
X_3931_ _3931_/Y _7213_/Q _6514_/A _3929_/Y vddd vssd sg13cmos5l_a21oi_1
X_6650_ _6650_/Y _6650_/A _6652_/S vddd vssd sg13cmos5l_nand2_1
X_3862_ _3862_/Y _3862_/A _4182_/B vddd vssd sg13cmos5l_nand2_1
XFILLER_32_697 vddd vssd sg13cmos5l_decap_8
XFILLER_31_163 vddd vssd sg13cmos5l_decap_8
X_5601_ _5601_/Y _5748_/A _5601_/B _5613_/A vddd vssd sg13cmos5l_nor3_1
XFILLER_18_1963 vddd vssd sg13cmos5l_decap_8
X_6581_ _6581_/Y _6581_/A _6581_/B vddd vssd sg13cmos5l_nor2_1
X_6970__475 _7023_/CLK _7380_/CLK vddd vssd sg13cmos5l_inv_1
X_3793_ _3793_/Y _3793_/A _4182_/B vddd vssd sg13cmos5l_nand2_1
X_5532_ _5532_/Y _5502_/A _5531_/A _5531_/Y _5528_/Y _5508_/X vddd vssd sg13cmos5l_a221oi_1
X_5463_ _5467_/B _5475_/C _5468_/C vddd vssd sg13cmos5l_nor2_1
X_5394_ _5394_/Y _5394_/A _5393_/Y vddd vssd sg13cmos5l_nor2b_1
X_7202_ _7202_/Q _7301_/CLK _7202_/D fanout369/X vddd vssd sg13cmos5l_dfrbpq_1
X_4414_ _4414_/Y _4414_/A _4417_/B vddd vssd sg13cmos5l_nor2_1
X_7133_ _7133_/Q _7273_/CLK _7133_/D fanout390/X vddd vssd sg13cmos5l_dfrbpq_1
X_4345_ _4346_/B _4348_/A _4323_/C _4355_/B vddd vssd sg13cmos5l_o21ai_1
Xfanout305 _5348_/B hold1387/X vddd vssd sg13cmos5l_buf_1
Xfanout316 _6146_/A _6240_/A1 vddd vssd sg13cmos5l_buf_1
Xfanout338 _6901_/B_N _6916_/B_N vddd vssd sg13cmos5l_buf_1
Xfanout327 _5807_/A1 _3541_/Y vddd vssd sg13cmos5l_buf_1
X_7064_ _7064_/Q _7071_/CLK _7064_/D fanout352/X vddd vssd sg13cmos5l_dfrbpq_1
X_4276_ _7384_/D _6408_/A _6759_/A _4279_/B vddd vssd sg13cmos5l_mux2_1
Xfanout349 _6913_/B_N fanout354/X vddd vssd sg13cmos5l_buf_1
X_6015_ _6015_/Y _6146_/A _6014_/B _6014_/Y _5024_/A _5024_/C vddd vssd sg13cmos5l_a221oi_1
XFILLER_28_937 vddd vssd sg13cmos5l_decap_8
XFILLER_23_1691 vddd vssd sg13cmos5l_decap_8
Xclkbuf_leaf_25_SCK_regs _7268_/CLK clkload6/A vddd vssd sg13cmos5l_buf_8
XFILLER_19_1727 vddd vssd sg13cmos5l_decap_8
X_6917_ _6917_/Y _6917_/A _6917_/B_N vddd vssd sg13cmos5l_nor2b_1
XFILLER_22_141 vddd vssd sg13cmos5l_decap_8
X_6848_ _6848_/Y _6962_/A _6933_/B_N vddd vssd sg13cmos5l_nor2b_1
XFILLER_32_1916 vddd vssd sg13cmos5l_decap_8
X_6779_ _6784_/B _6779_/A _6779_/B vddd vssd sg13cmos5l_nand2_1
XFILLER_7_808 vddd vssd sg13cmos5l_decap_8
XFILLER_30_2385 vddd vssd sg13cmos5l_decap_8
XFILLER_8_2353 vddd vssd sg13cmos5l_decap_4
XFILLER_24_2167 vddd vssd sg13cmos5l_decap_8
XFILLER_24_1411 vddd vssd sg13cmos5l_decap_8
XFILLER_4_2206 vddd vssd sg13cmos5l_decap_8
XFILLER_24_1444 vddd vssd sg13cmos5l_decap_8
XFILLER_19_948 vddd vssd sg13cmos5l_decap_8
XFILLER_4_1538 vddd vssd sg13cmos5l_decap_8
Xhold1070 _6699_/A0 _7030_/Q vddd vssd sg13cmos5l_dlygate4sd3_1
Xhold1092 _6700_/A0 _7031_/Q vddd vssd sg13cmos5l_dlygate4sd3_1
Xhold1081 _7163_/D _6427_/X vddd vssd sg13cmos5l_dlygate4sd3_1
XFILLER_9_134 vddd vssd sg13cmos5l_decap_8
XFILLER_13_163 vddd vssd sg13cmos5l_decap_8
XFILLER_13_2583 vddd vssd sg13cmos5l_decap_8
XFILLER_10_892 vddd vssd sg13cmos5l_decap_8
XFILLER_29_1300 vddd vssd sg13cmos5l_decap_8
XFILLER_9_2128 vddd vssd sg13cmos5l_decap_4
XFILLER_29_1366 vddd vssd sg13cmos5l_decap_8
X_4130_ _4130_/X _5690_/B _6498_/A _6490_/A vddd vssd sg13cmos5l_a21o_1
X_4061_ _4061_/Y _7069_/Q _6753_/A _4059_/Y _4060_/Y _6746_/A vddd vssd sg13cmos5l_a221oi_1
XFILLER_20_2521 vddd vssd sg13cmos5l_decap_8
Xwire15 wire15/X wire16/X vddd vssd sg13cmos5l_buf_2
XFILLER_20_2598 vddd vssd sg13cmos5l_decap_8
XFILLER_20_1853 vddd vssd sg13cmos5l_decap_8
X_4963_ _4964_/C _4963_/A _4963_/B vddd vssd sg13cmos5l_nor2_1
X_6702_ _6706_/S _6702_/A _6702_/B vddd vssd sg13cmos5l_and2_1
XFILLER_18_2472 vddd vssd sg13cmos5l_decap_8
X_3914_ _3914_/Y _3925_/A wire98/A vddd vssd sg13cmos5l_nand2_1
XFILLER_32_461 vddd vssd sg13cmos5l_decap_8
X_6633_ _6639_/S wire91/X _6779_/B vddd vssd sg13cmos5l_and2_1
X_4894_ _4895_/C _4894_/A _4894_/B vddd vssd sg13cmos5l_nor2_1
XFILLER_18_1760 vddd vssd sg13cmos5l_decap_8
X_3845_ _3848_/B _6786_/A _3846_/A vddd vssd sg13cmos5l_nor2_1
X_3776_ _3776_/Y _7126_/Q _3717_/Y _6329_/A vddd vssd sg13cmos5l_o21ai_1
X_6564_ _6564_/Y _6668_/A _6567_/S vddd vssd sg13cmos5l_nor2_1
X_6495_ _6495_/X _6558_/A hold839/X _6496_/B vddd vssd sg13cmos5l_mux2_1
X_5515_ _5515_/Y _5748_/A _5515_/B _7180_/Q vddd vssd sg13cmos5l_nor3_1
X_5446_ _5446_/Y _5795_/A1 _5442_/Y _5445_/Y vddd vssd sg13cmos5l_a21oi_1
XFILLER_29_2590 vddd vssd sg13cmos5l_decap_8
X_5377_ _5386_/C _7158_/Q _7159_/Q vddd vssd sg13cmos5l_nand2_1
Xfanout102 _3734_/A _3712_/Y vddd vssd sg13cmos5l_buf_1
Xfanout113 _3683_/A _3755_/A vddd vssd sg13cmos5l_buf_1
XFILLER_25_2454 vddd vssd sg13cmos5l_decap_8
X_7116_ _7116_/Q _7276_/CLK _7116_/D fanout392/X vddd vssd sg13cmos5l_dfrbpq_1
X_4328_ _4328_/Y _4327_/Y _4329_/A vddd vssd sg13cmos5l_nand2b_1
Xfanout135 _3876_/D _3705_/Y vddd vssd sg13cmos5l_buf_1
Xfanout124 _6779_/B _6299_/Y vddd vssd sg13cmos5l_buf_1
XFILLER_5_2526 vddd vssd sg13cmos5l_decap_8
X_7047_ _7047_/Q _7367_/CLK _7047_/D fanout346/X vddd vssd sg13cmos5l_dfrbpq_1
XFILLER_21_2307 vddd vssd sg13cmos5l_decap_8
Xfanout179 _6408_/A fanout188/X vddd vssd sg13cmos5l_buf_1
X_6907__472 _7394_/CLK _7164_/CLK vddd vssd sg13cmos5l_inv_1
X_4259_ _4259_/Y _7088_/Q _4259_/B vddd vssd sg13cmos5l_nand2_1
Xfanout168 _4867_/A hold845/A vddd vssd sg13cmos5l_buf_1
XFILLER_9_1972 vddd vssd sg13cmos5l_decap_8
XFILLER_27_222 vddd vssd sg13cmos5l_decap_8
XFILLER_27_288 vddd vssd sg13cmos5l_decap_8
XFILLER_32_2425 vddd vssd sg13cmos5l_decap_8
XFILLER_24_984 vddd vssd sg13cmos5l_decap_4
XFILLER_23_461 vddd vssd sg13cmos5l_decap_8
XFILLER_11_656 vddd vssd sg13cmos5l_decap_4
XFILLER_10_144 vddd vssd sg13cmos5l_decap_4
XFILLER_32_1768 vddd vssd sg13cmos5l_decap_8
Xtiedowns\[33\] dbus_in_right[1] vddd vssd sg13cmos5l_antennanp
XFILLER_4_2036 vddd vssd sg13cmos5l_decap_8
XFILLER_8_2183 vddd vssd sg13cmos5l_decap_8
XFILLER_2_1070 vddd vssd sg13cmos5l_decap_8
XFILLER_18_1034 vddd vssd sg13cmos5l_decap_8
XFILLER_15_984 vddd vssd sg13cmos5l_decap_4
XFILLER_30_976 vddd vssd sg13cmos5l_decap_8
XFILLER_15_1988 vddd vssd sg13cmos5l_decap_8
X_3561_ _5517_/A _3561_/A vddd vssd sg13cmos5l_inv_1
X_5300_ _5303_/D _7148_/Q _5308_/D vddd vssd sg13cmos5l_nor2_1
X_6280_ _6282_/B _6291_/A vddd vssd sg13cmos5l_inv_1
X_3492_ _3492_/Y _4317_/A vddd vssd sg13cmos5l_inv_1
XFILLER_6_693 vddd vssd sg13cmos5l_decap_4
X_5231_ _5237_/B _5231_/A _5257_/B vddd vssd sg13cmos5l_or2_1
XFILLER_5_192 vddd vssd sg13cmos5l_decap_4
XFILLER_29_1163 vddd vssd sg13cmos5l_decap_8
X_5162_ _5169_/B _5162_/A _5162_/B vddd vssd sg13cmos5l_nor2_1
XFILLER_9_1224 vddd vssd sg13cmos5l_decap_8
X_4113_ _4115_/B dbus_in_left[9] dbus_in_right[9] vddd vssd sg13cmos5l_nor2_1
X_5093_ _5258_/A _5130_/A _7247_/Q vddd vssd sg13cmos5l_nand2_1
X_4044_ _4044_/Y _3568_/Y _6483_/A _6475_/A vddd vssd sg13cmos5l_a21oi_1
XFILLER_0_2401 vddd vssd sg13cmos5l_decap_8
XFILLER_24_203 vddd vssd sg13cmos5l_decap_8
XFILLER_0_2489 vddd vssd sg13cmos5l_decap_8
XFILLER_0_1733 vddd vssd sg13cmos5l_decap_8
X_5995_ _5995_/Y _6263_/A1 _5008_/C _5012_/C vddd vssd sg13cmos5l_a21oi_1
XFILLER_0_1766 vddd vssd sg13cmos5l_decap_8
XFILLER_21_910 vddd vssd sg13cmos5l_decap_8
XFILLER_16_1719 vddd vssd sg13cmos5l_decap_8
X_4946_ _4946_/Y _4946_/A _4949_/A vddd vssd sg13cmos5l_xnor2_1
X_4877_ _4890_/B _4934_/A _7145_/Q vddd vssd sg13cmos5l_nor2_1
XFILLER_14_2144 vddd vssd sg13cmos5l_decap_8
X_3828_ _3828_/Y _3824_/Y _3825_/X _3827_/Y vddd vssd sg13cmos5l_o21ai_1
XFILLER_18_1590 vddd vssd sg13cmos5l_decap_8
X_6616_ _6616_/Y _6616_/A _6620_/S vddd vssd sg13cmos5l_nor2_1
X_6547_ _7226_/D _6547_/A1 _6552_/B _6546_/Y vddd vssd sg13cmos5l_a21oi_1
X_3759_ wire29/A mask_rev_in[31] _4263_/B _3758_/X vddd vssd sg13cmos5l_o21ai_1
XFILLER_14_1487 vddd vssd sg13cmos5l_decap_8
X_6478_ _6478_/Y _6690_/A _6481_/B vddd vssd sg13cmos5l_nor2_1
XFILLER_27_2527 vddd vssd sg13cmos5l_decap_8
X_5429_ _5429_/Y _5544_/A _5429_/B _5442_/A vddd vssd sg13cmos5l_nor3_1
XFILLER_0_847 vddd vssd sg13cmos5l_decap_8
XFILLER_9_2492 vddd vssd sg13cmos5l_decap_8
Xclkbuf_leaf_40_SCK_regs _7375_/CLK clkbuf_3_0_0_SCK_regs/X vddd vssd sg13cmos5l_buf_8
XFILLER_5_1633 vddd vssd sg13cmos5l_decap_8
XFILLER_5_1666 vddd vssd sg13cmos5l_decap_8
XFILLER_7_424 vddd vssd sg13cmos5l_decap_4
XFILLER_8_925 vddd vssd sg13cmos5l_decap_8
XFILLER_7_446 vddd vssd sg13cmos5l_decap_8
XFILLER_10_2575 vddd vssd sg13cmos5l_decap_8
XFILLER_26_2015 vddd vssd sg13cmos5l_decap_8
XFILLER_24_7 vddd vssd sg13cmos5l_decap_8
XFILLER_4_1143 vddd vssd sg13cmos5l_decap_8
XFILLER_0_21 vddd vssd sg13cmos5l_decap_8
XFILLER_19_597 vddd vssd sg13cmos5l_decap_8
XFILLER_22_707 vddd vssd sg13cmos5l_decap_8
X_4800_ _4800_/Y _5315_/A _4815_/A vddd vssd sg13cmos5l_nor2_1
X_5780_ _5780_/Y _5778_/Y _5779_/Y _5791_/C vddd vssd sg13cmos5l_o21ai_1
X_4731_ _4731_/Y _4685_/A _4729_/Y _4731_/B1 vddd vssd sg13cmos5l_o21ai_1
XFILLER_9_63 vddd vssd sg13cmos5l_decap_4
XFILLER_14_280 vddd vssd sg13cmos5l_decap_8
X_4662_ _4663_/B _4662_/A _4732_/B vddd vssd sg13cmos5l_nand2_1
XFILLER_15_2486 vddd vssd sg13cmos5l_decap_8
X_6401_ _6401_/X hold681/X _6408_/A _6401_/S vddd vssd sg13cmos5l_mux2_1
X_3613_ _3613_/Y mask_rev_in[9] vddd vssd sg13cmos5l_inv_1
XFILLER_11_1605 vddd vssd sg13cmos5l_decap_4
XFILLER_11_2339 vddd vssd sg13cmos5l_decap_4
X_4593_ _4593_/Y _4685_/A _4593_/B _4593_/C vddd vssd sg13cmos5l_nor3_1
Xhold903 _4410_/A _7354_/Q vddd vssd sg13cmos5l_dlygate4sd3_1
XFILLER_11_1638 vddd vssd sg13cmos5l_decap_8
X_7381_ _7381_/Q _7403_/CLK _7381_/D _6895_/Y vddd vssd sg13cmos5l_dfrbpq_1
Xhold925 _6763_/A _7073_/Q vddd vssd sg13cmos5l_dlygate4sd3_1
XFILLER_31_1097 vddd vssd sg13cmos5l_decap_8
X_6332_ _6332_/Y _6782_/A _6344_/B vddd vssd sg13cmos5l_nand2_1
Xhold914 _6972_/D _5928_/Y vddd vssd sg13cmos5l_dlygate4sd3_1
Xhold936 hold936/X _5318_/B vddd vssd sg13cmos5l_dlygate4sd3_1
X_3544_ _5586_/A _5526_/A vddd vssd sg13cmos5l_inv_1
X_3475_ _3475_/Y _3475_/A vddd vssd sg13cmos5l_inv_1
X_6263_ _6263_/Y _6263_/A1 _5270_/B _6262_/Y vddd vssd sg13cmos5l_a21oi_1
Xhold947 hold947/X _3600_/Y vddd vssd sg13cmos5l_dlygate4sd3_1
Xhold969 hold969/X _6780_/Y vddd vssd sg13cmos5l_dlygate4sd3_1
Xhold958 hold958/X _7157_/Q vddd vssd sg13cmos5l_dlygate4sd3_1
Xoutbuffers\[64\] idac2_value[1] _7046_/Q vddd vssd sg13cmos5l_buf_16
X_5214_ _5215_/B _5214_/A _6175_/B _5214_/C _6170_/B vddd vssd sg13cmos5l_nor4_1
X_6194_ _6194_/Y _6175_/A _5237_/B _6193_/Y vddd vssd sg13cmos5l_o21ai_1
X_5145_ _5149_/C _5226_/A _5145_/B vddd vssd sg13cmos5l_nor2_1
XFILLER_9_1098 vddd vssd sg13cmos5l_decap_8
XFILLER_22_2457 vddd vssd sg13cmos5l_decap_8
XFILLER_2_1806 vddd vssd sg13cmos5l_decap_8
X_5076_ _5099_/B _7262_/Q _7263_/Q _5076_/C vddd vssd sg13cmos5l_nand3_1
X_4027_ _4027_/Y dbus_in_left[10] dbus_in_right[10] vddd vssd sg13cmos5l_nor2_1
XFILLER_25_501 vddd vssd sg13cmos5l_decap_8
XFILLER_22_1778 vddd vssd sg13cmos5l_decap_8
XFILLER_0_2220 vddd vssd sg13cmos5l_decap_8
XFILLER_20_2181 vddd vssd sg13cmos5l_decap_8
X_5978_ _5978_/Y _6238_/A1 _5977_/A _5977_/Y vddd vssd sg13cmos5l_a21oi_1
XFILLER_12_206 vddd vssd sg13cmos5l_decap_8
X_4929_ _4935_/A _4937_/A _4940_/A _4943_/A vddd vssd sg13cmos5l_and3_1
XFILLER_4_405 vddd vssd sg13cmos5l_decap_8
XFILLER_10_1104 vddd vssd sg13cmos5l_decap_8
XFILLER_14_1273 vddd vssd sg13cmos5l_decap_8
XFILLER_4_449 vddd vssd sg13cmos5l_decap_8
XFILLER_0_644 vddd vssd sg13cmos5l_decap_4
XFILLER_27_1667 vddd vssd sg13cmos5l_decap_4
XFILLER_5_2131 vddd vssd sg13cmos5l_decap_8
XFILLER_29_840 vddd vssd sg13cmos5l_decap_8
XFILLER_5_1463 vddd vssd sg13cmos5l_decap_8
XFILLER_16_578 vddd vssd sg13cmos5l_decap_8
XFILLER_31_548 vddd vssd sg13cmos5l_decap_8
XFILLER_32_2096 vddd vssd sg13cmos5l_decap_8
XFILLER_32_1373 vddd vssd sg13cmos5l_decap_8
XFILLER_8_777 vddd vssd sg13cmos5l_decap_8
XFILLER_4_972 vddd vssd sg13cmos5l_decap_4
XFILLER_22_1008 vddd vssd sg13cmos5l_decap_8
X_6950_ _6950_/Y _6965_/A _6966_/B_N vddd vssd sg13cmos5l_nor2b_1
X_5901_ _5901_/Y _5901_/A _5901_/B _7232_/Q _5901_/D vddd vssd sg13cmos5l_nor4_1
X_6881_ _6881_/Y _6901_/A _6917_/B_N vddd vssd sg13cmos5l_nor2b_1
X_5832_ _5832_/Y _5861_/A _7223_/Q vddd vssd sg13cmos5l_nand2b_1
XFILLER_17_2548 vddd vssd sg13cmos5l_decap_8
X_5763_ _5763_/Y _5730_/A _5760_/Y _5762_/Y vddd vssd sg13cmos5l_a21oi_1
Xoutbuffers\[8\] proj_ibias_ena[1] _7034_/Q vddd vssd sg13cmos5l_buf_16
X_4714_ _4714_/X _4169_/A _4689_/Y _4758_/B1 vddd vssd sg13cmos5l_a21o_1
X_5694_ _5694_/Y _5807_/A1 _5685_/B _5692_/Y _7204_/Q vddd vssd sg13cmos5l_a22oi_1
X_4645_ _4645_/Y _4668_/A _4645_/B vddd vssd sg13cmos5l_nor2_1
XFILLER_11_1402 vddd vssd sg13cmos5l_decap_8
X_4576_ _4576_/X _4575_/A _4572_/Y _4575_/Y vddd vssd sg13cmos5l_a21o_1
Xhold711 hold711/X _6393_/Y vddd vssd sg13cmos5l_dlygate4sd3_1
X_7364_ _7364_/Q _7367_/CLK _7364_/D _6878_/Y vddd vssd sg13cmos5l_dfrbpq_1
Xhold700 _6302_/A _7097_/Q vddd vssd sg13cmos5l_dlygate4sd3_1
X_3527_ _3527_/Y _3527_/A vddd vssd sg13cmos5l_inv_1
Xhold733 hold733/X _6378_/Y vddd vssd sg13cmos5l_dlygate4sd3_1
Xhold722 hold722/X _6391_/Y vddd vssd sg13cmos5l_dlygate4sd3_1
Xhold744 _7380_/D _4282_/X vddd vssd sg13cmos5l_dlygate4sd3_1
Xhold755 hold755/X _6794_/Y vddd vssd sg13cmos5l_dlygate4sd3_1
X_6315_ _6315_/Y _6782_/A _6327_/B vddd vssd sg13cmos5l_nand2_1
XFILLER_11_1468 vddd vssd sg13cmos5l_decap_8
Xhold766 _5940_/C _5939_/Y vddd vssd sg13cmos5l_dlygate4sd3_1
Xhold788 _5934_/B _5932_/Y vddd vssd sg13cmos5l_dlygate4sd3_1
Xhold777 _3533_/A _7091_/Q vddd vssd sg13cmos5l_dlygate4sd3_1
X_7295_ _7295_/Q _7297_/CLK _7295_/D fanout375/X vddd vssd sg13cmos5l_dfrbpq_1
Xhold799 hold799/X _7131_/Q vddd vssd sg13cmos5l_dlygate4sd3_1
X_6246_ _6246_/Y _5251_/B _6244_/Y _6245_/Y vddd vssd sg13cmos5l_o21ai_1
X_6177_ _6178_/B _6177_/A _6177_/B vddd vssd sg13cmos5l_nor2_1
Xhold1400 hold1400/X _7244_/Q vddd vssd sg13cmos5l_dlygate4sd3_1
XFILLER_6_2440 vddd vssd sg13cmos5l_decap_8
Xhold1411 _6486_/A1 _5629_/A vddd vssd sg13cmos5l_dlygate4sd3_1
Xhold1433 _6388_/A _7143_/Q vddd vssd sg13cmos5l_dlygate4sd3_1
Xhold1422 hold1422/X _7236_/Q vddd vssd sg13cmos5l_dlygate4sd3_1
XFILLER_6_2473 vddd vssd sg13cmos5l_decap_8
X_5128_ _5179_/B _7249_/Q _7248_/Q vddd vssd sg13cmos5l_nor2b_1
XFILLER_29_147 vddd vssd sg13cmos5l_decap_8
Xhold1466 _6729_/A1 _7051_/Q vddd vssd sg13cmos5l_dlygate4sd3_1
Xhold1477 hold1477/X _7387_/Q vddd vssd sg13cmos5l_dlygate4sd3_1
Xhold1444 _4731_/B1 _4730_/Y vddd vssd sg13cmos5l_dlygate4sd3_1
XFILLER_6_1783 vddd vssd sg13cmos5l_decap_8
Xhold1455 _7383_/D _4277_/X vddd vssd sg13cmos5l_dlygate4sd3_1
Xhold1488 hold496/A _7021_/Q vddd vssd sg13cmos5l_dlygate4sd3_1
Xhold1499 hold504/A _7012_/Q vddd vssd sg13cmos5l_dlygate4sd3_1
XFILLER_22_1575 vddd vssd sg13cmos5l_decap_4
XFILLER_22_1586 vddd vssd sg13cmos5l_decap_4
X_5059_ _5157_/A _5245_/A _5245_/B vddd vssd sg13cmos5l_nor2_1
XFILLER_0_1360 vddd vssd sg13cmos5l_decap_4
XFILLER_9_508 vddd vssd sg13cmos5l_decap_8
XFILLER_21_581 vddd vssd sg13cmos5l_decap_8
XFILLER_5_714 vddd vssd sg13cmos5l_decap_4
XFILLER_29_2408 vddd vssd sg13cmos5l_decap_8
XFILLER_5_736 vddd vssd sg13cmos5l_decap_4
XFILLER_20_84 vddd vssd sg13cmos5l_decap_8
XFILLER_27_2176 vddd vssd sg13cmos5l_decap_8
XFILLER_7_2226 vddd vssd sg13cmos5l_decap_8
XFILLER_0_474 vddd vssd sg13cmos5l_decap_8
XFILLER_32_857 vddd vssd sg13cmos5l_decap_8
XFILLER_31_323 vddd vssd sg13cmos5l_decap_8
XFILLER_16_386 vddd vssd sg13cmos5l_decap_8
XFILLER_16_1880 vddd vssd sg13cmos5l_decap_4
XFILLER_12_1711 vddd vssd sg13cmos5l_decap_8
X_4430_ _4818_/A _4461_/A _4507_/A vddd vssd sg13cmos5l_or2_1
XFILLER_12_1733 vddd vssd sg13cmos5l_decap_8
XANTENNA_2 SDI vddd vssd sg13cmos5l_antennanp
XFILLER_6_53 vddd vssd sg13cmos5l_decap_8
X_4361_ _4361_/Y _7088_/Q _4421_/A _4360_/X vddd vssd sg13cmos5l_o21ai_1
X_6100_ _6100_/Y _6100_/A _6100_/B vddd vssd sg13cmos5l_nand2_1
X_7080_ _7080_/Q _7276_/CLK _7080_/D fanout392/X vddd vssd sg13cmos5l_dfrbpq_1
X_4292_ _4292_/Y _6713_/A1 _4291_/B hold653/X vddd vssd sg13cmos5l_a21oi_1
X_6031_ _6031_/Y _6167_/B1 _6013_/Y _6030_/Y vddd vssd sg13cmos5l_o21ai_1
XFILLER_6_1002 vddd vssd sg13cmos5l_decap_8
XFILLER_23_2552 vddd vssd sg13cmos5l_decap_8
XFILLER_13_0 vddd vssd sg13cmos5l_decap_8
Xoutbuffers\[27\] voltgen_sink1[0] _7067_/Q vddd vssd sg13cmos5l_buf_16
XFILLER_26_139 vddd vssd sg13cmos5l_decap_8
X_6933_ _6933_/Y _6952_/A _6933_/B_N vddd vssd sg13cmos5l_nor2b_1
XFILLER_23_824 vddd vssd sg13cmos5l_decap_8
X_6864_ _6864_/Y _6870_/A _6865_/B_N vddd vssd sg13cmos5l_nor2b_1
X_5815_ _5819_/B _7220_/Q _7221_/Q vddd vssd sg13cmos5l_nor2_1
XFILLER_17_1644 vddd vssd sg13cmos5l_decap_8
X_6795_ _6795_/Y _6317_/A _6801_/B hold755/X vddd vssd sg13cmos5l_a21oi_1
X_5746_ _5746_/Y _5752_/B _7315_/Q vddd vssd sg13cmos5l_nor2_1
X_5677_ _5677_/Y _7200_/Q _7201_/Q _5677_/C vddd vssd sg13cmos5l_nor3_1
XFILLER_30_2567 vddd vssd sg13cmos5l_decap_8
XFILLER_30_1855 vddd vssd sg13cmos5l_decap_8
X_4628_ _4628_/X _4628_/A _4628_/B vddd vssd sg13cmos5l_or2_1
XFILLER_11_1210 vddd vssd sg13cmos5l_decap_8
Xhold530 _4632_/A _6992_/Q vddd vssd sg13cmos5l_dlygate4sd3_1
Xhold541 _6995_/D _6811_/X vddd vssd sg13cmos5l_dlygate4sd3_1
Xhold552 _6814_/A _6982_/Q vddd vssd sg13cmos5l_dlygate4sd3_1
X_4559_ _4559_/Y _7345_/Q _4549_/X _4558_/Y vddd vssd sg13cmos5l_a21oi_1
X_7347_ _7347_/Q _7348_/CLK _7347_/D _6861_/Y vddd vssd sg13cmos5l_dfrbpq_1
Xhold563 _7007_/D _3474_/Y vddd vssd sg13cmos5l_dlygate4sd3_1
X_7278_ _7278_/Q _7285_/CLK _7278_/D fanout385/X vddd vssd sg13cmos5l_dfrbpq_1
Xhold585 _4765_/B _6986_/Q vddd vssd sg13cmos5l_dlygate4sd3_1
Xhold574 _3862_/A _7392_/Q vddd vssd sg13cmos5l_dlygate4sd3_1
Xhold596 _4911_/A _7400_/Q vddd vssd sg13cmos5l_dlygate4sd3_1
XFILLER_28_2496 vddd vssd sg13cmos5l_decap_8
X_6229_ _6229_/Y _5967_/A _6227_/B _6227_/Y _6221_/Y _6230_/B vddd vssd sg13cmos5l_a221oi_1
XFILLER_8_2557 vddd vssd sg13cmos5l_decap_8
Xhold1230 _6757_/A1 _7069_/Q vddd vssd sg13cmos5l_dlygate4sd3_1
XFILLER_22_2062 vddd vssd sg13cmos5l_decap_8
Xhold1252 _3558_/A _7175_/Q vddd vssd sg13cmos5l_dlygate4sd3_1
Xhold1241 _6606_/A0 _7259_/Q vddd vssd sg13cmos5l_dlygate4sd3_1
Xhold1274 _7291_/D _6656_/X vddd vssd sg13cmos5l_dlygate4sd3_1
Xhold1263 _6594_/A1 _5245_/B vddd vssd sg13cmos5l_dlygate4sd3_1
Xhold1285 _4909_/A1 _7323_/Q vddd vssd sg13cmos5l_dlygate4sd3_1
Xhold1296 hold695/A _7403_/Q vddd vssd sg13cmos5l_dlygate4sd3_1
XFILLER_14_813 vddd vssd sg13cmos5l_decap_8
XFILLER_25_194 vddd vssd sg13cmos5l_decap_8
XFILLER_14_857 vddd vssd sg13cmos5l_decap_8
XFILLER_15_84 vddd vssd sg13cmos5l_decap_4
XFILLER_9_305 vddd vssd sg13cmos5l_decap_4
XFILLER_5_500 vddd vssd sg13cmos5l_decap_8
XFILLER_31_72 vddd vssd sg13cmos5l_decap_8
Xtiedowns\[63\] mask_rev_in[19] vddd vssd sg13cmos5l_antennanp
XFILLER_29_1537 vddd vssd sg13cmos5l_decap_4
XFILLER_7_1300 vddd vssd sg13cmos5l_decap_8
XFILLER_7_2056 vddd vssd sg13cmos5l_decap_8
XFILLER_23_1114 vddd vssd sg13cmos5l_decap_8
X_7319__461 _7319_/RESET_B vddd vssd sg13cmos5l_tiehi
X_3930_ _6506_/A _6762_/A _3966_/B vddd vssd sg13cmos5l_nand2b_1
XFILLER_17_673 vddd vssd sg13cmos5l_decap_8
Xoutbuffers\[117\] dbus_out[20] _5877_/X vddd vssd sg13cmos5l_buf_16
XFILLER_32_676 vddd vssd sg13cmos5l_decap_8
XFILLER_31_142 vddd vssd sg13cmos5l_decap_8
X_3861_ _3861_/Y _3858_/Y _3859_/Y hold570/X vddd vssd sg13cmos5l_o21ai_1
X_5600_ _5600_/Y _5613_/C _5599_/Y _5613_/A vddd vssd sg13cmos5l_o21ai_1
X_6580_ _7244_/D _6550_/A _6580_/A1 _6581_/B vddd vssd sg13cmos5l_mux2_1
X_3792_ _3792_/Y _3789_/Y _3790_/Y hold578/X vddd vssd sg13cmos5l_o21ai_1
XFILLER_14_1839 vddd vssd sg13cmos5l_decap_4
X_5531_ _5531_/Y _5531_/A _5531_/B vddd vssd sg13cmos5l_nor2_1
XFILLER_8_382 vddd vssd sg13cmos5l_decap_8
X_7201_ _7201_/Q _7201_/CLK _7201_/D fanout367/X vddd vssd sg13cmos5l_dfrbpq_1
X_5462_ _5468_/C _5472_/B _5465_/B vddd vssd sg13cmos5l_nand2b_1
XFILLER_12_2297 vddd vssd sg13cmos5l_decap_4
X_5393_ _5393_/Y _5416_/A _5393_/B _5393_/C vddd vssd sg13cmos5l_nand3_1
X_4413_ _4413_/Y _4419_/A _4413_/B _4413_/C vddd vssd sg13cmos5l_nor3_1
XFILLER_12_1585 vddd vssd sg13cmos5l_decap_8
X_7132_ _7132_/Q _7273_/CLK _7132_/D fanout390/X vddd vssd sg13cmos5l_dfrbpq_1
X_4344_ _4344_/Y _4325_/B _4343_/Y hold752/X vddd vssd sg13cmos5l_o21ai_1
X_7063_ _7063_/Q _7071_/CLK _7063_/D fanout352/X vddd vssd sg13cmos5l_dfrbpq_1
Xfanout306 _5327_/A hold1402/X vddd vssd sg13cmos5l_buf_1
Xfanout328 _5828_/B2 _3539_/Y vddd vssd sg13cmos5l_buf_1
XFILLER_8_1108 vddd vssd sg13cmos5l_decap_8
Xfanout339 _6916_/B_N _6915_/B_N vddd vssd sg13cmos5l_buf_1
Xfanout317 _6240_/A1 _4028_/X vddd vssd sg13cmos5l_buf_1
X_6014_ _6014_/Y _6239_/A _6014_/B vddd vssd sg13cmos5l_nor2_1
X_4275_ _7385_/D _6759_/A _6777_/A _4279_/B vddd vssd sg13cmos5l_mux2_1
XFILLER_28_916 vddd vssd sg13cmos5l_decap_8
XFILLER_27_404 vddd vssd sg13cmos5l_decap_4
XFILLER_23_621 vddd vssd sg13cmos5l_decap_8
XFILLER_19_1706 vddd vssd sg13cmos5l_decap_8
X_6916_ _6916_/Y _6916_/A _6916_/B_N vddd vssd sg13cmos5l_nor2b_1
XFILLER_22_120 vddd vssd sg13cmos5l_decap_8
X_6847_ _6847_/Y _6952_/A _6952_/B_N vddd vssd sg13cmos5l_nor2b_1
X_6778_ _6778_/Y _6778_/A1 _6777_/B _6777_/Y vddd vssd sg13cmos5l_o21ai_1
XFILLER_11_849 vddd vssd sg13cmos5l_decap_4
XFILLER_22_186 vddd vssd sg13cmos5l_decap_8
X_5729_ _5729_/Y _5729_/A _5730_/B _5729_/C _5729_/D vddd vssd sg13cmos5l_nand4_1
XFILLER_30_2364 vddd vssd sg13cmos5l_decap_8
XFILLER_28_1581 vddd vssd sg13cmos5l_decap_8
XFILLER_8_1642 vddd vssd sg13cmos5l_decap_8
XFILLER_8_2398 vddd vssd sg13cmos5l_decap_8
XFILLER_19_927 vddd vssd sg13cmos5l_decap_8
Xhold1060 hold492/A hold1508/X vddd vssd sg13cmos5l_dlygate4sd3_1
Xhold1071 _7030_/D _6699_/X vddd vssd sg13cmos5l_dlygate4sd3_1
Xhold1093 _7031_/D _6700_/X vddd vssd sg13cmos5l_dlygate4sd3_1
Xhold1082 _6708_/A0 _7037_/Q vddd vssd sg13cmos5l_dlygate4sd3_1
XFILLER_26_83 vddd vssd sg13cmos5l_decap_8
XFILLER_18_1238 vddd vssd sg13cmos5l_decap_8
XFILLER_13_142 vddd vssd sg13cmos5l_decap_8
XFILLER_14_687 vddd vssd sg13cmos5l_decap_8
XFILLER_13_2562 vddd vssd sg13cmos5l_decap_8
XFILLER_6_820 vddd vssd sg13cmos5l_decap_8
XFILLER_29_2035 vddd vssd sg13cmos5l_decap_4
XFILLER_9_2107 vddd vssd sg13cmos5l_decap_8
XFILLER_3_21 vddd vssd sg13cmos5l_decap_8
XFILLER_9_1417 vddd vssd sg13cmos5l_decap_8
XFILLER_9_1439 vddd vssd sg13cmos5l_decap_8
X_4060_ _4060_/Y _3622_/Y _3821_/Y _6753_/A vddd vssd sg13cmos5l_a21oi_1
XFILLER_20_2500 vddd vssd sg13cmos5l_decap_8
XFILLER_7_1185 vddd vssd sg13cmos5l_decap_8
XFILLER_20_2577 vddd vssd sg13cmos5l_decap_8
Xwire16 wire16/X wire16/A vddd vssd sg13cmos5l_buf_2
Xwire27 wire27/X wire27/A vddd vssd sg13cmos5l_buf_4
XFILLER_25_919 vddd vssd sg13cmos5l_decap_8
Xwire49 wire49/X wire49/A vddd vssd sg13cmos5l_buf_4
XFILLER_0_1926 vddd vssd sg13cmos5l_decap_8
XFILLER_20_1887 vddd vssd sg13cmos5l_decap_8
X_4962_ _4962_/Y _4943_/B _4961_/Y hold917/X vddd vssd sg13cmos5l_o21ai_1
X_6701_ _6701_/X _6701_/A0 _6550_/A _6709_/S vddd vssd sg13cmos5l_mux2_1
XFILLER_18_2451 vddd vssd sg13cmos5l_decap_8
X_4893_ _4895_/B _4890_/A _4884_/Y _4890_/D vddd vssd sg13cmos5l_a21oi_1
X_3913_ _6545_/A _3924_/A _3959_/A vddd vssd sg13cmos5l_nor2_1
X_6632_ _6632_/X _6632_/A0 _6645_/A1 _6632_/S vddd vssd sg13cmos5l_mux2_1
X_3844_ _3844_/Y _3509_/Y _6346_/A _3863_/B _7116_/Q _4253_/A vddd vssd sg13cmos5l_a221oi_1
X_3775_ _3775_/Y _3506_/Y wire81/X _3773_/Y _3774_/Y vddd vssd sg13cmos5l_a22oi_1
XFILLER_20_668 vddd vssd sg13cmos5l_decap_8
X_6563_ _7234_/D _6563_/A1 _6567_/S _6562_/Y vddd vssd sg13cmos5l_a21oi_1
Xoutbuffers\[94\] io_out[9] _6208_/X vddd vssd sg13cmos5l_buf_16
X_6494_ _7199_/D _6494_/A1 _6496_/B _6493_/Y vddd vssd sg13cmos5l_a21oi_1
X_5514_ _5514_/Y _7178_/Q _7179_/Q _5514_/C vddd vssd sg13cmos5l_nand3_1
XFILLER_31_1994 vddd vssd sg13cmos5l_decap_8
X_5445_ _5445_/Y _7168_/Q _7169_/Q _5445_/C vddd vssd sg13cmos5l_nor3_1
X_7115_ _7115_/Q _7119_/CLK _7115_/D fanout392/X vddd vssd sg13cmos5l_dfrbpq_1
Xfanout103 _4189_/B1 _3709_/Y vddd vssd sg13cmos5l_buf_1
X_5376_ _5383_/C _5374_/X _5375_/X _5389_/C vddd vssd sg13cmos5l_a21oi_1
XFILLER_25_2433 vddd vssd sg13cmos5l_decap_8
Xfanout136 _3940_/B _3878_/C vddd vssd sg13cmos5l_buf_1
Xfanout147 _5193_/B _5233_/A vddd vssd sg13cmos5l_buf_1
X_4327_ _4327_/Y _5988_/B _4326_/Y _4355_/B vddd vssd sg13cmos5l_o21ai_1
Xfanout114 _3755_/A _3666_/Y vddd vssd sg13cmos5l_buf_1
XFILLER_5_2505 vddd vssd sg13cmos5l_decap_8
Xfanout125 _4460_/B _4458_/Y vddd vssd sg13cmos5l_buf_1
X_7046_ _7046_/Q _7146_/CLK _7046_/D fanout350/X vddd vssd sg13cmos5l_dfrbpq_1
Xfanout158 _6121_/A _4630_/A vddd vssd sg13cmos5l_buf_1
Xfanout169 hold845/A hold844/X vddd vssd sg13cmos5l_buf_1
X_4258_ _4258_/Y _6789_/A _4258_/B _4258_/C _4258_/D vddd vssd sg13cmos5l_nand4_1
XFILLER_27_201 vddd vssd sg13cmos5l_decap_8
XFILLER_28_735 vddd vssd sg13cmos5l_decap_4
X_4189_ _4189_/X _3522_/Y wire92/X _4189_/B1 vddd vssd sg13cmos5l_a21o_1
XFILLER_19_2204 vddd vssd sg13cmos5l_decap_4
XFILLER_24_930 vddd vssd sg13cmos5l_decap_4
XFILLER_19_2237 vddd vssd sg13cmos5l_decap_8
XFILLER_19_1525 vddd vssd sg13cmos5l_decap_8
XFILLER_32_2404 vddd vssd sg13cmos5l_decap_8
XFILLER_19_1558 vddd vssd sg13cmos5l_decap_8
XFILLER_11_602 vddd vssd sg13cmos5l_decap_8
XFILLER_32_1747 vddd vssd sg13cmos5l_decap_8
XFILLER_12_63 vddd vssd sg13cmos5l_decap_4
XFILLER_26_2219 vddd vssd sg13cmos5l_decap_4
Xtiedowns\[26\] dbus_in_left[6] vddd vssd sg13cmos5l_antennanp
XFILLER_19_713 vddd vssd sg13cmos5l_decap_8
XFILLER_8_1483 vddd vssd sg13cmos5l_decap_8
X_7316__464 _7316_/RESET_B vddd vssd sg13cmos5l_tiehi
XFILLER_18_1079 vddd vssd sg13cmos5l_decap_8
XFILLER_18_1068 vddd vssd sg13cmos5l_decap_8
X_3560_ _5515_/B _7179_/Q vddd vssd sg13cmos5l_inv_1
X_5230_ _5234_/C _5141_/A _5264_/B vddd vssd sg13cmos5l_nand2b_1
X_3491_ _3491_/Y _6840_/A vddd vssd sg13cmos5l_inv_1
X_5161_ _5162_/B _5240_/A _5177_/B vddd vssd sg13cmos5l_nor2_1
XFILLER_25_1017 vddd vssd sg13cmos5l_decap_8
X_5092_ _5100_/B _5208_/A _5209_/B _5173_/A vddd vssd sg13cmos5l_nor3_1
X_4112_ _4112_/Y _4109_/Y _4110_/Y _4111_/Y vddd vssd sg13cmos5l_o21ai_1
XFILLER_9_1258 vddd vssd sg13cmos5l_decap_4
X_4043_ _4043_/Y _4040_/X _4041_/Y _4042_/Y vddd vssd sg13cmos5l_o21ai_1
XFILLER_22_1938 vddd vssd sg13cmos5l_decap_8
XFILLER_20_2341 vddd vssd sg13cmos5l_decap_4
X_5994_ _5994_/Y _4027_/Y _5009_/B _5993_/Y vddd vssd sg13cmos5l_a21oi_1
XFILLER_18_790 vddd vssd sg13cmos5l_decap_8
XFILLER_0_2468 vddd vssd sg13cmos5l_decap_8
X_4945_ _4945_/Y _4946_/A _4954_/B vddd vssd sg13cmos5l_nand2_1
XFILLER_18_2270 vddd vssd sg13cmos5l_decap_8
X_4876_ _4890_/A _4958_/A _7137_/Q _4875_/X vddd vssd sg13cmos5l_o21ai_1
X_3827_ _3827_/Y _3625_/Y _6753_/A _6746_/A vddd vssd sg13cmos5l_a21oi_1
XFILLER_20_476 vddd vssd sg13cmos5l_decap_4
X_6615_ _6620_/S _6615_/A _6736_/B vddd vssd sg13cmos5l_nor2_1
XFILLER_10_2009 vddd vssd sg13cmos5l_decap_4
X_3758_ _3758_/X _3758_/A wire76/A vddd vssd sg13cmos5l_and2_1
X_6546_ _6546_/Y _6727_/A _6552_/B vddd vssd sg13cmos5l_nor2_1
XFILLER_14_1466 vddd vssd sg13cmos5l_decap_8
XFILLER_31_2492 vddd vssd sg13cmos5l_decap_8
XFILLER_27_2506 vddd vssd sg13cmos5l_decap_8
X_6477_ _7190_/D _6492_/A1 _6481_/B hold961/X vddd vssd sg13cmos5l_o21ai_1
X_3689_ _3981_/A _3938_/B _3940_/B vddd vssd sg13cmos5l_nor2_1
X_5428_ _5428_/Y _5441_/C _5427_/Y _5442_/A vddd vssd sg13cmos5l_o21ai_1
XFILLER_9_2471 vddd vssd sg13cmos5l_decap_8
X_5359_ _5361_/B _5359_/A _5359_/B vddd vssd sg13cmos5l_nor2_1
XFILLER_25_2252 vddd vssd sg13cmos5l_decap_8
X_7029_ _7029_/Q _7201_/CLK _7029_/D fanout370/X vddd vssd sg13cmos5l_dfrbpq_1
XFILLER_9_1781 vddd vssd sg13cmos5l_decap_8
XFILLER_21_1459 vddd vssd sg13cmos5l_decap_8
XFILLER_28_587 vddd vssd sg13cmos5l_decap_4
XFILLER_3_1391 vddd vssd sg13cmos5l_decap_8
XFILLER_19_2045 vddd vssd sg13cmos5l_decap_4
XFILLER_15_237 vddd vssd sg13cmos5l_decap_8
XFILLER_12_911 vddd vssd sg13cmos5l_decap_4
XFILLER_32_2212 vddd vssd sg13cmos5l_decap_8
XFILLER_12_955 vddd vssd sg13cmos5l_decap_8
XFILLER_32_1555 vddd vssd sg13cmos5l_decap_8
XFILLER_23_84 vddd vssd sg13cmos5l_decap_8
XFILLER_11_487 vddd vssd sg13cmos5l_decap_8
XFILLER_10_2554 vddd vssd sg13cmos5l_decap_8
XFILLER_17_7 vddd vssd sg13cmos5l_decap_8
XFILLER_21_1982 vddd vssd sg13cmos5l_decap_8
XFILLER_0_77 vddd vssd sg13cmos5l_decap_8
XFILLER_19_2590 vddd vssd sg13cmos5l_decap_8
X_4730_ _4730_/Y _4730_/A _4732_/B vddd vssd sg13cmos5l_nand2_1
XFILLER_9_42 vddd vssd sg13cmos5l_decap_8
X_4661_ _4661_/Y _4546_/A _4659_/Y _4660_/Y vddd vssd sg13cmos5l_o21ai_1
XFILLER_15_2465 vddd vssd sg13cmos5l_decap_8
X_3612_ _3612_/Y _3612_/A vddd vssd sg13cmos5l_inv_1
X_6400_ _6400_/X _6400_/A0 _6722_/A _6401_/S vddd vssd sg13cmos5l_mux2_1
X_7380_ _7380_/Q _7380_/CLK _7380_/D _6894_/Y vddd vssd sg13cmos5l_dfrbpq_1
X_4592_ _4593_/C _4684_/A _4592_/B vddd vssd sg13cmos5l_nor2_1
X_6331_ _7112_/D _6738_/A1 _6338_/B hold606/X vddd vssd sg13cmos5l_a21oi_1
Xhold904 _4411_/B _4410_/Y vddd vssd sg13cmos5l_dlygate4sd3_1
XFILLER_11_1617 vddd vssd sg13cmos5l_decap_8
Xhold926 hold926/X _6763_/Y vddd vssd sg13cmos5l_dlygate4sd3_1
X_3543_ _3543_/Y _5727_/A vddd vssd sg13cmos5l_inv_1
Xhold915 hold915/X hold915/A vddd vssd sg13cmos5l_dlygate4sd3_1
Xhold937 hold937/X hold937/A vddd vssd sg13cmos5l_dlygate4sd3_1
X_6262_ _6262_/Y _6146_/A _6261_/B _6261_/Y _6170_/A _5270_/B vddd vssd sg13cmos5l_a221oi_1
Xhold948 _7111_/D _6328_/Y vddd vssd sg13cmos5l_dlygate4sd3_1
X_3474_ _3474_/Y _4765_/A vddd vssd sg13cmos5l_inv_1
Xhold959 _7157_/D _6416_/X vddd vssd sg13cmos5l_dlygate4sd3_1
X_6193_ _6193_/Y _4207_/Y _5218_/X _6192_/Y vddd vssd sg13cmos5l_o21ai_1
X_5213_ _5217_/C _4986_/A _5244_/B _5195_/Y vddd vssd sg13cmos5l_a21oi_1
X_5144_ _5148_/B _5225_/A _5144_/B vddd vssd sg13cmos5l_nor2_1
Xoutbuffers\[57\] voltgen_value[1] _7055_/Q vddd vssd sg13cmos5l_buf_16
XFILLER_22_2436 vddd vssd sg13cmos5l_decap_8
X_5075_ _5261_/A _7262_/Q _7263_/Q vddd vssd sg13cmos5l_nand2_1
XFILLER_20_2160 vddd vssd sg13cmos5l_decap_8
X_4026_ _4030_/A _3694_/Y _6144_/A _6561_/A vddd vssd sg13cmos5l_a21oi_1
XFILLER_0_2298 vddd vssd sg13cmos5l_decap_8
X_5977_ _5977_/Y _5977_/A _5977_/B _5977_/C vddd vssd sg13cmos5l_nor3_1
XFILLER_21_741 vddd vssd sg13cmos5l_decap_8
X_4928_ _4937_/B _4940_/A _4943_/A vddd vssd sg13cmos5l_nand2_1
X_4859_ _4859_/Y _4867_/A sram_odata[2] _4858_/Y vddd vssd sg13cmos5l_a21oi_1
XFILLER_14_1252 vddd vssd sg13cmos5l_decap_8
X_6529_ _6536_/B _6529_/A _6545_/B vddd vssd sg13cmos5l_nand2_1
XFILLER_27_1646 vddd vssd sg13cmos5l_decap_8
XFILLER_0_623 vddd vssd sg13cmos5l_decap_4
XFILLER_7_1707 vddd vssd sg13cmos5l_decap_8
XFILLER_25_2093 vddd vssd sg13cmos5l_decap_8
XFILLER_18_84 vddd vssd sg13cmos5l_decap_8
XFILLER_5_1486 vddd vssd sg13cmos5l_decap_8
XFILLER_16_557 vddd vssd sg13cmos5l_decap_8
XFILLER_19_1174 vddd vssd sg13cmos5l_decap_4
XFILLER_32_1352 vddd vssd sg13cmos5l_decap_8
XFILLER_10_2351 vddd vssd sg13cmos5l_decap_4
XFILLER_3_494 vddd vssd sg13cmos5l_decap_8
XFILLER_6_1239 vddd vssd sg13cmos5l_decap_8
X_5900_ _5905_/A _6230_/A _5897_/Y _5898_/Y _5896_/Y _5899_/Y vddd vssd sg13cmos5l_a221oi_1
X_6880_ _6880_/Y _6901_/A _6917_/B_N vddd vssd sg13cmos5l_nor2b_1
XFILLER_17_2527 vddd vssd sg13cmos5l_decap_8
X_5831_ _5831_/Y _7222_/Q _7223_/Q _5831_/C vddd vssd sg13cmos5l_nand3_1
X_5762_ _5762_/Y _5762_/A _7213_/Q _5762_/C vddd vssd sg13cmos5l_nor3_1
XFILLER_17_1859 vddd vssd sg13cmos5l_decap_4
X_4713_ _4713_/Y _4713_/A _4713_/B vddd vssd sg13cmos5l_nor2_1
X_5693_ _5693_/Y _5861_/A _7203_/Q _5693_/C vddd vssd sg13cmos5l_nand3b_1
X_4644_ _4645_/B _4698_/B _3601_/Y _4643_/Y vddd vssd sg13cmos5l_a21oi_1
XFILLER_11_1414 vddd vssd sg13cmos5l_decap_4
X_4575_ _4575_/Y _4575_/A _4575_/B vddd vssd sg13cmos5l_nor2_1
Xhold712 _7145_/D _6394_/Y vddd vssd sg13cmos5l_dlygate4sd3_1
Xhold701 hold701/X _6302_/Y vddd vssd sg13cmos5l_dlygate4sd3_1
X_7363_ _7363_/Q _7363_/CLK _7363_/D _6877_/Y vddd vssd sg13cmos5l_dfrbpq_1
XFILLER_28_2601 vddd vssd sg13cmos5l_decap_4
X_3526_ _3526_/Y _5936_/A vddd vssd sg13cmos5l_inv_1
Xhold745 _6380_/A _7139_/Q vddd vssd sg13cmos5l_dlygate4sd3_1
Xhold734 _7138_/D _6379_/Y vddd vssd sg13cmos5l_dlygate4sd3_1
X_6314_ _7104_/D _6738_/A1 _6321_/B hold791/X vddd vssd sg13cmos5l_a21oi_1
Xhold723 _4355_/A _7359_/Q vddd vssd sg13cmos5l_dlygate4sd3_1
X_7294_ _7294_/Q _7296_/CLK _7294_/D fanout375/X vddd vssd sg13cmos5l_dfrbpq_1
Xhold767 _6976_/D _5940_/Y vddd vssd sg13cmos5l_dlygate4sd3_1
X_6245_ _6245_/Y _6177_/A _5251_/B _5250_/A vddd vssd sg13cmos5l_a21oi_1
Xhold778 hold778/X _3533_/Y vddd vssd sg13cmos5l_dlygate4sd3_1
Xhold756 _7090_/D _6795_/Y vddd vssd sg13cmos5l_dlygate4sd3_1
XFILLER_24_2509 vddd vssd sg13cmos5l_decap_8
Xhold789 _6974_/D _5934_/Y vddd vssd sg13cmos5l_dlygate4sd3_1
Xclkbuf_leaf_19_SCK_regs _7285_/CLK clkload9/A vddd vssd sg13cmos5l_buf_8
XFILLER_22_2200 vddd vssd sg13cmos5l_decap_8
X_6176_ _6176_/Y _6174_/Y _6175_/X _6177_/B vddd vssd sg13cmos5l_o21ai_1
Xhold1401 _6580_/A1 _5204_/A vddd vssd sg13cmos5l_dlygate4sd3_1
XFILLER_29_126 vddd vssd sg13cmos5l_decap_8
X_5127_ _5131_/D _7286_/Q _7287_/Q _6145_/C vddd vssd sg13cmos5l_nor3_1
Xhold1412 hold1412/X _7231_/Q vddd vssd sg13cmos5l_dlygate4sd3_1
Xhold1423 _6566_/A1 _6235_/A vddd vssd sg13cmos5l_dlygate4sd3_1
XFILLER_6_1751 vddd vssd sg13cmos5l_decap_4
Xhold1434 _6389_/B1 _6388_/Y vddd vssd sg13cmos5l_dlygate4sd3_1
Xhold1467 _7051_/D _6729_/X vddd vssd sg13cmos5l_dlygate4sd3_1
Xhold1456 _6761_/A1 _7072_/Q vddd vssd sg13cmos5l_dlygate4sd3_1
Xhold1445 _7337_/D _4731_/Y vddd vssd sg13cmos5l_dlygate4sd3_1
X_5058_ _5067_/D _7264_/Q _7265_/Q _5246_/A vddd vssd sg13cmos5l_nor3_1
Xhold1489 _7022_/D hold496/X vddd vssd sg13cmos5l_dlygate4sd3_1
XFILLER_22_1554 vddd vssd sg13cmos5l_decap_8
X_4009_ _6702_/A _4009_/A _4009_/B _4010_/B _4010_/C vddd vssd sg13cmos5l_nor4_1
Xhold1478 hold1478/X _7385_/Q vddd vssd sg13cmos5l_dlygate4sd3_1
XFILLER_0_2062 vddd vssd sg13cmos5l_decap_4
XFILLER_16_1303 vddd vssd sg13cmos5l_decap_8
XFILLER_21_593 vddd vssd sg13cmos5l_decap_4
XFILLER_4_214 vddd vssd sg13cmos5l_decap_4
XFILLER_5_759 vddd vssd sg13cmos5l_decap_8
XFILLER_29_1719 vddd vssd sg13cmos5l_decap_8
XFILLER_20_63 vddd vssd sg13cmos5l_decap_8
XFILLER_0_453 vddd vssd sg13cmos5l_decap_8
XFILLER_21_1042 vddd vssd sg13cmos5l_decap_8
XFILLER_16_321 vddd vssd sg13cmos5l_decap_4
XFILLER_32_836 vddd vssd sg13cmos5l_decap_8
XFILLER_16_2582 vddd vssd sg13cmos5l_decap_8
XANTENNA_3 SDI vddd vssd sg13cmos5l_antennanp
XFILLER_12_2479 vddd vssd sg13cmos5l_decap_8
XFILLER_32_1193 vddd vssd sg13cmos5l_decap_8
X_4360_ _4360_/X _7089_/Q _4400_/B vddd vssd sg13cmos5l_or2_1
X_4291_ _4291_/Y _4309_/C _4291_/B vddd vssd sg13cmos5l_nor2_1
X_6030_ _6030_/Y _7291_/Q _6028_/Y _6029_/Y vddd vssd sg13cmos5l_o21ai_1
XFILLER_23_2531 vddd vssd sg13cmos5l_decap_8
XFILLER_6_1069 vddd vssd sg13cmos5l_decap_8
XFILLER_26_118 vddd vssd sg13cmos5l_decap_8
X_6932_ _6932_/Y _6952_/A _6952_/B_N vddd vssd sg13cmos5l_nor2b_1
X_6863_ _6863_/Y _6952_/A _6952_/B_N vddd vssd sg13cmos5l_nor2b_1
X_5814_ _5814_/Y _5812_/Y _5814_/B vddd vssd sg13cmos5l_nand2b_1
XFILLER_17_2368 vddd vssd sg13cmos5l_decap_8
X_6794_ _6794_/Y _6794_/A _6801_/B vddd vssd sg13cmos5l_nor2_1
X_5745_ _5760_/C _7210_/Q _7211_/Q vddd vssd sg13cmos5l_nand2_1
XFILLER_30_2546 vddd vssd sg13cmos5l_decap_8
X_5676_ _5676_/Y _5671_/Y _5672_/X _5675_/Y vddd vssd sg13cmos5l_o21ai_1
X_4627_ _4627_/Y _4668_/A _4626_/Y _4650_/A vddd vssd sg13cmos5l_a21oi_1
Xhold520 _4514_/A _7017_/Q vddd vssd sg13cmos5l_dlygate4sd3_1
Xhold531 _6993_/D _3482_/Y vddd vssd sg13cmos5l_dlygate4sd3_1
X_7346_ _7346_/Q _7346_/CLK _7346_/D _6860_/Y vddd vssd sg13cmos5l_dfrbpq_1
Xhold553 _6983_/D _6814_/X vddd vssd sg13cmos5l_dlygate4sd3_1
X_4558_ _4558_/Y _5659_/A _4549_/X _4818_/B vddd vssd sg13cmos5l_o21ai_1
Xhold542 _4813_/B _6983_/Q vddd vssd sg13cmos5l_dlygate4sd3_1
XFILLER_11_1277 vddd vssd sg13cmos5l_decap_8
XFILLER_28_2475 vddd vssd sg13cmos5l_decap_8
X_7277_ _7277_/Q _7300_/CLK _7277_/D fanout384/X vddd vssd sg13cmos5l_dfrbpq_1
X_4489_ _4490_/B _4566_/A1 _4479_/B _4483_/B _4488_/A vddd vssd sg13cmos5l_a22oi_1
Xhold564 _6813_/A _6988_/Q vddd vssd sg13cmos5l_dlygate4sd3_1
Xhold586 _6987_/D _3486_/Y vddd vssd sg13cmos5l_dlygate4sd3_1
Xhold575 hold575/X _3862_/Y vddd vssd sg13cmos5l_dlygate4sd3_1
XFILLER_8_2536 vddd vssd sg13cmos5l_decap_8
Xhold597 _4913_/B _4911_/Y vddd vssd sg13cmos5l_dlygate4sd3_1
X_3509_ _3509_/Y _7124_/Q vddd vssd sg13cmos5l_inv_1
XFILLER_24_1605 vddd vssd sg13cmos5l_decap_8
X_6228_ _6230_/B _7234_/Q _7235_/Q _6228_/C vddd vssd sg13cmos5l_nor3_1
X_6159_ _6159_/Y _6156_/Y _6157_/Y _6144_/B vddd vssd sg13cmos5l_o21ai_1
Xhold1231 _7069_/D _6757_/X vddd vssd sg13cmos5l_dlygate4sd3_1
Xhold1220 _7025_/D _6691_/Y vddd vssd sg13cmos5l_dlygate4sd3_1
Xhold1242 _7259_/D _6606_/X vddd vssd sg13cmos5l_dlygate4sd3_1
Xhold1275 _3551_/A _7158_/Q vddd vssd sg13cmos5l_dlygate4sd3_1
Xhold1264 _7251_/D _6594_/Y vddd vssd sg13cmos5l_dlygate4sd3_1
Xhold1253 _6449_/A1 _5498_/B vddd vssd sg13cmos5l_dlygate4sd3_1
Xhold1297 _4308_/B _4304_/B vddd vssd sg13cmos5l_dlygate4sd3_1
Xhold1286 _4910_/A _4909_/Y vddd vssd sg13cmos5l_dlygate4sd3_1
XFILLER_26_663 vddd vssd sg13cmos5l_decap_8
XFILLER_25_173 vddd vssd sg13cmos5l_decap_8
XFILLER_15_63 vddd vssd sg13cmos5l_decap_8
XFILLER_12_1008 vddd vssd sg13cmos5l_decap_8
XFILLER_31_51 vddd vssd sg13cmos5l_decap_8
XFILLER_29_2217 vddd vssd sg13cmos5l_decap_4
XFILLER_29_1516 vddd vssd sg13cmos5l_decap_8
Xtiedowns\[56\] mask_rev_in[12] vddd vssd sg13cmos5l_antennanp
XFILLER_7_2024 vddd vssd sg13cmos5l_decap_8
XFILLER_23_1148 vddd vssd sg13cmos5l_decap_4
XFILLER_32_655 vddd vssd sg13cmos5l_decap_8
XFILLER_31_121 vddd vssd sg13cmos5l_decap_8
XFILLER_14_2519 vddd vssd sg13cmos5l_decap_8
X_3860_ _3860_/Y _3860_/A _4182_/B vddd vssd sg13cmos5l_nand2_1
X_3791_ _3791_/Y _3791_/A _4182_/B vddd vssd sg13cmos5l_nand2_1
XFILLER_31_198 vddd vssd sg13cmos5l_decap_8
XFILLER_14_1818 vddd vssd sg13cmos5l_decap_8
X_5530_ _5531_/B _5530_/A _5530_/B vddd vssd sg13cmos5l_nor2_1
X_5461_ _5461_/Y _5459_/Y _5460_/Y _5472_/C vddd vssd sg13cmos5l_o21ai_1
XFILLER_8_361 vddd vssd sg13cmos5l_decap_8
XFILLER_9_884 vddd vssd sg13cmos5l_decap_8
X_7200_ _7200_/Q _7200_/CLK _7200_/D fanout367/X vddd vssd sg13cmos5l_dfrbpq_1
X_4412_ _4412_/Y _4412_/A _4415_/B vddd vssd sg13cmos5l_nor2_1
XFILLER_12_1553 vddd vssd sg13cmos5l_decap_8
X_5392_ _5392_/Y _5388_/Y _5390_/X _5391_/Y vddd vssd sg13cmos5l_o21ai_1
XFILLER_28_1015 vddd vssd sg13cmos5l_decap_8
X_7131_ _7131_/Q _7135_/CLK _7131_/D fanout390/X vddd vssd sg13cmos5l_dfrbpq_1
X_4343_ _4343_/Y _4339_/B _4355_/B _4346_/A vddd vssd sg13cmos5l_a21oi_1
X_7062_ _7062_/Q _7190_/CLK _7062_/D fanout351/X vddd vssd sg13cmos5l_dfrbpq_1
Xfanout318 _6239_/A _6188_/A vddd vssd sg13cmos5l_buf_1
Xfanout307 _5308_/D _7149_/Q vddd vssd sg13cmos5l_buf_1
Xfanout329 _6713_/A1 _6748_/A1 vddd vssd sg13cmos5l_buf_1
X_4274_ _4274_/X _6777_/A _6801_/A _4279_/B vddd vssd sg13cmos5l_mux2_1
X_6013_ _6013_/Y _5315_/A _6057_/B _6012_/Y vddd vssd sg13cmos5l_a21oi_1
XFILLER_3_2411 vddd vssd sg13cmos5l_decap_8
XFILLER_3_2455 vddd vssd sg13cmos5l_decap_4
X_6915_ _6915_/Y _6917_/A _6915_/B_N vddd vssd sg13cmos5l_nor2b_1
X_6846_ _6846_/Y _6952_/A _6952_/B_N vddd vssd sg13cmos5l_nor2b_1
X_6777_ _6777_/Y _6777_/A _6777_/B vddd vssd sg13cmos5l_nand2_1
XFILLER_17_1442 vddd vssd sg13cmos5l_decap_8
XFILLER_17_1486 vddd vssd sg13cmos5l_decap_8
X_5728_ _5729_/D _5841_/A _5732_/B _5728_/C vddd vssd sg13cmos5l_nand3_1
X_3989_ _3989_/Y _7123_/Q _3717_/Y _6329_/A vddd vssd sg13cmos5l_o21ai_1
XFILLER_30_1653 vddd vssd sg13cmos5l_decap_8
X_5659_ _5659_/Y _5659_/A _5666_/B vddd vssd sg13cmos5l_nor2_1
XFILLER_11_1030 vddd vssd sg13cmos5l_decap_4
Xclkbuf_leaf_34_SCK_regs _7228_/CLK clkload3/A vddd vssd sg13cmos5l_buf_8
X_7329_ _7329_/Q _7398_/CLK _7329_/D _6843_/Y vddd vssd sg13cmos5l_dfrbpq_1
XFILLER_8_1621 vddd vssd sg13cmos5l_decap_8
XFILLER_8_1665 vddd vssd sg13cmos5l_decap_8
Xhold1050 _5944_/A _3527_/Y vddd vssd sg13cmos5l_dlygate4sd3_1
XFILLER_18_416 vddd vssd sg13cmos5l_decap_4
XFILLER_6_2090 vddd vssd sg13cmos5l_decap_8
Xhold1094 _6769_/A0 _7076_/Q vddd vssd sg13cmos5l_dlygate4sd3_1
Xhold1083 _7037_/D _6708_/X vddd vssd sg13cmos5l_dlygate4sd3_1
Xhold1072 _4404_/A _7355_/Q vddd vssd sg13cmos5l_dlygate4sd3_1
Xhold1061 _5985_/A0 _4942_/A vddd vssd sg13cmos5l_dlygate4sd3_1
XFILLER_26_62 vddd vssd sg13cmos5l_decap_8
XFILLER_14_622 vddd vssd sg13cmos5l_decap_8
XFILLER_18_1217 vddd vssd sg13cmos5l_decap_8
XFILLER_14_666 vddd vssd sg13cmos5l_decap_8
XFILLER_13_2541 vddd vssd sg13cmos5l_decap_8
XFILLER_13_1862 vddd vssd sg13cmos5l_decap_8
XFILLER_6_876 vddd vssd sg13cmos5l_decap_8
XFILLER_5_375 vddd vssd sg13cmos5l_decap_8
XFILLER_27_1092 vddd vssd sg13cmos5l_decap_8
XFILLER_7_1164 vddd vssd sg13cmos5l_decap_8
XFILLER_20_2556 vddd vssd sg13cmos5l_decap_8
XFILLER_20_1833 vddd vssd sg13cmos5l_decap_8
Xwire17 wire17/X wire18/X vddd vssd sg13cmos5l_buf_2
XFILLER_24_408 vddd vssd sg13cmos5l_decap_8
Xwire28 wire28/X wire28/A vddd vssd sg13cmos5l_buf_4
XFILLER_17_482 vddd vssd sg13cmos5l_decap_4
X_4961_ _4961_/Y _4961_/A _4961_/B vddd vssd sg13cmos5l_xnor2_1
X_6700_ _6700_/X _6700_/A0 _6668_/A _6709_/S vddd vssd sg13cmos5l_mux2_1
X_3912_ _3912_/Y _6232_/B _6561_/A _3909_/Y _3906_/Y _6554_/A vddd vssd sg13cmos5l_a221oi_1
X_4892_ _4899_/A _4901_/B _4892_/B vddd vssd sg13cmos5l_nor2_1
X_6631_ _6631_/X _6631_/A0 _6773_/A _6632_/S vddd vssd sg13cmos5l_mux2_1
X_3843_ wire21/A _3840_/Y _3841_/Y _3842_/Y vddd vssd sg13cmos5l_o21ai_1
XFILLER_20_647 vddd vssd sg13cmos5l_decap_8
X_3774_ _3774_/Y _7056_/Q _6726_/A vddd vssd sg13cmos5l_nand2b_1
X_6562_ _6562_/Y _6727_/A _6567_/S vddd vssd sg13cmos5l_nor2_1
X_6493_ _6493_/Y _6532_/A _6496_/B vddd vssd sg13cmos5l_nor2_1
X_5513_ _5514_/C _5513_/A _7181_/Q vddd vssd sg13cmos5l_nand2_1
XFILLER_12_2084 vddd vssd sg13cmos5l_decap_8
Xoutbuffers\[87\] io_out[2] _6056_/Y vddd vssd sg13cmos5l_buf_16
X_5444_ _5444_/Y _5439_/Y _5440_/X _5443_/Y vddd vssd sg13cmos5l_o21ai_1
XFILLER_25_2412 vddd vssd sg13cmos5l_decap_8
X_7114_ _7114_/Q _7135_/CLK _7114_/D _6958_/B_N vddd vssd sg13cmos5l_dfrbpq_1
X_5375_ _5375_/X _5484_/A _5386_/A vddd vssd sg13cmos5l_or2_1
Xfanout104 _6653_/A _3709_/Y vddd vssd sg13cmos5l_buf_1
XFILLER_29_1880 vddd vssd sg13cmos5l_decap_4
Xfanout137 _3938_/B _3878_/B vddd vssd sg13cmos5l_buf_1
X_4326_ _4326_/Y _4333_/A _4336_/A _4326_/C vddd vssd sg13cmos5l_nand3_1
Xfanout115 _6736_/B _6300_/Y vddd vssd sg13cmos5l_buf_1
Xfanout126 _4818_/B _4458_/Y vddd vssd sg13cmos5l_buf_1
X_7045_ _7045_/Q _7071_/CLK _7045_/D fanout346/X vddd vssd sg13cmos5l_dfrbpq_1
XFILLER_25_2489 vddd vssd sg13cmos5l_decap_8
Xfanout148 _5233_/A _5182_/A vddd vssd sg13cmos5l_buf_1
Xfanout159 _5991_/S _5985_/S vddd vssd sg13cmos5l_buf_1
X_4257_ _4258_/D _7086_/Q _3848_/B _6779_/A _4458_/B vddd vssd sg13cmos5l_a22oi_1
X_4188_ _4188_/Y _6702_/A _4186_/Y wire92/X vddd vssd sg13cmos5l_a21oi_1
XFILLER_19_1504 vddd vssd sg13cmos5l_decap_8
X_6829_ _6829_/Y _6835_/A _6835_/B_N vddd vssd sg13cmos5l_nor2b_1
XFILLER_23_485 vddd vssd sg13cmos5l_decap_8
XFILLER_11_625 vddd vssd sg13cmos5l_decap_8
XFILLER_32_1726 vddd vssd sg13cmos5l_decap_8
XFILLER_6_117 vddd vssd sg13cmos5l_decap_8
XFILLER_12_42 vddd vssd sg13cmos5l_decap_8
XFILLER_30_1472 vddd vssd sg13cmos5l_decap_8
XFILLER_12_86 vddd vssd sg13cmos5l_decap_8
XFILLER_3_835 vddd vssd sg13cmos5l_decap_8
XFILLER_8_2163 vddd vssd sg13cmos5l_decap_4
XFILLER_4_1315 vddd vssd sg13cmos5l_decap_8
Xtiedowns\[19\] _6219_/A vddd vssd sg13cmos5l_antennanp
XFILLER_19_758 vddd vssd sg13cmos5l_decap_8
XFILLER_4_1348 vddd vssd sg13cmos5l_decap_8
XFILLER_18_257 vddd vssd sg13cmos5l_decap_8
XFILLER_18_1003 vddd vssd sg13cmos5l_decap_8
XFILLER_30_934 vddd vssd sg13cmos5l_decap_8
XFILLER_15_1946 vddd vssd sg13cmos5l_decap_8
X_3490_ _4308_/A _4287_/B vddd vssd sg13cmos5l_inv_1
XFILLER_10_691 vddd vssd sg13cmos5l_decap_8
XFILLER_13_1692 vddd vssd sg13cmos5l_decap_8
X_5160_ _5162_/A _5249_/A _5174_/B vddd vssd sg13cmos5l_nor2_1
X_5091_ _5173_/A _7266_/Q _7267_/Q vddd vssd sg13cmos5l_nand2_1
X_4111_ _4111_/Y _7247_/Q _3892_/Y _6576_/A _7243_/Q _4115_/A vddd vssd sg13cmos5l_a221oi_1
X_4042_ _4042_/Y _7204_/Q _6498_/A _6490_/A _5673_/A _6483_/A vddd vssd sg13cmos5l_a221oi_1
XFILLER_20_2386 vddd vssd sg13cmos5l_decap_8
XFILLER_0_2447 vddd vssd sg13cmos5l_decap_8
XFILLER_4_2594 vddd vssd sg13cmos5l_decap_8
X_5993_ _5993_/Y _6170_/A _5009_/C _5009_/B vddd vssd sg13cmos5l_a21oi_1
XFILLER_20_1674 vddd vssd sg13cmos5l_decap_8
XFILLER_20_1696 vddd vssd sg13cmos5l_decap_8
XFILLER_17_290 vddd vssd sg13cmos5l_decap_8
Xclkbuf_3_2_0_SCK_regs clkload4/A clkbuf_0_SCK_regs/X vddd vssd sg13cmos5l_buf_8
X_4944_ _7310_/D _4942_/A _4954_/B _4943_/Y vddd vssd sg13cmos5l_a21o_1
XFILLER_32_282 vddd vssd sg13cmos5l_decap_8
XFILLER_21_945 vddd vssd sg13cmos5l_decap_8
X_4875_ _4875_/X _4961_/A _7136_/Q vddd vssd sg13cmos5l_or2_1
X_3826_ _3826_/Y _3938_/A _3936_/B _3846_/A vddd vssd sg13cmos5l_nor3_1
XFILLER_14_2168 vddd vssd sg13cmos5l_decap_8
X_6614_ _6614_/X _6614_/A0 _6336_/A _6614_/S vddd vssd sg13cmos5l_mux2_1
XFILLER_14_1401 vddd vssd sg13cmos5l_decap_8
XFILLER_14_1423 vddd vssd sg13cmos5l_decap_4
XFILLER_31_2471 vddd vssd sg13cmos5l_decap_8
X_3757_ wire76/A _3922_/B wire95/A _3755_/A vddd vssd sg13cmos5l_o21ai_1
X_6545_ _6552_/B _6545_/A _6545_/B vddd vssd sg13cmos5l_nand2_1
XFILLER_31_1792 vddd vssd sg13cmos5l_decap_8
X_6476_ _6476_/Y _6476_/A _6481_/B vddd vssd sg13cmos5l_nand2_1
X_3688_ _3878_/C _3753_/B _3753_/A vddd vssd sg13cmos5l_nand2b_1
X_5427_ _5427_/Y _7337_/Q _5441_/B vddd vssd sg13cmos5l_nor2b_1
XFILLER_9_2450 vddd vssd sg13cmos5l_decap_8
X_5358_ _5359_/B _5360_/C _5355_/Y _5360_/B vddd vssd sg13cmos5l_a21oi_1
X_4309_ _4964_/B _4309_/A _4309_/B _4309_/C vddd vssd sg13cmos5l_nor3_1
XFILLER_9_1760 vddd vssd sg13cmos5l_decap_8
X_7028_ _7028_/Q _7301_/CLK _7028_/D fanout370/X vddd vssd sg13cmos5l_dfrbpq_1
X_5289_ _5304_/A _5294_/A _7147_/Q vddd vssd sg13cmos5l_nand2_1
XFILLER_25_1585 vddd vssd sg13cmos5l_decap_8
XFILLER_21_1438 vddd vssd sg13cmos5l_decap_8
XFILLER_3_2071 vddd vssd sg13cmos5l_decap_8
XFILLER_30_219 vddd vssd sg13cmos5l_decap_8
XFILLER_19_1334 vddd vssd sg13cmos5l_decap_8
XFILLER_12_934 vddd vssd sg13cmos5l_decap_8
XFILLER_23_63 vddd vssd sg13cmos5l_decap_8
XFILLER_32_2279 vddd vssd sg13cmos5l_decap_8
XFILLER_10_2533 vddd vssd sg13cmos5l_decap_8
XFILLER_3_654 vddd vssd sg13cmos5l_decap_8
XFILLER_3_0 vddd vssd sg13cmos5l_decap_8
XFILLER_3_687 vddd vssd sg13cmos5l_decap_8
XFILLER_10_1898 vddd vssd sg13cmos5l_decap_8
XFILLER_8_1270 vddd vssd sg13cmos5l_decap_8
XFILLER_19_555 vddd vssd sg13cmos5l_decap_8
XFILLER_0_56 vddd vssd sg13cmos5l_decap_8
XFILLER_9_21 vddd vssd sg13cmos5l_decap_8
XFILLER_15_2444 vddd vssd sg13cmos5l_decap_8
XFILLER_30_742 vddd vssd sg13cmos5l_decap_8
X_4660_ _4660_/Y _4684_/A _4658_/Y _4685_/A vddd vssd sg13cmos5l_a21oi_1
XFILLER_19_1890 vddd vssd sg13cmos5l_decap_8
X_3611_ _3611_/Y _3611_/A vddd vssd sg13cmos5l_inv_1
X_4591_ _4592_/B _4771_/A1 _3863_/A _4771_/B1 _4586_/B vddd vssd sg13cmos5l_a22oi_1
X_6330_ _6330_/Y _6330_/A _6338_/B vddd vssd sg13cmos5l_nor2_1
XFILLER_7_971 vddd vssd sg13cmos5l_decap_8
X_3542_ _5752_/A _5783_/A vddd vssd sg13cmos5l_inv_1
Xhold927 _6598_/A _7254_/Q vddd vssd sg13cmos5l_dlygate4sd3_1
Xhold905 _7354_/D _4411_/Y vddd vssd sg13cmos5l_dlygate4sd3_1
Xhold916 hold916/X _4961_/A vddd vssd sg13cmos5l_dlygate4sd3_1
X_3473_ _3473_/Y _4677_/A vddd vssd sg13cmos5l_inv_1
X_6261_ _6261_/Y _6261_/A _6261_/B vddd vssd sg13cmos5l_nor2_1
Xhold949 hold949/X hold949/A vddd vssd sg13cmos5l_dlygate4sd3_1
Xhold938 hold938/X _4958_/A vddd vssd sg13cmos5l_dlygate4sd3_1
X_6192_ _6192_/Y _6192_/A vddd vssd sg13cmos5l_inv_1
X_5212_ _6170_/B _5212_/A _5212_/B _6188_/C vddd vssd sg13cmos5l_nor3_1
X_5143_ _6103_/D _5219_/A _5171_/B vddd vssd sg13cmos5l_nor2_1
XFILLER_6_1900 vddd vssd sg13cmos5l_decap_8
XFILLER_26_2584 vddd vssd sg13cmos5l_decap_8
XFILLER_22_1736 vddd vssd sg13cmos5l_decap_8
X_5074_ _6069_/B _7258_/Q _7259_/Q _5074_/C vddd vssd sg13cmos5l_nand3_1
X_4025_ _6144_/A dbus_in_left[2] dbus_in_right[2] vddd vssd sg13cmos5l_or2_1
XFILLER_4_2391 vddd vssd sg13cmos5l_decap_4
XFILLER_4_1690 vddd vssd sg13cmos5l_decap_8
XFILLER_0_2277 vddd vssd sg13cmos5l_decap_8
XFILLER_25_569 vddd vssd sg13cmos5l_decap_8
X_5976_ _5977_/C _5976_/A _5976_/B vddd vssd sg13cmos5l_and2_1
XFILLER_16_1518 vddd vssd sg13cmos5l_decap_8
X_4927_ _4943_/A _4942_/A _4942_/B vddd vssd sg13cmos5l_and2_1
XFILLER_18_2090 vddd vssd sg13cmos5l_decap_8
X_4858_ _4858_/Y _4852_/B _4857_/Y _4867_/A vddd vssd sg13cmos5l_a21oi_1
X_3809_ _3810_/D mask_rev_in[5] _4172_/B1 _4256_/B _7101_/Q vddd vssd sg13cmos5l_a22oi_1
X_4789_ _4792_/B _4806_/A _4789_/B _4790_/B vddd vssd sg13cmos5l_nand3_1
X_6528_ _7217_/D _6552_/A _6528_/A1 _6528_/S vddd vssd sg13cmos5l_mux2_1
X_6459_ _6459_/Y _6459_/A _6459_/B vddd vssd sg13cmos5l_nor2_1
XFILLER_27_1625 vddd vssd sg13cmos5l_decap_8
XFILLER_21_1202 vddd vssd sg13cmos5l_decap_8
XFILLER_5_2199 vddd vssd sg13cmos5l_decap_4
XFILLER_18_63 vddd vssd sg13cmos5l_decap_8
XFILLER_32_2021 vddd vssd sg13cmos5l_decap_8
XFILLER_15_1028 vddd vssd sg13cmos5l_decap_8
XFILLER_32_2065 vddd vssd sg13cmos5l_decap_8
XFILLER_12_1916 vddd vssd sg13cmos5l_decap_8
XFILLER_3_451 vddd vssd sg13cmos5l_decap_8
XFILLER_10_1673 vddd vssd sg13cmos5l_decap_8
XFILLER_6_1218 vddd vssd sg13cmos5l_decap_8
XFILLER_17_2506 vddd vssd sg13cmos5l_decap_8
X_5830_ _5831_/C _7225_/Q _5830_/B vddd vssd sg13cmos5l_nand2_1
X_5761_ _5761_/Y _5727_/A _5759_/C _5759_/Y vddd vssd sg13cmos5l_o21ai_1
X_4712_ _4713_/B _6012_/A _4712_/B vddd vssd sg13cmos5l_nor2_1
X_5692_ _5692_/Y _4385_/A _5685_/B _5691_/X vddd vssd sg13cmos5l_o21ai_1
X_4643_ _4643_/Y _4662_/A _4698_/B vddd vssd sg13cmos5l_nor2_1
XFILLER_11_2149 vddd vssd sg13cmos5l_decap_8
X_4574_ _4575_/B _4620_/B _3863_/A _4573_/Y vddd vssd sg13cmos5l_a21oi_1
Xhold702 _7097_/D _6303_/Y vddd vssd sg13cmos5l_dlygate4sd3_1
XFILLER_15_1595 vddd vssd sg13cmos5l_decap_8
XFILLER_11_1448 vddd vssd sg13cmos5l_decap_8
X_7362_ _7362_/Q _7386_/CLK _7362_/D _6876_/Y vddd vssd sg13cmos5l_dfrbpq_1
X_3525_ _3525_/Y _5933_/A vddd vssd sg13cmos5l_inv_1
Xhold746 hold746/X _6380_/Y vddd vssd sg13cmos5l_dlygate4sd3_1
X_7293_ _7293_/Q _7297_/CLK _7293_/D fanout377/X vddd vssd sg13cmos5l_dfrbpq_1
Xhold735 _4862_/A _7325_/Q vddd vssd sg13cmos5l_dlygate4sd3_1
Xhold713 _6790_/A _7088_/Q vddd vssd sg13cmos5l_dlygate4sd3_1
X_6313_ _6313_/Y _6313_/A _6321_/B vddd vssd sg13cmos5l_nor2_1
Xhold724 _4354_/A _4352_/Y vddd vssd sg13cmos5l_dlygate4sd3_1
X_6244_ _6244_/Y _3696_/Y _5253_/B _6242_/Y _6243_/Y vddd vssd sg13cmos5l_a22oi_1
Xhold768 _6386_/A _7142_/Q vddd vssd sg13cmos5l_dlygate4sd3_1
Xhold757 _4339_/B _7362_/Q vddd vssd sg13cmos5l_dlygate4sd3_1
Xhold779 _7091_/D _6797_/Y vddd vssd sg13cmos5l_dlygate4sd3_1
XFILLER_26_2381 vddd vssd sg13cmos5l_decap_8
X_6175_ _6175_/X _6175_/A _6175_/B vddd vssd sg13cmos5l_and2_1
XFILLER_29_105 vddd vssd sg13cmos5l_decap_8
Xhold1424 hold1424/X _7345_/Q vddd vssd sg13cmos5l_dlygate4sd3_1
X_5126_ _6145_/C _7289_/Q _7288_/Q vddd vssd sg13cmos5l_nand2b_1
Xhold1402 hold1402/X _7152_/Q vddd vssd sg13cmos5l_dlygate4sd3_1
XFILLER_6_1730 vddd vssd sg13cmos5l_decap_8
Xhold1413 _6557_/A1 _5901_/B vddd vssd sg13cmos5l_dlygate4sd3_1
Xhold1468 _3624_/A _7054_/Q vddd vssd sg13cmos5l_dlygate4sd3_1
Xhold1457 _7072_/D _6761_/X vddd vssd sg13cmos5l_dlygate4sd3_1
Xhold1446 hold1446/X _7287_/Q vddd vssd sg13cmos5l_dlygate4sd3_1
X_5057_ _5246_/A _7262_/Q _7263_/Q vddd vssd sg13cmos5l_nand2b_1
Xhold1435 _7143_/D _6389_/Y vddd vssd sg13cmos5l_dlygate4sd3_1
XFILLER_26_812 vddd vssd sg13cmos5l_decap_8
X_4008_ _4015_/A _6609_/A _4008_/B _4008_/C _4008_/D vddd vssd sg13cmos5l_nand4_1
Xhold1479 hold1479/X _7382_/Q vddd vssd sg13cmos5l_dlygate4sd3_1
XFILLER_25_322 vddd vssd sg13cmos5l_decap_8
XFILLER_16_2016 vddd vssd sg13cmos5l_decap_8
X_5959_ _5959_/Y _5888_/A _7241_/Q _5957_/Y vddd vssd sg13cmos5l_o21ai_1
XFILLER_20_42 vddd vssd sg13cmos5l_decap_8
XFILLER_11_1993 vddd vssd sg13cmos5l_decap_4
XFILLER_0_432 vddd vssd sg13cmos5l_decap_4
XFILLER_29_84 vddd vssd sg13cmos5l_decap_8
XFILLER_5_1240 vddd vssd sg13cmos5l_decap_8
XFILLER_17_801 vddd vssd sg13cmos5l_decap_8
XFILLER_28_193 vddd vssd sg13cmos5l_decap_8
XFILLER_21_1065 vddd vssd sg13cmos5l_decap_8
XFILLER_32_815 vddd vssd sg13cmos5l_decap_8
XFILLER_16_2561 vddd vssd sg13cmos5l_decap_8
XFILLER_12_2458 vddd vssd sg13cmos5l_decap_8
XFILLER_32_1172 vddd vssd sg13cmos5l_decap_8
XFILLER_8_598 vddd vssd sg13cmos5l_decap_8
XANTENNA_4 SDI vddd vssd sg13cmos5l_antennanp
XFILLER_6_44 vddd vssd sg13cmos5l_decap_4
XFILLER_12_1768 vddd vssd sg13cmos5l_decap_8
X_4290_ _4290_/X _4290_/A _4308_/A _4290_/C vddd vssd sg13cmos5l_and3_1
XFILLER_23_2510 vddd vssd sg13cmos5l_decap_8
XFILLER_23_2587 vddd vssd sg13cmos5l_decap_8
X_6931_ _6931_/Y _6952_/A _6952_/B_N vddd vssd sg13cmos5l_nor2b_1
X_6862_ _6862_/Y _6965_/A _6945_/B_N vddd vssd sg13cmos5l_nor2b_1
X_5813_ _5814_/B _5841_/A _7220_/Q _5813_/C _5813_/D vddd vssd sg13cmos5l_nand4_1
X_6793_ _6793_/Y _6782_/A _6801_/B hold690/X vddd vssd sg13cmos5l_a21oi_1
X_5744_ _5762_/C _7210_/Q _7211_/Q vddd vssd sg13cmos5l_nand2b_1
XFILLER_31_892 vddd vssd sg13cmos5l_decap_8
XFILLER_30_2525 vddd vssd sg13cmos5l_decap_8
X_5675_ _5675_/Y _5730_/A _5673_/Y _5674_/Y vddd vssd sg13cmos5l_a21oi_1
X_4626_ _4626_/Y _4628_/B _4626_/B vddd vssd sg13cmos5l_nand2b_1
Xhold510 _4971_/A _7020_/Q vddd vssd sg13cmos5l_dlygate4sd3_1
X_7345_ _7345_/Q clkload1/A _7345_/D _6859_/Y vddd vssd sg13cmos5l_dfrbpq_1
Xhold532 _4971_/B _7022_/Q vddd vssd sg13cmos5l_dlygate4sd3_1
Xhold521 _7018_/D _3470_/Y vddd vssd sg13cmos5l_dlygate4sd3_1
Xhold554 _6810_/A _6999_/Q vddd vssd sg13cmos5l_dlygate4sd3_1
X_4557_ _4557_/Y _4501_/B _4535_/Y _4556_/Y vddd vssd sg13cmos5l_a21oi_1
Xhold543 _6984_/D _3488_/Y vddd vssd sg13cmos5l_dlygate4sd3_1
XFILLER_11_1267 vddd vssd sg13cmos5l_decap_4
XFILLER_28_2454 vddd vssd sg13cmos5l_decap_8
XFILLER_24_2307 vddd vssd sg13cmos5l_decap_8
X_7276_ _7276_/Q _7276_/CLK _7276_/D fanout384/X vddd vssd sg13cmos5l_dfrbpq_1
X_3508_ _3508_/Y _7139_/Q vddd vssd sg13cmos5l_inv_1
Xhold565 _6989_/D _6813_/X vddd vssd sg13cmos5l_dlygate4sd3_1
Xhold587 _3793_/A _7394_/Q vddd vssd sg13cmos5l_dlygate4sd3_1
Xhold576 _7392_/D _4003_/Y vddd vssd sg13cmos5l_dlygate4sd3_1
XFILLER_8_2515 vddd vssd sg13cmos5l_decap_8
X_4488_ _4488_/Y _4488_/A vddd vssd sg13cmos5l_inv_1
X_6227_ _6227_/Y _6227_/A _6227_/B _6227_/C vddd vssd sg13cmos5l_nor3_1
Xhold598 _7399_/D _5276_/Y vddd vssd sg13cmos5l_dlygate4sd3_1
X_6158_ _6158_/Y _6272_/A _6158_/B vddd vssd sg13cmos5l_nor2_1
XFILLER_6_2261 vddd vssd sg13cmos5l_decap_4
X_5109_ _5171_/B _7285_/Q _7284_/Q vddd vssd sg13cmos5l_nand2b_1
Xhold1210 _6643_/A0 _7283_/Q vddd vssd sg13cmos5l_dlygate4sd3_1
Xhold1243 _3535_/A _7026_/Q vddd vssd sg13cmos5l_dlygate4sd3_1
Xhold1232 _3619_/A _7060_/Q vddd vssd sg13cmos5l_dlygate4sd3_1
Xhold1221 _6588_/A0 _7248_/Q vddd vssd sg13cmos5l_dlygate4sd3_1
Xhold1276 _6419_/A1 _5373_/A vddd vssd sg13cmos5l_dlygate4sd3_1
Xhold1265 _6749_/A1 _7063_/Q vddd vssd sg13cmos5l_dlygate4sd3_1
Xhold1254 _6750_/A1 _7064_/Q vddd vssd sg13cmos5l_dlygate4sd3_1
XFILLER_22_2086 vddd vssd sg13cmos5l_decap_8
XFILLER_22_1341 vddd vssd sg13cmos5l_decap_8
X_6089_ _6089_/Y _6087_/Y _6088_/X _5133_/C vddd vssd sg13cmos5l_o21ai_1
XFILLER_22_1363 vddd vssd sg13cmos5l_decap_8
Xhold1287 _3590_/A _7228_/Q vddd vssd sg13cmos5l_dlygate4sd3_1
Xhold1298 _7371_/D _4308_/Y vddd vssd sg13cmos5l_dlygate4sd3_1
XFILLER_25_163 vddd vssd sg13cmos5l_decap_8
XFILLER_14_826 vddd vssd sg13cmos5l_decap_8
XFILLER_15_42 vddd vssd sg13cmos5l_decap_8
XFILLER_16_1112 vddd vssd sg13cmos5l_decap_8
XFILLER_31_30 vddd vssd sg13cmos5l_decap_8
Xtiedowns\[49\] mask_rev_in[5] vddd vssd sg13cmos5l_antennanp
XFILLER_7_1324 vddd vssd sg13cmos5l_decap_8
XFILLER_0_284 vddd vssd sg13cmos5l_decap_8
XFILLER_7_1379 vddd vssd sg13cmos5l_decap_8
XFILLER_31_100 vddd vssd sg13cmos5l_decap_8
Xclkbuf_leaf_4_SCK_regs _7231_/CLK clkload3/A vddd vssd sg13cmos5l_buf_8
XFILLER_32_634 vddd vssd sg13cmos5l_decap_8
XFILLER_31_177 vddd vssd sg13cmos5l_decap_8
XFILLER_18_1977 vddd vssd sg13cmos5l_decap_8
X_3790_ _3790_/Y _3793_/A _4267_/B _7023_/D vddd vssd sg13cmos5l_o21ai_1
X_5460_ _5460_/Y _5319_/A _5472_/B _5458_/Y vddd vssd sg13cmos5l_o21ai_1
X_4411_ _4411_/Y _4419_/A _4411_/B vddd vssd sg13cmos5l_nor2_1
X_5391_ _5391_/Y _5393_/B _5393_/C _5389_/Y _5795_/A1 vddd vssd sg13cmos5l_a22oi_1
X_7130_ _7130_/Q _7273_/CLK _7130_/D _6958_/B_N vddd vssd sg13cmos5l_dfrbpq_1
X_4342_ _4342_/Y _4342_/A _4348_/A _5279_/A vddd vssd sg13cmos5l_nand3_1
X_7061_ _7061_/Q _7146_/CLK _7061_/D fanout350/X vddd vssd sg13cmos5l_dfrbpq_1
Xfanout319 _6267_/A1 _3696_/Y vddd vssd sg13cmos5l_buf_1
Xfanout308 _4771_/A1 _4659_/A1 vddd vssd sg13cmos5l_buf_1
X_4273_ _7387_/D _6801_/A _6344_/A _4279_/B vddd vssd sg13cmos5l_mux2_1
XFILLER_25_1915 vddd vssd sg13cmos5l_decap_8
X_6012_ _6012_/Y _6012_/A _6057_/B vddd vssd sg13cmos5l_nor2_1
.ends

.subckt chipalooza_frame vddd vdd3v3 vdd1v2 s1_an[0] s1_an[1] s2_an[0] s2_an[1] s3_an[0]
+ s3_an[1] s4_an[0] s5_an[0] s5_an[1] s5_an[2] s6_an[0] s6_an[1] s7_an[0] s7_an[1]
+ s8_an[0] s9_an[0] s9_an[1] s9_an[2] analog[0] analog[1] analog[2] analog[3] s10_an[0]
+ s10_an[1] s10_an[2] s11_an[0] s12_an[0] s12_an[1] s13_an[0] s13_an[1] s14_an[0]
+ s14_an[1] s14_an[2] s15_an[0] s16_an[0] s16_an[1] s17_an[0] s17_an[1] s18_an[0]
+ s18_an[1] SDO_out SDO_ena SDI_in CSB_in SCK_in clk_in gpio_in[0] gpio_out[0] gpio_oe[0]
+ gpio_in[1] gpio_out[1] gpio_oe[1] gpio_in[2] gpio_out[2] gpio_oe[2] gpio_in[3] gpio_out[3]
+ gpio_oe[3] gpio_in[4] gpio_out[4] gpio_oe[4] gpio_in[5] gpio_out[5] gpio_oe[5] gpio_in[6]
+ gpio_out[6] gpio_oe[6] gpio_in[7] gpio_out[7] gpio_oe[7] gpio_in[8] gpio_out[8]
+ gpio_oe[8] gpio_in[9] gpio_out[9] gpio_oe[9] gpio_in[10] gpio_out[10] gpio_oe[10]
+ gpio_in[11] gpio_out[11] gpio_oe[11] analog_esd[0] analog_esd[1] analog_esd[2] analog_esd[3]
+ s1_an_0_esd s1_an_1_esd s2_an_0_esd s2_an_1_esd s3_an_0_esd s3_an_1_esd s4_an_0_esd
+ s5_an_0_esd s5_an_1_esd s5_an_2_esd s6_an_0_esd s6_an_1_esd s7_an_0_esd s7_an_1_esd
+ s8_an_0_esd s9_an_0_esd s9_an_1_esd s9_an_2_esd s10_an_0_esd s10_an_1_esd s10_an_2_esd
+ s11_an_0_esd s12_an_0_esd s12_an_1_esd s13_an_0_esd s13_an_1_esd s14_an_0_esd s14_an_1_esd
+ s14_an_2_esd s15_an_0_esd s16_an_0_esd s16_an_1_esd s17_an_0_esd s17_an_1_esd s18_an_0_esd
+ s18_an_1_esd mask_rev[0] mask_rev[1] mask_rev[2] mask_rev[3] mask_rev[4] mask_rev[5]
+ mask_rev[6] mask_rev[7] mask_rev[8] mask_rev[9] mask_rev[10] mask_rev[11] mask_rev[12]
+ mask_rev[13] mask_rev[14] mask_rev[15] mask_rev[16] mask_rev[17] mask_rev[18] mask_rev[19]
+ mask_rev[20] mask_rev[21] mask_rev[22] mask_rev[23] mask_rev[24] mask_rev[25] mask_rev[26]
+ mask_rev[27] mask_rev[28] mask_rev[29] mask_rev[30] mask_rev[31] vdd1v2_uq0 vdd1v2_uq2
+ vss3v3
Xslot16_wrapper_0 vss3v3 s16_an[0] s16_an[1] s16_an_0_esd s16_an_1_esd slot16_wrapper_0/vbias
+ slot16_wrapper_0/dig_in[23] slot16_wrapper_0/dig_in[22] slot16_wrapper_0/dig_in[21]
+ slot16_wrapper_0/dig_in[20] slot16_wrapper_0/dig_in[19] slot16_wrapper_0/dig_in[18]
+ slot16_wrapper_0/dig_in[17] slot16_wrapper_0/dig_in[16] slot16_wrapper_0/dig_in[15]
+ slot16_wrapper_0/dig_in[14] slot16_wrapper_0/dig_in[13] slot16_wrapper_0/dig_in[12]
+ slot16_wrapper_0/dig_in[11] slot16_wrapper_0/dig_in[10] slot16_wrapper_0/dig_in[9]
+ slot16_wrapper_0/dig_in[8] slot16_wrapper_0/dig_in[7] slot16_wrapper_0/dig_in[6]
+ slot16_wrapper_0/dig_in[5] slot16_wrapper_0/dig_in[4] slot16_wrapper_0/dig_in[3]
+ slot16_wrapper_0/dig_in[2] slot16_wrapper_0/dig_in[1] slot16_wrapper_0/dig_in[0]
+ slot16_wrapper_0/dig_out[11] slot16_wrapper_0/dig_out[10] slot16_wrapper_0/dig_out[9]
+ slot16_wrapper_0/dig_out[8] slot16_wrapper_0/dig_out[7] slot16_wrapper_0/dig_out[6]
+ slot16_wrapper_0/dig_out[5] slot16_wrapper_0/dig_out[4] slot16_wrapper_0/dig_out[3]
+ slot16_wrapper_0/dig_out[2] slot16_wrapper_0/dig_out[1] slot16_wrapper_0/dig_out[0]
+ slot16_wrapper_0/ibias0 slot16_wrapper_0/ibias1 slot16_wrapper_0/analog_bus3 slot16_wrapper_0/analog_bus2
+ slot16_wrapper_0/analog_bus1 slot16_wrapper_0/analog_bus0 slot16_wrapper_0/vdd_1v2
+ vss3v3 slot16_wrapper_0/vdd_3v3 slot16_wrapper_0/enable slot16_wrapper_0/clk slot16_wrapper_0/reset
+ slot16_wrapper
Xanalog_switch_array_7[0] analog[0] analog_switch_array_7[0]/analog_switch_med_17/enable
+ analog_switch_small_1/in vss3v3 analog_switch_array_7[0]/analog_switch_med_0/enable
+ analog_switch_array_7[0]/analog_switch_med_2/enable vss3v3 slot1_wrapper_0/analog_bus1
+ vss3v3 slot1_wrapper_0/analog_bus3 analog_switch_array_7[0]/analog_switch_med_20/enable
+ analog_switch_array_7[0]/analog_switch_med_1/enable analog_pswitch_small_1/out vss3v3
+ vdd3v3 analog_switch_array_7[0]/analog_pswitch_small_3/enable analog_pswitch_small_0/out
+ slot1_wrapper_0/analog_bus0 vss3v3 slot18_wrapper_0/analog_bus2 vss3v3 analog_switch_array_7[0]/analog_pswitch_small_2/enable
+ vdd3v3 analog_switch_array_7[0]/analog_switch_small_1/enable vdd3v3 analog_switch_array_7[0]/analog_switch_med_3/enable
+ slot1_wrapper_0/vbias slot18_wrapper_0/analog_bus0 slot18_wrapper_0/analog_bus1
+ vdd1v2_uq2 slot18_wrapper_0/analog_bus3 vdd3v3 vss3v3 vdd1v2_uq2 vss3v3 slot18_wrapper_0/ibias0
+ slot1_wrapper_0/ibias1 slot1_wrapper_0/analog_bus2 analog_switch_array_7[0]/analog_pswitch_small_1/enable
+ vss3v3 vdd1v2_uq2 slot1_wrapper_0/ibias0 analog_switch_array_7[0]/analog_switch_small_0/enable
+ vss3v3 vdd1v2_uq2 vss3v3 vss3v3 vss3v3 vdd3v3 analog[2] analog[3] slot18_wrapper_0/ibias1
+ vss3v3 analog_switch_array_7[0]/analog_switch_med_18/enable slot18_wrapper_0/vbias
+ analog_switch_array_7[0]/analog_pswitch_small_0/enable vdd3v3 vss3v3 analog_switch_array_7[0]/analog_switch_med_22/enable
+ vdd1v2_uq2 vss3v3 vss3v3 vdd1v2_uq2 vss3v3 analog[1] vdd3v3 vdd1v2_uq2 vss3v3 vdd1v2_uq2
+ vss3v3 vss3v3 vss3v3 analog_switch_array
Xanalog_switch_array_7[1] analog[0] analog_switch_array_7[1]/analog_switch_med_17/enable
+ analog_switch_small_1/in vss3v3 analog_switch_array_7[1]/analog_switch_med_0/enable
+ analog_switch_array_7[1]/analog_switch_med_2/enable vss3v3 slot2_wrapper_0/analog_bus1
+ vss3v3 slot2_wrapper_0/analog_bus3 analog_switch_array_7[1]/analog_switch_med_20/enable
+ analog_switch_array_7[1]/analog_switch_med_1/enable analog_pswitch_small_1/out vss3v3
+ vdd3v3 analog_switch_array_7[1]/analog_pswitch_small_3/enable analog_pswitch_small_0/out
+ slot2_wrapper_0/analog_bus0 vss3v3 slot17_wrapper_0/analog_bus2 vss3v3 analog_switch_array_7[1]/analog_pswitch_small_2/enable
+ vdd3v3 analog_switch_array_7[1]/analog_switch_small_1/enable vdd3v3 analog_switch_array_7[1]/analog_switch_med_3/enable
+ slot2_wrapper_0/vbias slot17_wrapper_0/analog_bus0 slot17_wrapper_0/analog_bus1
+ vdd1v2_uq2 slot17_wrapper_0/analog_bus3 vdd3v3 vss3v3 vdd1v2_uq2 vss3v3 slot17_wrapper_0/ibias0
+ slot2_wrapper_0/ibias1 slot2_wrapper_0/analog_bus2 analog_switch_array_7[1]/analog_pswitch_small_1/enable
+ vss3v3 vdd1v2_uq2 slot2_wrapper_0/ibias0 analog_switch_array_7[1]/analog_switch_small_0/enable
+ vss3v3 vdd1v2_uq2 vss3v3 vss3v3 vss3v3 vdd3v3 analog[2] analog[3] slot17_wrapper_0/ibias1
+ vss3v3 analog_switch_array_7[1]/analog_switch_med_18/enable slot17_wrapper_0/vbias
+ analog_switch_array_7[1]/analog_pswitch_small_0/enable vdd3v3 vss3v3 analog_switch_array_7[1]/analog_switch_med_22/enable
+ vdd1v2_uq2 vss3v3 vss3v3 vdd1v2_uq2 vss3v3 analog[1] vdd3v3 vdd1v2_uq2 vss3v3 vdd1v2_uq2
+ vss3v3 vss3v3 vss3v3 analog_switch_array
Xanalog_switch_array_7[2] analog[0] analog_switch_array_7[2]/analog_switch_med_17/enable
+ analog_switch_small_1/in vss3v3 analog_switch_array_7[2]/analog_switch_med_0/enable
+ analog_switch_array_7[2]/analog_switch_med_2/enable vss3v3 slot3_wrapper_0/analog_bus1
+ vss3v3 slot3_wrapper_0/analog_bus3 analog_switch_array_7[2]/analog_switch_med_20/enable
+ analog_switch_array_7[2]/analog_switch_med_1/enable analog_pswitch_small_1/out vss3v3
+ vdd3v3 analog_switch_array_7[2]/analog_pswitch_small_3/enable analog_pswitch_small_0/out
+ slot3_wrapper_0/analog_bus0 vss3v3 slot16_wrapper_0/analog_bus2 vss3v3 analog_switch_array_7[2]/analog_pswitch_small_2/enable
+ vdd3v3 analog_switch_array_7[2]/analog_switch_small_1/enable vdd3v3 analog_switch_array_7[2]/analog_switch_med_3/enable
+ slot3_wrapper_0/vbias slot16_wrapper_0/analog_bus0 slot16_wrapper_0/analog_bus1
+ vdd1v2_uq2 slot16_wrapper_0/analog_bus3 vdd3v3 vss3v3 vdd1v2_uq2 vss3v3 slot16_wrapper_0/ibias0
+ slot3_wrapper_0/ibias1 slot3_wrapper_0/analog_bus2 analog_switch_array_7[2]/analog_pswitch_small_1/enable
+ vss3v3 vdd1v2_uq2 slot3_wrapper_0/ibias0 analog_switch_array_7[2]/analog_switch_small_0/enable
+ vss3v3 vdd1v2_uq2 vss3v3 vss3v3 vss3v3 vdd3v3 analog[2] analog[3] slot16_wrapper_0/ibias1
+ vss3v3 analog_switch_array_7[2]/analog_switch_med_18/enable slot16_wrapper_0/vbias
+ analog_switch_array_7[2]/analog_pswitch_small_0/enable vdd3v3 vss3v3 analog_switch_array_7[2]/analog_switch_med_22/enable
+ vdd1v2_uq2 vss3v3 vss3v3 vdd1v2_uq2 vss3v3 analog[1] vdd3v3 vdd1v2_uq2 vss3v3 vdd1v2_uq2
+ vss3v3 vss3v3 vss3v3 analog_switch_array
Xanalog_switch_array_7[3] analog[0] analog_switch_array_7[3]/analog_switch_med_17/enable
+ analog_switch_small_1/in vss3v3 analog_switch_array_7[3]/analog_switch_med_0/enable
+ analog_switch_array_7[3]/analog_switch_med_2/enable vss3v3 slot4_wrapper_0/analog_bus1
+ vss3v3 slot4_wrapper_0/analog_bus3 analog_switch_array_7[3]/analog_switch_med_20/enable
+ analog_switch_array_7[3]/analog_switch_med_1/enable analog_pswitch_small_1/out vss3v3
+ vdd3v3 analog_switch_array_7[3]/analog_pswitch_small_3/enable analog_pswitch_small_0/out
+ slot4_wrapper_0/analog_bus0 vss3v3 slot15_wrapper_0/analog_bus2 vss3v3 analog_switch_array_7[3]/analog_pswitch_small_2/enable
+ vdd3v3 analog_switch_array_7[3]/analog_switch_small_1/enable vdd3v3 analog_switch_array_7[3]/analog_switch_med_3/enable
+ slot4_wrapper_0/vbias slot15_wrapper_0/analog_bus0 slot15_wrapper_0/analog_bus1
+ vdd1v2_uq2 slot15_wrapper_0/analog_bus3 vdd3v3 vss3v3 vdd1v2_uq2 vss3v3 slot15_wrapper_0/ibias0
+ slot4_wrapper_0/ibias1 slot4_wrapper_0/analog_bus2 analog_switch_array_7[3]/analog_pswitch_small_1/enable
+ vss3v3 vdd1v2_uq2 slot4_wrapper_0/ibias0 analog_switch_array_7[3]/analog_switch_small_0/enable
+ vss3v3 vdd1v2_uq2 vss3v3 vss3v3 vss3v3 vdd3v3 analog[2] analog[3] slot15_wrapper_0/ibias1
+ vss3v3 analog_switch_array_7[3]/analog_switch_med_18/enable slot15_wrapper_0/vbias
+ analog_switch_array_7[3]/analog_pswitch_small_0/enable vdd3v3 vss3v3 analog_switch_array_7[3]/analog_switch_med_22/enable
+ vdd1v2_uq2 vss3v3 vss3v3 vdd1v2_uq2 vss3v3 analog[1] vdd3v3 vdd1v2_uq2 vss3v3 vdd1v2_uq2
+ vss3v3 vss3v3 vss3v3 analog_switch_array
Xanalog_switch_array_7[4] analog[0] analog_switch_array_7[4]/analog_switch_med_17/enable
+ analog_switch_small_1/in vss3v3 analog_switch_array_7[4]/analog_switch_med_0/enable
+ analog_switch_array_7[4]/analog_switch_med_2/enable vss3v3 slot5_wrapper_0/analog_bus1
+ vss3v3 slot5_wrapper_0/analog_bus3 analog_switch_array_7[4]/analog_switch_med_20/enable
+ analog_switch_array_7[4]/analog_switch_med_1/enable analog_pswitch_small_1/out vss3v3
+ vdd3v3 analog_switch_array_7[4]/analog_pswitch_small_3/enable analog_pswitch_small_0/out
+ slot5_wrapper_0/analog_bus0 vss3v3 slot14_wrapper_0/analog_bus2 vss3v3 analog_switch_array_7[4]/analog_pswitch_small_2/enable
+ vdd3v3 analog_switch_array_7[4]/analog_switch_small_1/enable vdd3v3 analog_switch_array_7[4]/analog_switch_med_3/enable
+ slot5_wrapper_0/vbias slot14_wrapper_0/analog_bus0 slot14_wrapper_0/analog_bus1
+ vdd1v2_uq2 slot14_wrapper_0/analog_bus3 vdd3v3 vss3v3 vdd1v2_uq2 vss3v3 slot14_wrapper_0/ibias0
+ slot5_wrapper_0/ibias1 slot5_wrapper_0/analog_bus2 analog_switch_array_7[4]/analog_pswitch_small_1/enable
+ vss3v3 vdd1v2_uq2 slot5_wrapper_0/ibias0 analog_switch_array_7[4]/analog_switch_small_0/enable
+ vss3v3 vdd1v2_uq2 vss3v3 vss3v3 vss3v3 vdd3v3 analog[2] analog[3] slot14_wrapper_0/ibias1
+ vss3v3 analog_switch_array_7[4]/analog_switch_med_18/enable slot14_wrapper_0/vbias
+ analog_switch_array_7[4]/analog_pswitch_small_0/enable vdd3v3 vss3v3 analog_switch_array_7[4]/analog_switch_med_22/enable
+ vdd1v2_uq2 vss3v3 vss3v3 vdd1v2_uq2 vss3v3 analog[1] vdd3v3 vdd1v2_uq2 vss3v3 vdd1v2_uq2
+ vss3v3 vss3v3 vss3v3 analog_switch_array
Xanalog_switch_array_7[5] analog[0] analog_switch_array_7[5]/analog_switch_med_17/enable
+ analog_switch_small_1/in vss3v3 analog_switch_array_7[5]/analog_switch_med_0/enable
+ analog_switch_array_7[5]/analog_switch_med_2/enable vss3v3 slot6_wrapper_0/analog_bus1
+ vss3v3 slot6_wrapper_0/analog_bus3 analog_switch_array_7[5]/analog_switch_med_20/enable
+ analog_switch_array_7[5]/analog_switch_med_1/enable analog_pswitch_small_1/out vss3v3
+ vdd3v3 analog_switch_array_7[5]/analog_pswitch_small_3/enable analog_pswitch_small_0/out
+ slot6_wrapper_0/analog_bus0 vss3v3 slot13_wrapper_0/analog_bus2 vss3v3 analog_switch_array_7[5]/analog_pswitch_small_2/enable
+ vdd3v3 analog_switch_array_7[5]/analog_switch_small_1/enable vdd3v3 analog_switch_array_7[5]/analog_switch_med_3/enable
+ slot6_wrapper_0/vbias slot13_wrapper_0/analog_bus0 slot13_wrapper_0/analog_bus1
+ vdd1v2_uq2 slot13_wrapper_0/analog_bus3 vdd3v3 vss3v3 vdd1v2_uq2 vss3v3 slot13_wrapper_0/ibias0
+ slot6_wrapper_0/ibias1 slot6_wrapper_0/analog_bus2 analog_switch_array_7[5]/analog_pswitch_small_1/enable
+ vss3v3 vdd1v2_uq2 slot6_wrapper_0/ibias0 analog_switch_array_7[5]/analog_switch_small_0/enable
+ vss3v3 vdd1v2_uq2 vss3v3 vss3v3 vss3v3 vdd3v3 analog[2] analog[3] slot13_wrapper_0/ibias1
+ vss3v3 analog_switch_array_7[5]/analog_switch_med_18/enable slot13_wrapper_0/vbias
+ analog_switch_array_7[5]/analog_pswitch_small_0/enable vdd3v3 vss3v3 analog_switch_array_7[5]/analog_switch_med_22/enable
+ vdd1v2_uq2 vss3v3 vss3v3 vdd1v2_uq2 vss3v3 analog[1] vdd3v3 vdd1v2_uq2 vss3v3 vdd1v2_uq2
+ vss3v3 vss3v3 vss3v3 analog_switch_array
Xanalog_switch_array_7[6] analog[0] analog_switch_array_7[6]/analog_switch_med_17/enable
+ analog_switch_small_1/in vss3v3 analog_switch_array_7[6]/analog_switch_med_0/enable
+ analog_switch_array_7[6]/analog_switch_med_2/enable vss3v3 slot7_wrapper_0/analog_bus1
+ vss3v3 slot7_wrapper_0/analog_bus3 analog_switch_array_7[6]/analog_switch_med_20/enable
+ analog_switch_array_7[6]/analog_switch_med_1/enable analog_pswitch_small_1/out vss3v3
+ vdd3v3 analog_switch_array_7[6]/analog_pswitch_small_3/enable analog_pswitch_small_0/out
+ slot7_wrapper_0/analog_bus0 vss3v3 slot12_wrapper_0/analog_bus2 vss3v3 analog_switch_array_7[6]/analog_pswitch_small_2/enable
+ vdd3v3 analog_switch_array_7[6]/analog_switch_small_1/enable vdd3v3 analog_switch_array_7[6]/analog_switch_med_3/enable
+ slot7_wrapper_0/vbias slot12_wrapper_0/analog_bus0 slot12_wrapper_0/analog_bus1
+ vdd1v2_uq2 slot12_wrapper_0/analog_bus3 vdd3v3 vss3v3 vdd1v2_uq2 vss3v3 slot12_wrapper_0/ibias0
+ slot7_wrapper_0/ibias1 slot7_wrapper_0/analog_bus2 analog_switch_array_7[6]/analog_pswitch_small_1/enable
+ vss3v3 vdd1v2_uq2 slot7_wrapper_0/ibias0 analog_switch_array_7[6]/analog_switch_small_0/enable
+ vss3v3 vdd1v2_uq2 vss3v3 vss3v3 vss3v3 vdd3v3 analog[2] analog[3] slot12_wrapper_0/ibias1
+ vss3v3 analog_switch_array_7[6]/analog_switch_med_18/enable slot12_wrapper_0/vbias
+ analog_switch_array_7[6]/analog_pswitch_small_0/enable vdd3v3 vss3v3 analog_switch_array_7[6]/analog_switch_med_22/enable
+ vdd1v2_uq2 vss3v3 vss3v3 vdd1v2_uq2 vss3v3 analog[1] vdd3v3 vdd1v2_uq2 vss3v3 vdd1v2_uq2
+ vss3v3 vss3v3 vss3v3 analog_switch_array
Xanalog_switch_array_7[7] analog[0] analog_switch_array_7[7]/analog_switch_med_17/enable
+ analog_switch_small_1/in vss3v3 analog_switch_array_7[7]/analog_switch_med_0/enable
+ analog_switch_array_7[7]/analog_switch_med_2/enable vss3v3 slot8_wrapper_0/analog_bus1
+ vss3v3 slot8_wrapper_0/analog_bus3 analog_switch_array_7[7]/analog_switch_med_20/enable
+ analog_switch_array_7[7]/analog_switch_med_1/enable analog_pswitch_small_1/out vss3v3
+ vdd3v3 analog_switch_array_7[7]/analog_pswitch_small_3/enable analog_pswitch_small_0/out
+ slot8_wrapper_0/analog_bus0 vss3v3 slot11_wrapper_0/analog_bus2 vss3v3 analog_switch_array_7[7]/analog_pswitch_small_2/enable
+ vdd3v3 analog_switch_array_7[7]/analog_switch_small_1/enable vdd3v3 analog_switch_array_7[7]/analog_switch_med_3/enable
+ slot8_wrapper_0/vbias slot11_wrapper_0/analog_bus0 slot11_wrapper_0/analog_bus1
+ vdd1v2_uq2 slot11_wrapper_0/analog_bus3 vdd3v3 vss3v3 vdd1v2_uq2 vss3v3 slot11_wrapper_0/ibias0
+ slot8_wrapper_0/ibias1 slot8_wrapper_0/analog_bus2 analog_switch_array_7[7]/analog_pswitch_small_1/enable
+ vss3v3 vdd1v2_uq2 slot8_wrapper_0/ibias0 analog_switch_array_7[7]/analog_switch_small_0/enable
+ vss3v3 vdd1v2_uq2 vss3v3 vss3v3 vss3v3 vdd3v3 analog[2] analog[3] slot11_wrapper_0/ibias1
+ vss3v3 analog_switch_array_7[7]/analog_switch_med_18/enable slot11_wrapper_0/vbias
+ analog_switch_array_7[7]/analog_pswitch_small_0/enable vdd3v3 vss3v3 analog_switch_array_7[7]/analog_switch_med_22/enable
+ vdd1v2_uq2 vss3v3 vss3v3 vdd1v2_uq2 vss3v3 analog[1] vdd3v3 vdd1v2_uq2 vss3v3 vdd1v2_uq2
+ vss3v3 vss3v3 vss3v3 analog_switch_array
Xanalog_switch_array_7[8] analog[0] analog_switch_array_7[8]/analog_switch_med_17/enable
+ analog_switch_small_1/in vss3v3 analog_switch_array_7[8]/analog_switch_med_0/enable
+ analog_switch_array_7[8]/analog_switch_med_2/enable vss3v3 slot9_wrapper_0/analog_bus1
+ vss3v3 slot9_wrapper_0/analog_bus3 analog_switch_array_7[8]/analog_switch_med_20/enable
+ analog_switch_array_7[8]/analog_switch_med_1/enable analog_pswitch_small_1/out vss3v3
+ vdd3v3 analog_switch_array_7[8]/analog_pswitch_small_3/enable analog_pswitch_small_0/out
+ slot9_wrapper_0/analog_bus0 vss3v3 slot10_wrapper_0/analog_bus2 vss3v3 analog_switch_array_7[8]/analog_pswitch_small_2/enable
+ vdd3v3 analog_switch_array_7[8]/analog_switch_small_1/enable vdd3v3 analog_switch_array_7[8]/analog_switch_med_3/enable
+ slot9_wrapper_0/vbias slot10_wrapper_0/analog_bus0 slot10_wrapper_0/analog_bus1
+ vdd1v2_uq2 slot10_wrapper_0/analog_bus3 vdd3v3 vss3v3 vdd1v2_uq2 vss3v3 slot10_wrapper_0/ibias0
+ slot9_wrapper_0/ibias1 slot9_wrapper_0/analog_bus2 analog_switch_array_7[8]/analog_pswitch_small_1/enable
+ vss3v3 vdd1v2_uq2 slot9_wrapper_0/ibias0 analog_switch_array_7[8]/analog_switch_small_0/enable
+ vss3v3 vdd1v2_uq2 vss3v3 vss3v3 vss3v3 vdd3v3 analog[2] analog[3] slot10_wrapper_0/ibias1
+ vss3v3 analog_switch_array_7[8]/analog_switch_med_18/enable slot10_wrapper_0/vbias
+ analog_switch_array_7[8]/analog_pswitch_small_0/enable vdd3v3 vss3v3 analog_switch_array_7[8]/analog_switch_med_22/enable
+ vdd1v2_uq2 vss3v3 vss3v3 vdd1v2_uq2 vss3v3 analog[1] vdd3v3 vdd1v2_uq2 vss3v3 vdd1v2_uq2
+ vss3v3 vss3v3 vss3v3 analog_switch_array
Xproject_control_area_0 slot10_wrapper_0/dig_in[20] analog_switch_array_7[8]/analog_switch_med_1/enable
+ analog_switch_array_7[8]/analog_switch_med_0/enable slot10_wrapper_0/dig_out[7]
+ housekeeping_top_0/proj_sel[2] vss3v3 slot10_wrapper_0/dig_in[2] slot10_wrapper_0/dig_in[21]
+ housekeeping_top_0/dbus_out[22] slot10_wrapper_0/dig_out[8] housekeeping_top_0/proj_sel[1]
+ slot10_wrapper_0/dig_in[3] slot10_wrapper_0/dig_in[22] slot10_wrapper_0/dig_out[9]
+ housekeeping_top_0/analog_bus_ena[2] slot10_wrapper_0/analog_bus3 slot10_wrapper_0/dig_in[4]
+ analog_switch_array_7[8]/analog_switch_med_2/enable slot10_wrapper_0/dig_in[23]
+ project_control_area_0/user_project_control_0/dig_out[3] project_control_area_0/user_project_control_0/dig_out[11]
+ project_control_area_0/user_project_control_0/dig_out[4] slot10_wrapper_0/analog_bus2
+ slot10_wrapper_0/dig_in[5] housekeeping_top_0/analog_bus_ena[1] slot10_wrapper_0/analog_bus1
+ housekeeping_top_0/dbus_out[5] slot10_wrapper_0/dig_in[6] housekeeping_top_0/dbus_out[21]
+ housekeeping_top_0/dbus_out[9] project_control_area_0/user_project_control_0/dig_out[8]
+ slot10_wrapper_0/analog_bus0 project_control_area_0/user_project_control_0/dig_out[9]
+ slot10_wrapper_0/dig_in[7] vss3v3 slot10_wrapper_0/dig_in[8] analog_switch_array_7[8]/analog_pswitch_small_3/enable
+ housekeeping_top_0/proj_sel[0] housekeeping_top_0/dbus_out[1] slot10_wrapper_0/dig_in[9]
+ housekeeping_top_0/dbus_out[17] housekeeping_top_0/dbus_out[2] vss3v3 slot10_wrapper_0/dig_out[10]
+ housekeeping_top_0/proj_dig_ena slot10_wrapper_0/dig_out[11] housekeeping_top_0/dbus_out[10]
+ vdd1v2_uq2 vdd1v2_uq2 project_control_area_0/user_project_control_0/dig_out[5] housekeeping_top_0/proj_ibias_ena[1]
+ housekeeping_top_0/dbus_out[23] slot10_wrapper_0/ibias1 project_control_area_0/user_project_control_0/dig_out[10]
+ slot10_wrapper_0/vdd_3v3 housekeeping_top_0/dbus_out[6] slot10_wrapper_0/ibias0
+ slot10_wrapper_0/dig_in[10] vss3v3 housekeeping_top_0/proj_vbias_ena slot10_wrapper_0/dig_in[11]
+ vdd3v3 slot10_wrapper_0/enable vss3v3 vss3v3 slot10_wrapper_0/dig_in[12] slot10_wrapper_0/dig_in[13]
+ housekeeping_top_0/proj_3v3_ena vss3v3 slot10_wrapper_0/vbias slot10_wrapper_0/dig_in[14]
+ housekeeping_top_0/analog_bus_ena[3] housekeeping_top_0/proj_ibias_ena[0] vss3v3
+ slot10_wrapper_0/dig_in[15] housekeeping_top_0/dbus_out[20] vdd1v2_uq2 housekeeping_top_0/dbus_out[19]
+ slot10_wrapper_0/dig_in[16] vss3v3 housekeeping_top_0/proj_sel[4] project_control_area_0/user_project_control_0/dig_out[6]
+ vss3v3 housekeeping_top_0/reset housekeeping_top_0/dbus_out[12] slot10_wrapper_0/dig_in[17]
+ housekeeping_top_0/analog_bus_ena[0] housekeeping_top_0/proj_1v2_ena slot10_wrapper_0/dig_in[18]
+ housekeeping_top_0/proj_ena slot10_wrapper_0/dig_in[19] vdd1v2_uq2 vss3v3 vdd3v3
+ housekeeping_top_0/dbus_out[14] analog_switch_array_7[8]/analog_pswitch_small_2/enable
+ vss3v3 housekeeping_top_0/dbus_out[16] housekeeping_top_0/dbus_out[18] slot10_wrapper_0/dig_out[0]
+ housekeeping_top_0/clk_out slot10_wrapper_0/reset slot10_wrapper_0/dig_out[1] project_control_area_0/user_project_control_0/dig_out[2]
+ housekeeping_top_0/dbus_out[0] slot10_wrapper_0/dig_out[2] project_control_area_0/user_project_control_0/dig_out[7]
+ project_control_area_0/user_project_control_0/dig_out[0] slot10_wrapper_0/clk project_control_area_0/user_project_control_0/dig_out[1]
+ housekeeping_top_0/dbus_out[7] slot10_wrapper_0/dig_out[3] housekeeping_top_0/dbus_out[8]
+ housekeeping_top_0/dbus_out[11] vss3v3 slot10_wrapper_0/dig_out[4] housekeeping_top_0/dbus_out[3]
+ analog_switch_array_7[8]/analog_switch_small_1/enable housekeeping_top_0/proj_sel[3]
+ slot10_wrapper_0/dig_out[5] vss3v3 housekeeping_top_0/dbus_out[4] slot10_wrapper_0/dig_in[0]
+ housekeeping_top_0/dbus_out[15] vss3v3 analog_switch_array_7[8]/analog_switch_med_3/enable
+ housekeeping_top_0/dbus_out[13] slot10_wrapper_0/dig_out[6] vss3v3 slot10_wrapper_0/vdd_1v2
+ vss3v3 vss3v3 slot10_wrapper_0/dig_in[1] project_control_area
Xproject_control_area_1 slot9_wrapper_0/dig_in[20] analog_switch_array_7[8]/analog_switch_med_18/enable
+ analog_switch_array_7[8]/analog_switch_med_17/enable slot9_wrapper_0/dig_out[7]
+ housekeeping_top_0/proj_sel[2] vss3v3 slot9_wrapper_0/dig_in[2] slot9_wrapper_0/dig_in[21]
+ housekeeping_top_0/dbus_out[22] slot9_wrapper_0/dig_out[8] housekeeping_top_0/proj_sel[1]
+ slot9_wrapper_0/dig_in[3] slot9_wrapper_0/dig_in[22] slot9_wrapper_0/dig_out[9]
+ housekeeping_top_0/analog_bus_ena[2] slot9_wrapper_0/analog_bus3 slot9_wrapper_0/dig_in[4]
+ analog_switch_array_7[8]/analog_switch_med_20/enable slot9_wrapper_0/dig_in[23]
+ project_control_area_1/user_project_control_0/dig_out[3] project_control_area_1/user_project_control_0/dig_out[11]
+ project_control_area_1/user_project_control_0/dig_out[4] slot9_wrapper_0/analog_bus2
+ slot9_wrapper_0/dig_in[5] housekeeping_top_0/analog_bus_ena[1] slot9_wrapper_0/analog_bus1
+ housekeeping_top_0/dbus_out[5] slot9_wrapper_0/dig_in[6] housekeeping_top_0/dbus_out[21]
+ housekeeping_top_0/dbus_out[9] project_control_area_1/user_project_control_0/dig_out[8]
+ slot9_wrapper_0/analog_bus0 project_control_area_1/user_project_control_0/dig_out[9]
+ slot9_wrapper_0/dig_in[7] vss3v3 slot9_wrapper_0/dig_in[8] analog_switch_array_7[8]/analog_pswitch_small_0/enable
+ housekeeping_top_0/proj_sel[0] housekeeping_top_0/dbus_out[1] slot9_wrapper_0/dig_in[9]
+ housekeeping_top_0/dbus_out[17] housekeeping_top_0/dbus_out[2] vdd1v2_uq2 slot9_wrapper_0/dig_out[10]
+ housekeeping_top_0/proj_dig_ena slot9_wrapper_0/dig_out[11] housekeeping_top_0/dbus_out[10]
+ vss3v3 vdd1v2_uq2 project_control_area_1/user_project_control_0/dig_out[5] housekeeping_top_0/proj_ibias_ena[1]
+ housekeeping_top_0/dbus_out[23] slot9_wrapper_0/ibias1 project_control_area_1/user_project_control_0/dig_out[10]
+ slot9_wrapper_0/vdd_3v3 housekeeping_top_0/dbus_out[6] slot9_wrapper_0/ibias0 slot9_wrapper_0/dig_in[10]
+ vss3v3 housekeeping_top_0/proj_vbias_ena slot9_wrapper_0/dig_in[11] vdd3v3 slot9_wrapper_0/enable
+ vss3v3 vss3v3 slot9_wrapper_0/dig_in[12] slot9_wrapper_0/dig_in[13] housekeeping_top_0/proj_3v3_ena
+ vss3v3 slot9_wrapper_0/vbias slot9_wrapper_0/dig_in[14] housekeeping_top_0/analog_bus_ena[3]
+ housekeeping_top_0/proj_ibias_ena[0] vss3v3 slot9_wrapper_0/dig_in[15] housekeeping_top_0/dbus_out[20]
+ vdd1v2_uq2 housekeeping_top_0/dbus_out[19] slot9_wrapper_0/dig_in[16] vss3v3 housekeeping_top_0/proj_sel[4]
+ project_control_area_1/user_project_control_0/dig_out[6] vss3v3 housekeeping_top_0/reset
+ housekeeping_top_0/dbus_out[12] slot9_wrapper_0/dig_in[17] housekeeping_top_0/analog_bus_ena[0]
+ housekeeping_top_0/proj_1v2_ena slot9_wrapper_0/dig_in[18] housekeeping_top_0/proj_ena
+ slot9_wrapper_0/dig_in[19] vdd1v2_uq2 vss3v3 vdd3v3 housekeeping_top_0/dbus_out[14]
+ analog_switch_array_7[8]/analog_pswitch_small_1/enable vss3v3 housekeeping_top_0/dbus_out[16]
+ housekeeping_top_0/dbus_out[18] slot9_wrapper_0/dig_out[0] housekeeping_top_0/clk_out
+ slot9_wrapper_0/reset slot9_wrapper_0/dig_out[1] project_control_area_1/user_project_control_0/dig_out[2]
+ housekeeping_top_0/dbus_out[0] slot9_wrapper_0/dig_out[2] project_control_area_1/user_project_control_0/dig_out[7]
+ project_control_area_1/user_project_control_0/dig_out[0] slot9_wrapper_0/clk project_control_area_1/user_project_control_0/dig_out[1]
+ housekeeping_top_0/dbus_out[7] slot9_wrapper_0/dig_out[3] housekeeping_top_0/dbus_out[8]
+ housekeeping_top_0/dbus_out[11] vss3v3 slot9_wrapper_0/dig_out[4] housekeeping_top_0/dbus_out[3]
+ analog_switch_array_7[8]/analog_switch_small_0/enable housekeeping_top_0/proj_sel[3]
+ slot9_wrapper_0/dig_out[5] vss3v3 housekeeping_top_0/dbus_out[4] slot9_wrapper_0/dig_in[0]
+ housekeeping_top_0/dbus_out[15] vss3v3 analog_switch_array_7[8]/analog_switch_med_22/enable
+ housekeeping_top_0/dbus_out[13] slot9_wrapper_0/dig_out[6] vss3v3 slot9_wrapper_0/vdd_1v2
+ vss3v3 vss3v3 slot9_wrapper_0/dig_in[1] project_control_area
Xslot3_wrapper_0 vss3v3 s3_an[0] s3_an[1] s3_an_0_esd slot3_wrapper_0/vbias slot3_wrapper_0/dig_in[23]
+ slot3_wrapper_0/dig_in[22] slot3_wrapper_0/dig_in[21] slot3_wrapper_0/dig_in[20]
+ slot3_wrapper_0/dig_in[19] slot3_wrapper_0/dig_in[18] slot3_wrapper_0/dig_in[17]
+ slot3_wrapper_0/dig_in[16] slot3_wrapper_0/dig_in[15] slot3_wrapper_0/dig_in[14]
+ slot3_wrapper_0/dig_in[13] slot3_wrapper_0/dig_in[12] slot3_wrapper_0/dig_in[11]
+ slot3_wrapper_0/dig_in[10] slot3_wrapper_0/dig_in[9] slot3_wrapper_0/dig_in[8] slot3_wrapper_0/dig_in[7]
+ slot3_wrapper_0/dig_in[6] slot3_wrapper_0/dig_in[5] slot3_wrapper_0/dig_in[4] slot3_wrapper_0/dig_in[3]
+ slot3_wrapper_0/dig_in[2] slot3_wrapper_0/dig_in[1] slot3_wrapper_0/dig_in[0] slot3_wrapper_0/dig_out[11]
+ slot3_wrapper_0/dig_out[10] slot3_wrapper_0/dig_out[9] slot3_wrapper_0/dig_out[8]
+ slot3_wrapper_0/dig_out[7] slot3_wrapper_0/dig_out[6] slot3_wrapper_0/dig_out[5]
+ slot3_wrapper_0/dig_out[4] slot3_wrapper_0/dig_out[3] slot3_wrapper_0/dig_out[2]
+ slot3_wrapper_0/dig_out[1] slot3_wrapper_0/dig_out[0] slot3_wrapper_0/ibias0 slot3_wrapper_0/ibias1
+ slot3_wrapper_0/analog_bus3 slot3_wrapper_0/analog_bus2 slot3_wrapper_0/analog_bus1
+ slot3_wrapper_0/analog_bus0 vss3v3 slot3_wrapper_0/vdd_1v2 slot3_wrapper_0/vdd_3v3
+ slot3_wrapper_0/enable slot3_wrapper_0/clk slot3_wrapper_0/reset slot3_wrapper
Xsg13cmos5l_ocd_ip__por_0 vdd1v2_uq2 vdd1v2_uq2 sg13cmos5l_ocd_ip__por_0/por_unbuf
+ housekeeping_top_0/porb sg13cmos5l_ocd_ip__por_0/por vss3v3 sg13cmos5l_ocd_ip__por
Xproject_control_area_2 slot11_wrapper_0/dig_in[20] analog_switch_array_7[7]/analog_switch_med_1/enable
+ analog_switch_array_7[7]/analog_switch_med_0/enable slot11_wrapper_0/dig_out[7]
+ housekeeping_top_0/proj_sel[2] project_control_area_0/user_project_control_0/dig_out[0]
+ slot11_wrapper_0/dig_in[2] slot11_wrapper_0/dig_in[21] housekeeping_top_0/dbus_out[22]
+ slot11_wrapper_0/dig_out[8] housekeeping_top_0/proj_sel[1] slot11_wrapper_0/dig_in[3]
+ slot11_wrapper_0/dig_in[22] slot11_wrapper_0/dig_out[9] housekeeping_top_0/analog_bus_ena[2]
+ slot11_wrapper_0/analog_bus3 slot11_wrapper_0/dig_in[4] analog_switch_array_7[7]/analog_switch_med_2/enable
+ slot11_wrapper_0/dig_in[23] project_control_area_2/user_project_control_0/dig_out[3]
+ project_control_area_2/user_project_control_0/dig_out[11] project_control_area_2/user_project_control_0/dig_out[4]
+ slot11_wrapper_0/analog_bus2 slot11_wrapper_0/dig_in[5] housekeeping_top_0/analog_bus_ena[1]
+ slot11_wrapper_0/analog_bus1 housekeeping_top_0/dbus_out[5] slot11_wrapper_0/dig_in[6]
+ housekeeping_top_0/dbus_out[21] housekeeping_top_0/dbus_out[9] project_control_area_2/user_project_control_0/dig_out[8]
+ slot11_wrapper_0/analog_bus0 project_control_area_2/user_project_control_0/dig_out[9]
+ slot11_wrapper_0/dig_in[7] project_control_area_0/user_project_control_0/dig_out[11]
+ slot11_wrapper_0/dig_in[8] analog_switch_array_7[7]/analog_pswitch_small_3/enable
+ housekeeping_top_0/proj_sel[0] housekeeping_top_0/dbus_out[1] slot11_wrapper_0/dig_in[9]
+ housekeeping_top_0/dbus_out[17] housekeeping_top_0/dbus_out[2] vdd1v2_uq2 slot11_wrapper_0/dig_out[10]
+ housekeeping_top_0/proj_dig_ena slot11_wrapper_0/dig_out[11] housekeeping_top_0/dbus_out[10]
+ vdd1v2_uq2 vdd1v2_uq2 project_control_area_2/user_project_control_0/dig_out[5] housekeeping_top_0/proj_ibias_ena[1]
+ housekeeping_top_0/dbus_out[23] slot11_wrapper_0/ibias1 project_control_area_2/user_project_control_0/dig_out[10]
+ slot11_wrapper_0/vdd_3v3 housekeeping_top_0/dbus_out[6] slot11_wrapper_0/ibias0
+ slot11_wrapper_0/dig_in[10] project_control_area_0/user_project_control_0/dig_out[2]
+ housekeeping_top_0/proj_vbias_ena slot11_wrapper_0/dig_in[11] vdd3v3 slot11_wrapper_0/enable
+ project_control_area_0/user_project_control_0/dig_out[1] project_control_area_0/user_project_control_0/dig_out[3]
+ slot11_wrapper_0/dig_in[12] slot11_wrapper_0/dig_in[13] housekeeping_top_0/proj_3v3_ena
+ project_control_area_0/user_project_control_0/dig_out[4] slot11_wrapper_0/vbias
+ slot11_wrapper_0/dig_in[14] housekeeping_top_0/analog_bus_ena[3] housekeeping_top_0/proj_ibias_ena[0]
+ project_control_area_0/user_project_control_0/dig_out[5] slot11_wrapper_0/dig_in[15]
+ housekeeping_top_0/dbus_out[20] vdd1v2_uq2 housekeeping_top_0/dbus_out[19] slot11_wrapper_0/dig_in[16]
+ project_control_area_0/user_project_control_0/dig_out[6] housekeeping_top_0/proj_sel[4]
+ project_control_area_2/user_project_control_0/dig_out[6] vss3v3 housekeeping_top_0/reset
+ housekeeping_top_0/dbus_out[12] slot11_wrapper_0/dig_in[17] housekeeping_top_0/analog_bus_ena[0]
+ housekeeping_top_0/proj_1v2_ena slot11_wrapper_0/dig_in[18] housekeeping_top_0/proj_ena
+ slot11_wrapper_0/dig_in[19] vdd1v2_uq2 project_control_area_0/user_project_control_0/dig_out[9]
+ vdd3v3 housekeeping_top_0/dbus_out[14] analog_switch_array_7[7]/analog_pswitch_small_2/enable
+ project_control_area_0/user_project_control_0/dig_out[10] housekeeping_top_0/dbus_out[16]
+ housekeeping_top_0/dbus_out[18] slot11_wrapper_0/dig_out[0] housekeeping_top_0/clk_out
+ slot11_wrapper_0/reset slot11_wrapper_0/dig_out[1] project_control_area_2/user_project_control_0/dig_out[2]
+ housekeeping_top_0/dbus_out[0] slot11_wrapper_0/dig_out[2] project_control_area_2/user_project_control_0/dig_out[7]
+ project_control_area_2/user_project_control_0/dig_out[0] slot11_wrapper_0/clk project_control_area_2/user_project_control_0/dig_out[1]
+ housekeeping_top_0/dbus_out[7] slot11_wrapper_0/dig_out[3] housekeeping_top_0/dbus_out[8]
+ housekeeping_top_0/dbus_out[11] project_control_area_0/user_project_control_0/dig_out[7]
+ slot11_wrapper_0/dig_out[4] housekeeping_top_0/dbus_out[3] analog_switch_array_7[7]/analog_switch_small_1/enable
+ housekeeping_top_0/proj_sel[3] slot11_wrapper_0/dig_out[5] project_control_area_0/user_project_control_0/dig_out[8]
+ housekeeping_top_0/dbus_out[4] slot11_wrapper_0/dig_in[0] housekeeping_top_0/dbus_out[15]
+ vss3v3 analog_switch_array_7[7]/analog_switch_med_3/enable housekeeping_top_0/dbus_out[13]
+ slot11_wrapper_0/dig_out[6] vss3v3 slot11_wrapper_0/vdd_1v2 vss3v3 vss3v3 slot11_wrapper_0/dig_in[1]
+ project_control_area
Xproject_control_area_3 slot8_wrapper_0/dig_in[20] analog_switch_array_7[7]/analog_switch_med_18/enable
+ analog_switch_array_7[7]/analog_switch_med_17/enable slot8_wrapper_0/dig_out[7]
+ housekeeping_top_0/proj_sel[2] project_control_area_1/user_project_control_0/dig_out[0]
+ slot8_wrapper_0/dig_in[2] slot8_wrapper_0/dig_in[21] housekeeping_top_0/dbus_out[22]
+ slot8_wrapper_0/dig_out[8] housekeeping_top_0/proj_sel[1] slot8_wrapper_0/dig_in[3]
+ slot8_wrapper_0/dig_in[22] slot8_wrapper_0/dig_out[9] housekeeping_top_0/analog_bus_ena[2]
+ slot8_wrapper_0/analog_bus3 slot8_wrapper_0/dig_in[4] analog_switch_array_7[7]/analog_switch_med_20/enable
+ slot8_wrapper_0/dig_in[23] project_control_area_3/user_project_control_0/dig_out[3]
+ project_control_area_3/user_project_control_0/dig_out[11] project_control_area_3/user_project_control_0/dig_out[4]
+ slot8_wrapper_0/analog_bus2 slot8_wrapper_0/dig_in[5] housekeeping_top_0/analog_bus_ena[1]
+ slot8_wrapper_0/analog_bus1 housekeeping_top_0/dbus_out[5] slot8_wrapper_0/dig_in[6]
+ housekeeping_top_0/dbus_out[21] housekeeping_top_0/dbus_out[9] project_control_area_3/user_project_control_0/dig_out[8]
+ slot8_wrapper_0/analog_bus0 project_control_area_3/user_project_control_0/dig_out[9]
+ slot8_wrapper_0/dig_in[7] project_control_area_1/user_project_control_0/dig_out[11]
+ slot8_wrapper_0/dig_in[8] analog_switch_array_7[7]/analog_pswitch_small_0/enable
+ housekeeping_top_0/proj_sel[0] housekeeping_top_0/dbus_out[1] slot8_wrapper_0/dig_in[9]
+ housekeeping_top_0/dbus_out[17] housekeeping_top_0/dbus_out[2] vss3v3 slot8_wrapper_0/dig_out[10]
+ housekeeping_top_0/proj_dig_ena slot8_wrapper_0/dig_out[11] housekeeping_top_0/dbus_out[10]
+ vss3v3 vdd1v2_uq2 project_control_area_3/user_project_control_0/dig_out[5] housekeeping_top_0/proj_ibias_ena[1]
+ housekeeping_top_0/dbus_out[23] slot8_wrapper_0/ibias1 project_control_area_3/user_project_control_0/dig_out[10]
+ slot8_wrapper_0/vdd_3v3 housekeeping_top_0/dbus_out[6] slot8_wrapper_0/ibias0 slot8_wrapper_0/dig_in[10]
+ project_control_area_1/user_project_control_0/dig_out[2] housekeeping_top_0/proj_vbias_ena
+ slot8_wrapper_0/dig_in[11] vdd3v3 slot8_wrapper_0/enable project_control_area_1/user_project_control_0/dig_out[1]
+ project_control_area_1/user_project_control_0/dig_out[3] slot8_wrapper_0/dig_in[12]
+ slot8_wrapper_0/dig_in[13] housekeeping_top_0/proj_3v3_ena project_control_area_1/user_project_control_0/dig_out[4]
+ slot8_wrapper_0/vbias slot8_wrapper_0/dig_in[14] housekeeping_top_0/analog_bus_ena[3]
+ housekeeping_top_0/proj_ibias_ena[0] project_control_area_1/user_project_control_0/dig_out[5]
+ slot8_wrapper_0/dig_in[15] housekeeping_top_0/dbus_out[20] vdd1v2_uq2 housekeeping_top_0/dbus_out[19]
+ slot8_wrapper_0/dig_in[16] project_control_area_1/user_project_control_0/dig_out[6]
+ housekeeping_top_0/proj_sel[4] project_control_area_3/user_project_control_0/dig_out[6]
+ vss3v3 housekeeping_top_0/reset housekeeping_top_0/dbus_out[12] slot8_wrapper_0/dig_in[17]
+ housekeeping_top_0/analog_bus_ena[0] housekeeping_top_0/proj_1v2_ena slot8_wrapper_0/dig_in[18]
+ housekeeping_top_0/proj_ena slot8_wrapper_0/dig_in[19] vdd1v2_uq2 project_control_area_1/user_project_control_0/dig_out[9]
+ vdd3v3 housekeeping_top_0/dbus_out[14] analog_switch_array_7[7]/analog_pswitch_small_1/enable
+ project_control_area_1/user_project_control_0/dig_out[10] housekeeping_top_0/dbus_out[16]
+ housekeeping_top_0/dbus_out[18] slot8_wrapper_0/dig_out[0] housekeeping_top_0/clk_out
+ slot8_wrapper_0/reset slot8_wrapper_0/dig_out[1] project_control_area_3/user_project_control_0/dig_out[2]
+ housekeeping_top_0/dbus_out[0] slot8_wrapper_0/dig_out[2] project_control_area_3/user_project_control_0/dig_out[7]
+ project_control_area_3/user_project_control_0/dig_out[0] slot8_wrapper_0/clk project_control_area_3/user_project_control_0/dig_out[1]
+ housekeeping_top_0/dbus_out[7] slot8_wrapper_0/dig_out[3] housekeeping_top_0/dbus_out[8]
+ housekeeping_top_0/dbus_out[11] project_control_area_1/user_project_control_0/dig_out[7]
+ slot8_wrapper_0/dig_out[4] housekeeping_top_0/dbus_out[3] analog_switch_array_7[7]/analog_switch_small_0/enable
+ housekeeping_top_0/proj_sel[3] slot8_wrapper_0/dig_out[5] project_control_area_1/user_project_control_0/dig_out[8]
+ housekeeping_top_0/dbus_out[4] slot8_wrapper_0/dig_in[0] housekeeping_top_0/dbus_out[15]
+ vss3v3 analog_switch_array_7[7]/analog_switch_med_22/enable housekeeping_top_0/dbus_out[13]
+ slot8_wrapper_0/dig_out[6] vss3v3 slot8_wrapper_0/vdd_1v2 vss3v3 vss3v3 slot8_wrapper_0/dig_in[1]
+ project_control_area
Xslot7_wrapper_0 vss3v3 s7_an[0] s7_an[1] s7_an_0_esd slot7_wrapper_0/vbias slot7_wrapper_0/dig_in[23]
+ slot7_wrapper_0/dig_in[22] slot7_wrapper_0/dig_in[21] slot7_wrapper_0/dig_in[20]
+ slot7_wrapper_0/dig_in[19] slot7_wrapper_0/dig_in[18] slot7_wrapper_0/dig_in[17]
+ slot7_wrapper_0/dig_in[16] slot7_wrapper_0/dig_in[15] slot7_wrapper_0/dig_in[14]
+ slot7_wrapper_0/dig_in[13] slot7_wrapper_0/dig_in[12] slot7_wrapper_0/dig_in[11]
+ slot7_wrapper_0/dig_in[10] slot7_wrapper_0/dig_in[9] slot7_wrapper_0/dig_in[8] slot7_wrapper_0/dig_in[7]
+ slot7_wrapper_0/dig_in[6] slot7_wrapper_0/dig_in[5] slot7_wrapper_0/dig_in[4] slot7_wrapper_0/dig_in[3]
+ slot7_wrapper_0/dig_in[2] slot7_wrapper_0/dig_in[1] slot7_wrapper_0/dig_in[0] slot7_wrapper_0/dig_out[11]
+ slot7_wrapper_0/dig_out[10] slot7_wrapper_0/dig_out[9] slot7_wrapper_0/dig_out[8]
+ slot7_wrapper_0/dig_out[7] slot7_wrapper_0/dig_out[6] slot7_wrapper_0/dig_out[5]
+ slot7_wrapper_0/dig_out[4] slot7_wrapper_0/dig_out[3] slot7_wrapper_0/dig_out[2]
+ slot7_wrapper_0/dig_out[1] slot7_wrapper_0/dig_out[0] slot7_wrapper_0/ibias0 slot7_wrapper_0/ibias1
+ slot7_wrapper_0/analog_bus3 slot7_wrapper_0/analog_bus2 slot7_wrapper_0/analog_bus1
+ slot7_wrapper_0/analog_bus0 slot7_wrapper_0/vdd_1v2 vss3v3 slot7_wrapper_0/vdd_3v3
+ slot7_wrapper_0/enable slot7_wrapper_0/clk slot7_wrapper_0/reset slot7_wrapper
Xproject_control_area_4 slot12_wrapper_0/dig_in[20] analog_switch_array_7[6]/analog_switch_med_1/enable
+ analog_switch_array_7[6]/analog_switch_med_0/enable slot12_wrapper_0/dig_out[7]
+ housekeeping_top_0/proj_sel[2] project_control_area_2/user_project_control_0/dig_out[0]
+ slot12_wrapper_0/dig_in[2] slot12_wrapper_0/dig_in[21] housekeeping_top_0/dbus_out[22]
+ slot12_wrapper_0/dig_out[8] housekeeping_top_0/proj_sel[1] slot12_wrapper_0/dig_in[3]
+ slot12_wrapper_0/dig_in[22] slot12_wrapper_0/dig_out[9] housekeeping_top_0/analog_bus_ena[2]
+ slot12_wrapper_0/analog_bus3 slot12_wrapper_0/dig_in[4] analog_switch_array_7[6]/analog_switch_med_2/enable
+ slot12_wrapper_0/dig_in[23] project_control_area_4/user_project_control_0/dig_out[3]
+ project_control_area_4/user_project_control_0/dig_out[11] project_control_area_4/user_project_control_0/dig_out[4]
+ slot12_wrapper_0/analog_bus2 slot12_wrapper_0/dig_in[5] housekeeping_top_0/analog_bus_ena[1]
+ slot12_wrapper_0/analog_bus1 housekeeping_top_0/dbus_out[5] slot12_wrapper_0/dig_in[6]
+ housekeeping_top_0/dbus_out[21] housekeeping_top_0/dbus_out[9] project_control_area_4/user_project_control_0/dig_out[8]
+ slot12_wrapper_0/analog_bus0 project_control_area_4/user_project_control_0/dig_out[9]
+ slot12_wrapper_0/dig_in[7] project_control_area_2/user_project_control_0/dig_out[11]
+ slot12_wrapper_0/dig_in[8] analog_switch_array_7[6]/analog_pswitch_small_3/enable
+ housekeeping_top_0/proj_sel[0] housekeeping_top_0/dbus_out[1] slot12_wrapper_0/dig_in[9]
+ housekeeping_top_0/dbus_out[17] housekeeping_top_0/dbus_out[2] vss3v3 slot12_wrapper_0/dig_out[10]
+ housekeeping_top_0/proj_dig_ena slot12_wrapper_0/dig_out[11] housekeeping_top_0/dbus_out[10]
+ vss3v3 vdd1v2_uq2 project_control_area_4/user_project_control_0/dig_out[5] housekeeping_top_0/proj_ibias_ena[1]
+ housekeeping_top_0/dbus_out[23] slot12_wrapper_0/ibias1 project_control_area_4/user_project_control_0/dig_out[10]
+ slot12_wrapper_0/vdd_3v3 housekeeping_top_0/dbus_out[6] slot12_wrapper_0/ibias0
+ slot12_wrapper_0/dig_in[10] project_control_area_2/user_project_control_0/dig_out[2]
+ housekeeping_top_0/proj_vbias_ena slot12_wrapper_0/dig_in[11] vdd3v3 slot12_wrapper_0/enable
+ project_control_area_2/user_project_control_0/dig_out[1] project_control_area_2/user_project_control_0/dig_out[3]
+ slot12_wrapper_0/dig_in[12] slot12_wrapper_0/dig_in[13] housekeeping_top_0/proj_3v3_ena
+ project_control_area_2/user_project_control_0/dig_out[4] slot12_wrapper_0/vbias
+ slot12_wrapper_0/dig_in[14] housekeeping_top_0/analog_bus_ena[3] housekeeping_top_0/proj_ibias_ena[0]
+ project_control_area_2/user_project_control_0/dig_out[5] slot12_wrapper_0/dig_in[15]
+ housekeeping_top_0/dbus_out[20] vdd1v2_uq2 housekeeping_top_0/dbus_out[19] slot12_wrapper_0/dig_in[16]
+ project_control_area_2/user_project_control_0/dig_out[6] housekeeping_top_0/proj_sel[4]
+ project_control_area_4/user_project_control_0/dig_out[6] vss3v3 housekeeping_top_0/reset
+ housekeeping_top_0/dbus_out[12] slot12_wrapper_0/dig_in[17] housekeeping_top_0/analog_bus_ena[0]
+ housekeeping_top_0/proj_1v2_ena slot12_wrapper_0/dig_in[18] housekeeping_top_0/proj_ena
+ slot12_wrapper_0/dig_in[19] vdd1v2_uq2 project_control_area_2/user_project_control_0/dig_out[9]
+ vdd3v3 housekeeping_top_0/dbus_out[14] analog_switch_array_7[6]/analog_pswitch_small_2/enable
+ project_control_area_2/user_project_control_0/dig_out[10] housekeeping_top_0/dbus_out[16]
+ housekeeping_top_0/dbus_out[18] slot12_wrapper_0/dig_out[0] housekeeping_top_0/clk_out
+ slot12_wrapper_0/reset slot12_wrapper_0/dig_out[1] project_control_area_4/user_project_control_0/dig_out[2]
+ housekeeping_top_0/dbus_out[0] slot12_wrapper_0/dig_out[2] project_control_area_4/user_project_control_0/dig_out[7]
+ project_control_area_4/user_project_control_0/dig_out[0] slot12_wrapper_0/clk project_control_area_4/user_project_control_0/dig_out[1]
+ housekeeping_top_0/dbus_out[7] slot12_wrapper_0/dig_out[3] housekeeping_top_0/dbus_out[8]
+ housekeeping_top_0/dbus_out[11] project_control_area_2/user_project_control_0/dig_out[7]
+ slot12_wrapper_0/dig_out[4] housekeeping_top_0/dbus_out[3] analog_switch_array_7[6]/analog_switch_small_1/enable
+ housekeeping_top_0/proj_sel[3] slot12_wrapper_0/dig_out[5] project_control_area_2/user_project_control_0/dig_out[8]
+ housekeeping_top_0/dbus_out[4] slot12_wrapper_0/dig_in[0] housekeeping_top_0/dbus_out[15]
+ vss3v3 analog_switch_array_7[6]/analog_switch_med_3/enable housekeeping_top_0/dbus_out[13]
+ slot12_wrapper_0/dig_out[6] vss3v3 slot12_wrapper_0/vdd_1v2 vdd1v2_uq2 vss3v3 slot12_wrapper_0/dig_in[1]
+ project_control_area
Xproject_control_area_5 slot7_wrapper_0/dig_in[20] analog_switch_array_7[6]/analog_switch_med_18/enable
+ analog_switch_array_7[6]/analog_switch_med_17/enable slot7_wrapper_0/dig_out[7]
+ housekeeping_top_0/proj_sel[2] project_control_area_3/user_project_control_0/dig_out[0]
+ slot7_wrapper_0/dig_in[2] slot7_wrapper_0/dig_in[21] housekeeping_top_0/dbus_out[22]
+ slot7_wrapper_0/dig_out[8] housekeeping_top_0/proj_sel[1] slot7_wrapper_0/dig_in[3]
+ slot7_wrapper_0/dig_in[22] slot7_wrapper_0/dig_out[9] housekeeping_top_0/analog_bus_ena[2]
+ slot7_wrapper_0/analog_bus3 slot7_wrapper_0/dig_in[4] analog_switch_array_7[6]/analog_switch_med_20/enable
+ slot7_wrapper_0/dig_in[23] project_control_area_5/user_project_control_0/dig_out[3]
+ project_control_area_5/user_project_control_0/dig_out[11] project_control_area_5/user_project_control_0/dig_out[4]
+ slot7_wrapper_0/analog_bus2 slot7_wrapper_0/dig_in[5] housekeeping_top_0/analog_bus_ena[1]
+ slot7_wrapper_0/analog_bus1 housekeeping_top_0/dbus_out[5] slot7_wrapper_0/dig_in[6]
+ housekeeping_top_0/dbus_out[21] housekeeping_top_0/dbus_out[9] project_control_area_5/user_project_control_0/dig_out[8]
+ slot7_wrapper_0/analog_bus0 project_control_area_5/user_project_control_0/dig_out[9]
+ slot7_wrapper_0/dig_in[7] project_control_area_3/user_project_control_0/dig_out[11]
+ slot7_wrapper_0/dig_in[8] analog_switch_array_7[6]/analog_pswitch_small_0/enable
+ housekeeping_top_0/proj_sel[0] housekeeping_top_0/dbus_out[1] slot7_wrapper_0/dig_in[9]
+ housekeeping_top_0/dbus_out[17] housekeeping_top_0/dbus_out[2] vdd1v2_uq2 slot7_wrapper_0/dig_out[10]
+ housekeeping_top_0/proj_dig_ena slot7_wrapper_0/dig_out[11] housekeeping_top_0/dbus_out[10]
+ vdd1v2_uq2 vss3v3 project_control_area_5/user_project_control_0/dig_out[5] housekeeping_top_0/proj_ibias_ena[1]
+ housekeeping_top_0/dbus_out[23] slot7_wrapper_0/ibias1 project_control_area_5/user_project_control_0/dig_out[10]
+ slot7_wrapper_0/vdd_3v3 housekeeping_top_0/dbus_out[6] slot7_wrapper_0/ibias0 slot7_wrapper_0/dig_in[10]
+ project_control_area_3/user_project_control_0/dig_out[2] housekeeping_top_0/proj_vbias_ena
+ slot7_wrapper_0/dig_in[11] vdd3v3 slot7_wrapper_0/enable project_control_area_3/user_project_control_0/dig_out[1]
+ project_control_area_3/user_project_control_0/dig_out[3] slot7_wrapper_0/dig_in[12]
+ slot7_wrapper_0/dig_in[13] housekeeping_top_0/proj_3v3_ena project_control_area_3/user_project_control_0/dig_out[4]
+ slot7_wrapper_0/vbias slot7_wrapper_0/dig_in[14] housekeeping_top_0/analog_bus_ena[3]
+ housekeeping_top_0/proj_ibias_ena[0] project_control_area_3/user_project_control_0/dig_out[5]
+ slot7_wrapper_0/dig_in[15] housekeeping_top_0/dbus_out[20] vdd1v2_uq2 housekeeping_top_0/dbus_out[19]
+ slot7_wrapper_0/dig_in[16] project_control_area_3/user_project_control_0/dig_out[6]
+ housekeeping_top_0/proj_sel[4] project_control_area_5/user_project_control_0/dig_out[6]
+ vss3v3 housekeeping_top_0/reset housekeeping_top_0/dbus_out[12] slot7_wrapper_0/dig_in[17]
+ housekeeping_top_0/analog_bus_ena[0] housekeeping_top_0/proj_1v2_ena slot7_wrapper_0/dig_in[18]
+ housekeeping_top_0/proj_ena slot7_wrapper_0/dig_in[19] vdd1v2_uq2 project_control_area_3/user_project_control_0/dig_out[9]
+ vdd3v3 housekeeping_top_0/dbus_out[14] analog_switch_array_7[6]/analog_pswitch_small_1/enable
+ project_control_area_3/user_project_control_0/dig_out[10] housekeeping_top_0/dbus_out[16]
+ housekeeping_top_0/dbus_out[18] slot7_wrapper_0/dig_out[0] housekeeping_top_0/clk_out
+ slot7_wrapper_0/reset slot7_wrapper_0/dig_out[1] project_control_area_5/user_project_control_0/dig_out[2]
+ housekeeping_top_0/dbus_out[0] slot7_wrapper_0/dig_out[2] project_control_area_5/user_project_control_0/dig_out[7]
+ project_control_area_5/user_project_control_0/dig_out[0] slot7_wrapper_0/clk project_control_area_5/user_project_control_0/dig_out[1]
+ housekeeping_top_0/dbus_out[7] slot7_wrapper_0/dig_out[3] housekeeping_top_0/dbus_out[8]
+ housekeeping_top_0/dbus_out[11] project_control_area_3/user_project_control_0/dig_out[7]
+ slot7_wrapper_0/dig_out[4] housekeeping_top_0/dbus_out[3] analog_switch_array_7[6]/analog_switch_small_0/enable
+ housekeeping_top_0/proj_sel[3] slot7_wrapper_0/dig_out[5] project_control_area_3/user_project_control_0/dig_out[8]
+ housekeeping_top_0/dbus_out[4] slot7_wrapper_0/dig_in[0] housekeeping_top_0/dbus_out[15]
+ vss3v3 analog_switch_array_7[6]/analog_switch_med_22/enable housekeeping_top_0/dbus_out[13]
+ slot7_wrapper_0/dig_out[6] vss3v3 slot7_wrapper_0/vdd_1v2 vdd1v2_uq2 vss3v3 slot7_wrapper_0/dig_in[1]
+ project_control_area
Xslot11_wrapper_0 vss3v3 s11_an[0] s11_an_0_esd slot11_wrapper_0/vbias slot11_wrapper_0/dig_in[23]
+ slot11_wrapper_0/dig_in[22] slot11_wrapper_0/dig_in[21] slot11_wrapper_0/dig_in[20]
+ slot11_wrapper_0/dig_in[19] slot11_wrapper_0/dig_in[18] slot11_wrapper_0/dig_in[17]
+ slot11_wrapper_0/dig_in[16] slot11_wrapper_0/dig_in[15] slot11_wrapper_0/dig_in[14]
+ slot11_wrapper_0/dig_in[13] slot11_wrapper_0/dig_in[12] slot11_wrapper_0/dig_in[11]
+ slot11_wrapper_0/dig_in[10] slot11_wrapper_0/dig_in[9] slot11_wrapper_0/dig_in[8]
+ slot11_wrapper_0/dig_in[7] slot11_wrapper_0/dig_in[6] slot11_wrapper_0/dig_in[5]
+ slot11_wrapper_0/dig_in[4] slot11_wrapper_0/dig_in[3] slot11_wrapper_0/dig_in[2]
+ slot11_wrapper_0/dig_in[1] slot11_wrapper_0/dig_in[0] slot11_wrapper_0/dig_out[11]
+ slot11_wrapper_0/dig_out[10] slot11_wrapper_0/dig_out[9] slot11_wrapper_0/dig_out[8]
+ slot11_wrapper_0/dig_out[7] slot11_wrapper_0/dig_out[6] slot11_wrapper_0/dig_out[5]
+ slot11_wrapper_0/dig_out[4] slot11_wrapper_0/dig_out[3] slot11_wrapper_0/dig_out[2]
+ slot11_wrapper_0/dig_out[1] slot11_wrapper_0/dig_out[0] slot11_wrapper_0/ibias0
+ slot11_wrapper_0/ibias1 slot11_wrapper_0/analog_bus3 slot11_wrapper_0/analog_bus2
+ slot11_wrapper_0/analog_bus1 slot11_wrapper_0/analog_bus0 slot11_wrapper_0/vdd_1v2
+ vss3v3 slot11_wrapper_0/vdd_3v3 slot11_wrapper_0/enable slot11_wrapper_0/clk slot11_wrapper_0/reset
+ slot11_wrapper
Xproject_control_area_6 slot13_wrapper_0/dig_in[20] analog_switch_array_7[5]/analog_switch_med_1/enable
+ analog_switch_array_7[5]/analog_switch_med_0/enable slot13_wrapper_0/dig_out[7]
+ housekeeping_top_0/proj_sel[2] project_control_area_4/user_project_control_0/dig_out[0]
+ slot13_wrapper_0/dig_in[2] slot13_wrapper_0/dig_in[21] housekeeping_top_0/dbus_out[22]
+ slot13_wrapper_0/dig_out[8] housekeeping_top_0/proj_sel[1] slot13_wrapper_0/dig_in[3]
+ slot13_wrapper_0/dig_in[22] slot13_wrapper_0/dig_out[9] housekeeping_top_0/analog_bus_ena[2]
+ slot13_wrapper_0/analog_bus3 slot13_wrapper_0/dig_in[4] analog_switch_array_7[5]/analog_switch_med_2/enable
+ slot13_wrapper_0/dig_in[23] project_control_area_6/user_project_control_0/dig_out[3]
+ project_control_area_6/user_project_control_0/dig_out[11] project_control_area_6/user_project_control_0/dig_out[4]
+ slot13_wrapper_0/analog_bus2 slot13_wrapper_0/dig_in[5] housekeeping_top_0/analog_bus_ena[1]
+ slot13_wrapper_0/analog_bus1 housekeeping_top_0/dbus_out[5] slot13_wrapper_0/dig_in[6]
+ housekeeping_top_0/dbus_out[21] housekeeping_top_0/dbus_out[9] project_control_area_6/user_project_control_0/dig_out[8]
+ slot13_wrapper_0/analog_bus0 project_control_area_6/user_project_control_0/dig_out[9]
+ slot13_wrapper_0/dig_in[7] project_control_area_4/user_project_control_0/dig_out[11]
+ slot13_wrapper_0/dig_in[8] analog_switch_array_7[5]/analog_pswitch_small_3/enable
+ housekeeping_top_0/proj_sel[0] housekeeping_top_0/dbus_out[1] slot13_wrapper_0/dig_in[9]
+ housekeeping_top_0/dbus_out[17] housekeeping_top_0/dbus_out[2] vdd1v2_uq2 slot13_wrapper_0/dig_out[10]
+ housekeeping_top_0/proj_dig_ena slot13_wrapper_0/dig_out[11] housekeeping_top_0/dbus_out[10]
+ vss3v3 vdd1v2_uq2 project_control_area_6/user_project_control_0/dig_out[5] housekeeping_top_0/proj_ibias_ena[1]
+ housekeeping_top_0/dbus_out[23] slot13_wrapper_0/ibias1 project_control_area_6/user_project_control_0/dig_out[10]
+ slot13_wrapper_0/vdd_3v3 housekeeping_top_0/dbus_out[6] slot13_wrapper_0/ibias0
+ slot13_wrapper_0/dig_in[10] project_control_area_4/user_project_control_0/dig_out[2]
+ housekeeping_top_0/proj_vbias_ena slot13_wrapper_0/dig_in[11] vdd3v3 slot13_wrapper_0/enable
+ project_control_area_4/user_project_control_0/dig_out[1] project_control_area_4/user_project_control_0/dig_out[3]
+ slot13_wrapper_0/dig_in[12] slot13_wrapper_0/dig_in[13] housekeeping_top_0/proj_3v3_ena
+ project_control_area_4/user_project_control_0/dig_out[4] slot13_wrapper_0/vbias
+ slot13_wrapper_0/dig_in[14] housekeeping_top_0/analog_bus_ena[3] housekeeping_top_0/proj_ibias_ena[0]
+ project_control_area_4/user_project_control_0/dig_out[5] slot13_wrapper_0/dig_in[15]
+ housekeeping_top_0/dbus_out[20] vdd1v2_uq2 housekeeping_top_0/dbus_out[19] slot13_wrapper_0/dig_in[16]
+ project_control_area_4/user_project_control_0/dig_out[6] housekeeping_top_0/proj_sel[4]
+ project_control_area_6/user_project_control_0/dig_out[6] vss3v3 housekeeping_top_0/reset
+ housekeeping_top_0/dbus_out[12] slot13_wrapper_0/dig_in[17] housekeeping_top_0/analog_bus_ena[0]
+ housekeeping_top_0/proj_1v2_ena slot13_wrapper_0/dig_in[18] housekeeping_top_0/proj_ena
+ slot13_wrapper_0/dig_in[19] vdd1v2_uq2 project_control_area_4/user_project_control_0/dig_out[9]
+ vdd3v3 housekeeping_top_0/dbus_out[14] analog_switch_array_7[5]/analog_pswitch_small_2/enable
+ project_control_area_4/user_project_control_0/dig_out[10] housekeeping_top_0/dbus_out[16]
+ housekeeping_top_0/dbus_out[18] slot13_wrapper_0/dig_out[0] housekeeping_top_0/clk_out
+ slot13_wrapper_0/reset slot13_wrapper_0/dig_out[1] project_control_area_6/user_project_control_0/dig_out[2]
+ housekeeping_top_0/dbus_out[0] slot13_wrapper_0/dig_out[2] project_control_area_6/user_project_control_0/dig_out[7]
+ project_control_area_6/user_project_control_0/dig_out[0] slot13_wrapper_0/clk project_control_area_6/user_project_control_0/dig_out[1]
+ housekeeping_top_0/dbus_out[7] slot13_wrapper_0/dig_out[3] housekeeping_top_0/dbus_out[8]
+ housekeeping_top_0/dbus_out[11] project_control_area_4/user_project_control_0/dig_out[7]
+ slot13_wrapper_0/dig_out[4] housekeeping_top_0/dbus_out[3] analog_switch_array_7[5]/analog_switch_small_1/enable
+ housekeeping_top_0/proj_sel[3] slot13_wrapper_0/dig_out[5] project_control_area_4/user_project_control_0/dig_out[8]
+ housekeeping_top_0/dbus_out[4] slot13_wrapper_0/dig_in[0] housekeeping_top_0/dbus_out[15]
+ vss3v3 analog_switch_array_7[5]/analog_switch_med_3/enable housekeeping_top_0/dbus_out[13]
+ slot13_wrapper_0/dig_out[6] vss3v3 slot13_wrapper_0/vdd_1v2 vdd1v2_uq2 vss3v3 slot13_wrapper_0/dig_in[1]
+ project_control_area
Xproject_control_area_7 slot6_wrapper_0/dig_in[20] analog_switch_array_7[5]/analog_switch_med_18/enable
+ analog_switch_array_7[5]/analog_switch_med_17/enable slot6_wrapper_0/dig_out[7]
+ housekeeping_top_0/proj_sel[2] project_control_area_5/user_project_control_0/dig_out[0]
+ slot6_wrapper_0/dig_in[2] slot6_wrapper_0/dig_in[21] housekeeping_top_0/dbus_out[22]
+ slot6_wrapper_0/dig_out[8] housekeeping_top_0/proj_sel[1] slot6_wrapper_0/dig_in[3]
+ slot6_wrapper_0/dig_in[22] slot6_wrapper_0/dig_out[9] housekeeping_top_0/analog_bus_ena[2]
+ slot6_wrapper_0/analog_bus3 slot6_wrapper_0/dig_in[4] analog_switch_array_7[5]/analog_switch_med_20/enable
+ slot6_wrapper_0/dig_in[23] project_control_area_7/user_project_control_0/dig_out[3]
+ project_control_area_7/user_project_control_0/dig_out[11] project_control_area_7/user_project_control_0/dig_out[4]
+ slot6_wrapper_0/analog_bus2 slot6_wrapper_0/dig_in[5] housekeeping_top_0/analog_bus_ena[1]
+ slot6_wrapper_0/analog_bus1 housekeeping_top_0/dbus_out[5] slot6_wrapper_0/dig_in[6]
+ housekeeping_top_0/dbus_out[21] housekeeping_top_0/dbus_out[9] project_control_area_7/user_project_control_0/dig_out[8]
+ slot6_wrapper_0/analog_bus0 project_control_area_7/user_project_control_0/dig_out[9]
+ slot6_wrapper_0/dig_in[7] project_control_area_5/user_project_control_0/dig_out[11]
+ slot6_wrapper_0/dig_in[8] analog_switch_array_7[5]/analog_pswitch_small_0/enable
+ housekeeping_top_0/proj_sel[0] housekeeping_top_0/dbus_out[1] slot6_wrapper_0/dig_in[9]
+ housekeeping_top_0/dbus_out[17] housekeeping_top_0/dbus_out[2] vss3v3 slot6_wrapper_0/dig_out[10]
+ housekeeping_top_0/proj_dig_ena slot6_wrapper_0/dig_out[11] housekeeping_top_0/dbus_out[10]
+ vdd1v2_uq2 vss3v3 project_control_area_7/user_project_control_0/dig_out[5] housekeeping_top_0/proj_ibias_ena[1]
+ housekeeping_top_0/dbus_out[23] slot6_wrapper_0/ibias1 project_control_area_7/user_project_control_0/dig_out[10]
+ slot6_wrapper_0/vdd_3v3 housekeeping_top_0/dbus_out[6] slot6_wrapper_0/ibias0 slot6_wrapper_0/dig_in[10]
+ project_control_area_5/user_project_control_0/dig_out[2] housekeeping_top_0/proj_vbias_ena
+ slot6_wrapper_0/dig_in[11] vdd3v3 slot6_wrapper_0/enable project_control_area_5/user_project_control_0/dig_out[1]
+ project_control_area_5/user_project_control_0/dig_out[3] slot6_wrapper_0/dig_in[12]
+ slot6_wrapper_0/dig_in[13] housekeeping_top_0/proj_3v3_ena project_control_area_5/user_project_control_0/dig_out[4]
+ slot6_wrapper_0/vbias slot6_wrapper_0/dig_in[14] housekeeping_top_0/analog_bus_ena[3]
+ housekeeping_top_0/proj_ibias_ena[0] project_control_area_5/user_project_control_0/dig_out[5]
+ slot6_wrapper_0/dig_in[15] housekeeping_top_0/dbus_out[20] vdd1v2_uq2 housekeeping_top_0/dbus_out[19]
+ slot6_wrapper_0/dig_in[16] project_control_area_5/user_project_control_0/dig_out[6]
+ housekeeping_top_0/proj_sel[4] project_control_area_7/user_project_control_0/dig_out[6]
+ vss3v3 housekeeping_top_0/reset housekeeping_top_0/dbus_out[12] slot6_wrapper_0/dig_in[17]
+ housekeeping_top_0/analog_bus_ena[0] housekeeping_top_0/proj_1v2_ena slot6_wrapper_0/dig_in[18]
+ housekeeping_top_0/proj_ena slot6_wrapper_0/dig_in[19] vdd1v2_uq2 project_control_area_5/user_project_control_0/dig_out[9]
+ vdd3v3 housekeeping_top_0/dbus_out[14] analog_switch_array_7[5]/analog_pswitch_small_1/enable
+ project_control_area_5/user_project_control_0/dig_out[10] housekeeping_top_0/dbus_out[16]
+ housekeeping_top_0/dbus_out[18] slot6_wrapper_0/dig_out[0] housekeeping_top_0/clk_out
+ slot6_wrapper_0/reset slot6_wrapper_0/dig_out[1] project_control_area_7/user_project_control_0/dig_out[2]
+ housekeeping_top_0/dbus_out[0] slot6_wrapper_0/dig_out[2] project_control_area_7/user_project_control_0/dig_out[7]
+ project_control_area_7/user_project_control_0/dig_out[0] slot6_wrapper_0/clk project_control_area_7/user_project_control_0/dig_out[1]
+ housekeeping_top_0/dbus_out[7] slot6_wrapper_0/dig_out[3] housekeeping_top_0/dbus_out[8]
+ housekeeping_top_0/dbus_out[11] project_control_area_5/user_project_control_0/dig_out[7]
+ slot6_wrapper_0/dig_out[4] housekeeping_top_0/dbus_out[3] analog_switch_array_7[5]/analog_switch_small_0/enable
+ housekeeping_top_0/proj_sel[3] slot6_wrapper_0/dig_out[5] project_control_area_5/user_project_control_0/dig_out[8]
+ housekeeping_top_0/dbus_out[4] slot6_wrapper_0/dig_in[0] housekeeping_top_0/dbus_out[15]
+ vss3v3 analog_switch_array_7[5]/analog_switch_med_22/enable housekeeping_top_0/dbus_out[13]
+ slot6_wrapper_0/dig_out[6] vss3v3 slot6_wrapper_0/vdd_1v2 vdd1v2_uq2 vss3v3 slot6_wrapper_0/dig_in[1]
+ project_control_area
Xslot15_wrapper_0 vss3v3 s15_an[0] s15_an_0_esd slot15_wrapper_0/vbias slot15_wrapper_0/dig_in[23]
+ slot15_wrapper_0/dig_in[22] slot15_wrapper_0/dig_in[21] slot15_wrapper_0/dig_in[20]
+ slot15_wrapper_0/dig_in[19] slot15_wrapper_0/dig_in[18] slot15_wrapper_0/dig_in[17]
+ slot15_wrapper_0/dig_in[16] slot15_wrapper_0/dig_in[15] slot15_wrapper_0/dig_in[14]
+ slot15_wrapper_0/dig_in[13] slot15_wrapper_0/dig_in[12] slot15_wrapper_0/dig_in[11]
+ slot15_wrapper_0/dig_in[10] slot15_wrapper_0/dig_in[9] slot15_wrapper_0/dig_in[8]
+ slot15_wrapper_0/dig_in[7] slot15_wrapper_0/dig_in[6] slot15_wrapper_0/dig_in[5]
+ slot15_wrapper_0/dig_in[4] slot15_wrapper_0/dig_in[3] slot15_wrapper_0/dig_in[2]
+ slot15_wrapper_0/dig_in[1] slot15_wrapper_0/dig_in[0] slot15_wrapper_0/dig_out[11]
+ slot15_wrapper_0/dig_out[10] slot15_wrapper_0/dig_out[9] slot15_wrapper_0/dig_out[8]
+ slot15_wrapper_0/dig_out[7] slot15_wrapper_0/dig_out[6] slot15_wrapper_0/dig_out[5]
+ slot15_wrapper_0/dig_out[4] slot15_wrapper_0/dig_out[3] slot15_wrapper_0/dig_out[2]
+ slot15_wrapper_0/dig_out[1] slot15_wrapper_0/dig_out[0] slot15_wrapper_0/ibias0
+ slot15_wrapper_0/ibias1 slot15_wrapper_0/analog_bus3 slot15_wrapper_0/analog_bus2
+ slot15_wrapper_0/analog_bus1 slot15_wrapper_0/analog_bus0 vss3v3 slot15_wrapper_0/vdd_1v2
+ slot15_wrapper_0/vdd_3v3 slot15_wrapper_0/enable slot15_wrapper_0/clk slot15_wrapper_0/reset
+ slot15_wrapper
Xsg13cmos5l_ocd_ip__voltgen_v2_0 vdd1v2_uq2 housekeeping_top_0/voltgen_value[2] housekeeping_top_0/voltgen_value[1]
+ housekeeping_top_0/voltgen_value[0] analog_switch_small_0/in sg13cmos5l_ocd_ip__voltgen_v2_0/ibias1u_1
+ sg13cmos5l_ocd_ip__voltgen_v2_0/ibias1u_2 housekeeping_top_0/voltgen_ena[0] sg13cmos5l_ocd_ip__voltgen_v2_0/vout1
+ housekeeping_top_0/voltgen_ena[1] housekeeping_top_0/voltgen_ena[2] sg13cmos5l_ocd_ip__voltgen_v2_0/ibias1u_3
+ housekeeping_top_0/voltgen_high analog_switch_small_1/in vss3v3 vdd3v3 vss3v3 sg13cmos5l_ocd_ip__voltgen_v2
XRM_IHPSG13_1P_1024x8_c2_bm_bist_0 housekeeping_top_0/sram_addr[9] housekeeping_top_0/sram_addr[8]
+ housekeeping_top_0/sram_addr[7] housekeeping_top_0/sram_addr[6] housekeeping_top_0/sram_addr[5]
+ housekeeping_top_0/sram_addr[4] housekeeping_top_0/sram_addr[3] housekeeping_top_0/sram_addr[2]
+ housekeeping_top_0/sram_addr[1] housekeeping_top_0/sram_addr[0] vss3v3 vss3v3 vss3v3
+ vss3v3 vss3v3 vss3v3 vss3v3 vss3v3 vss3v3 vss3v3 vss3v3 vss3v3 vss3v3 vss3v3 vss3v3
+ vss3v3 vss3v3 vss3v3 vss3v3 vss3v3 vss3v3 vss3v3 vss3v3 vss3v3 vss3v3 vss3v3 vss3v3
+ vss3v3 vss3v3 vss3v3 vss3v3 vddd vddd vddd vddd vddd vddd vddd vddd housekeeping_top_0/sram_clk
+ housekeeping_top_0/sram_idata[7] housekeeping_top_0/sram_idata[6] housekeeping_top_0/sram_idata[5]
+ housekeeping_top_0/sram_idata[4] housekeeping_top_0/sram_idata[3] housekeeping_top_0/sram_idata[2]
+ housekeeping_top_0/sram_idata[1] housekeeping_top_0/sram_idata[0] vddd housekeeping_top_0/sram_odata[7]
+ housekeeping_top_0/sram_odata[6] housekeeping_top_0/sram_odata[5] housekeeping_top_0/sram_odata[4]
+ housekeeping_top_0/sram_odata[3] housekeeping_top_0/sram_odata[2] housekeeping_top_0/sram_odata[1]
+ housekeeping_top_0/sram_odata[0] housekeeping_top_0/porb housekeeping_top_0/sram_read
+ housekeeping_top_0/sram_write vddd vddd vss3v3 RM_IHPSG13_1P_1024x8_c2_bm_bist
Xproject_control_area_8 slot14_wrapper_0/dig_in[20] analog_switch_array_7[4]/analog_switch_med_1/enable
+ analog_switch_array_7[4]/analog_switch_med_0/enable slot14_wrapper_0/dig_out[7]
+ housekeeping_top_0/proj_sel[2] project_control_area_6/user_project_control_0/dig_out[0]
+ slot14_wrapper_0/dig_in[2] slot14_wrapper_0/dig_in[21] housekeeping_top_0/dbus_out[22]
+ slot14_wrapper_0/dig_out[8] housekeeping_top_0/proj_sel[1] slot14_wrapper_0/dig_in[3]
+ slot14_wrapper_0/dig_in[22] slot14_wrapper_0/dig_out[9] housekeeping_top_0/analog_bus_ena[2]
+ slot14_wrapper_0/analog_bus3 slot14_wrapper_0/dig_in[4] analog_switch_array_7[4]/analog_switch_med_2/enable
+ slot14_wrapper_0/dig_in[23] project_control_area_8/user_project_control_0/dig_out[3]
+ project_control_area_8/user_project_control_0/dig_out[11] project_control_area_8/user_project_control_0/dig_out[4]
+ slot14_wrapper_0/analog_bus2 slot14_wrapper_0/dig_in[5] housekeeping_top_0/analog_bus_ena[1]
+ slot14_wrapper_0/analog_bus1 housekeeping_top_0/dbus_out[5] slot14_wrapper_0/dig_in[6]
+ housekeeping_top_0/dbus_out[21] housekeeping_top_0/dbus_out[9] project_control_area_8/user_project_control_0/dig_out[8]
+ slot14_wrapper_0/analog_bus0 project_control_area_8/user_project_control_0/dig_out[9]
+ slot14_wrapper_0/dig_in[7] project_control_area_6/user_project_control_0/dig_out[11]
+ slot14_wrapper_0/dig_in[8] analog_switch_array_7[4]/analog_pswitch_small_3/enable
+ housekeeping_top_0/proj_sel[0] housekeeping_top_0/dbus_out[1] slot14_wrapper_0/dig_in[9]
+ housekeeping_top_0/dbus_out[17] housekeeping_top_0/dbus_out[2] vss3v3 slot14_wrapper_0/dig_out[10]
+ housekeeping_top_0/proj_dig_ena slot14_wrapper_0/dig_out[11] housekeeping_top_0/dbus_out[10]
+ vdd1v2_uq2 vdd1v2_uq2 project_control_area_8/user_project_control_0/dig_out[5] housekeeping_top_0/proj_ibias_ena[1]
+ housekeeping_top_0/dbus_out[23] slot14_wrapper_0/ibias1 project_control_area_8/user_project_control_0/dig_out[10]
+ slot14_wrapper_0/vdd_3v3 housekeeping_top_0/dbus_out[6] slot14_wrapper_0/ibias0
+ slot14_wrapper_0/dig_in[10] project_control_area_6/user_project_control_0/dig_out[2]
+ housekeeping_top_0/proj_vbias_ena slot14_wrapper_0/dig_in[11] vdd3v3 slot14_wrapper_0/enable
+ project_control_area_6/user_project_control_0/dig_out[1] project_control_area_6/user_project_control_0/dig_out[3]
+ slot14_wrapper_0/dig_in[12] slot14_wrapper_0/dig_in[13] housekeeping_top_0/proj_3v3_ena
+ project_control_area_6/user_project_control_0/dig_out[4] slot14_wrapper_0/vbias
+ slot14_wrapper_0/dig_in[14] housekeeping_top_0/analog_bus_ena[3] housekeeping_top_0/proj_ibias_ena[0]
+ project_control_area_6/user_project_control_0/dig_out[5] slot14_wrapper_0/dig_in[15]
+ housekeeping_top_0/dbus_out[20] vdd1v2_uq2 housekeeping_top_0/dbus_out[19] slot14_wrapper_0/dig_in[16]
+ project_control_area_6/user_project_control_0/dig_out[6] housekeeping_top_0/proj_sel[4]
+ project_control_area_8/user_project_control_0/dig_out[6] vss3v3 housekeeping_top_0/reset
+ housekeeping_top_0/dbus_out[12] slot14_wrapper_0/dig_in[17] housekeeping_top_0/analog_bus_ena[0]
+ housekeeping_top_0/proj_1v2_ena slot14_wrapper_0/dig_in[18] housekeeping_top_0/proj_ena
+ slot14_wrapper_0/dig_in[19] vdd1v2_uq2 project_control_area_6/user_project_control_0/dig_out[9]
+ vdd3v3 housekeeping_top_0/dbus_out[14] analog_switch_array_7[4]/analog_pswitch_small_2/enable
+ project_control_area_6/user_project_control_0/dig_out[10] housekeeping_top_0/dbus_out[16]
+ housekeeping_top_0/dbus_out[18] slot14_wrapper_0/dig_out[0] housekeeping_top_0/clk_out
+ slot14_wrapper_0/reset slot14_wrapper_0/dig_out[1] project_control_area_8/user_project_control_0/dig_out[2]
+ housekeeping_top_0/dbus_out[0] slot14_wrapper_0/dig_out[2] project_control_area_8/user_project_control_0/dig_out[7]
+ project_control_area_8/user_project_control_0/dig_out[0] slot14_wrapper_0/clk project_control_area_8/user_project_control_0/dig_out[1]
+ housekeeping_top_0/dbus_out[7] slot14_wrapper_0/dig_out[3] housekeeping_top_0/dbus_out[8]
+ housekeeping_top_0/dbus_out[11] project_control_area_6/user_project_control_0/dig_out[7]
+ slot14_wrapper_0/dig_out[4] housekeeping_top_0/dbus_out[3] analog_switch_array_7[4]/analog_switch_small_1/enable
+ housekeeping_top_0/proj_sel[3] slot14_wrapper_0/dig_out[5] project_control_area_6/user_project_control_0/dig_out[8]
+ housekeeping_top_0/dbus_out[4] slot14_wrapper_0/dig_in[0] housekeeping_top_0/dbus_out[15]
+ vss3v3 analog_switch_array_7[4]/analog_switch_med_3/enable housekeeping_top_0/dbus_out[13]
+ slot14_wrapper_0/dig_out[6] vss3v3 slot14_wrapper_0/vdd_1v2 vdd1v2_uq2 vss3v3 slot14_wrapper_0/dig_in[1]
+ project_control_area
Xsg13cmos5l_ocd_ip__biasgen2_0 housekeeping_top_0/biasgen_ena analog_switch_small_0/in
+ housekeeping_top_0/biasgen_ref_vbg analog_pswitch_small_1/out housekeeping_top_0/idac2_value[4]
+ housekeeping_top_0/idac2_value[3] housekeeping_top_0/idac2_value[2] housekeeping_top_0/idac2_value[1]
+ housekeeping_top_0/idac2_value[0] analog_pswitch_small_0/out housekeeping_top_0/idac1_value[0]
+ housekeeping_top_0/idac1_value[1] housekeeping_top_0/idac1_value[2] housekeeping_top_0/idac1_value[3]
+ housekeeping_top_0/idac1_value[4] housekeeping_top_0/voltgen_source[4] housekeeping_top_0/voltgen_source[3]
+ housekeeping_top_0/voltgen_source[2] housekeeping_top_0/voltgen_source[1] housekeeping_top_0/voltgen_source[0]
+ sg13cmos5l_ocd_ip__voltgen_v2_0/ibias1u_1 housekeeping_top_0/biasgen_coarse housekeeping_top_0/biasgen_fine
+ sg13cmos5l_ocd_ip__bandgap_v3_0/ibias1_250n housekeeping_top_0/bandgap_sink2[0]
+ housekeeping_top_0/bandgap_sink2[1] housekeeping_top_0/bandgap_sink1[0] housekeeping_top_0/bandgap_sink1[1]
+ housekeeping_top_0/bandgap_sink1[2] housekeeping_top_0/voltgen_sink1[0] housekeeping_top_0/voltgen_sink1[1]
+ housekeeping_top_0/voltgen_sink1[2] housekeeping_top_0/voltgen_sink2[0] housekeeping_top_0/voltgen_sink2[1]
+ housekeeping_top_0/voltgen_sink2[2] sg13cmos5l_ocd_ip__voltgen_v2_0/ibias1u_2 sg13cmos5l_ocd_ip__voltgen_v2_0/ibias1u_3
+ sg13cmos5l_ocd_ip__bandgap_v3_0/ibias2_1u vdd3v3 vdd3v3 vss3v3 vss3v3 vdd1v2_uq2
+ sg13cmos5l_ocd_ip__biasgen2
Xproject_control_area_9 slot5_wrapper_0/dig_in[20] analog_switch_array_7[4]/analog_switch_med_18/enable
+ analog_switch_array_7[4]/analog_switch_med_17/enable slot5_wrapper_0/dig_out[7]
+ housekeeping_top_0/proj_sel[2] project_control_area_7/user_project_control_0/dig_out[0]
+ slot5_wrapper_0/dig_in[2] slot5_wrapper_0/dig_in[21] housekeeping_top_0/dbus_out[22]
+ slot5_wrapper_0/dig_out[8] housekeeping_top_0/proj_sel[1] slot5_wrapper_0/dig_in[3]
+ slot5_wrapper_0/dig_in[22] slot5_wrapper_0/dig_out[9] housekeeping_top_0/analog_bus_ena[2]
+ slot5_wrapper_0/analog_bus3 slot5_wrapper_0/dig_in[4] analog_switch_array_7[4]/analog_switch_med_20/enable
+ slot5_wrapper_0/dig_in[23] project_control_area_9/user_project_control_0/dig_out[3]
+ project_control_area_9/user_project_control_0/dig_out[11] project_control_area_9/user_project_control_0/dig_out[4]
+ slot5_wrapper_0/analog_bus2 slot5_wrapper_0/dig_in[5] housekeeping_top_0/analog_bus_ena[1]
+ slot5_wrapper_0/analog_bus1 housekeeping_top_0/dbus_out[5] slot5_wrapper_0/dig_in[6]
+ housekeeping_top_0/dbus_out[21] housekeeping_top_0/dbus_out[9] project_control_area_9/user_project_control_0/dig_out[8]
+ slot5_wrapper_0/analog_bus0 project_control_area_9/user_project_control_0/dig_out[9]
+ slot5_wrapper_0/dig_in[7] project_control_area_7/user_project_control_0/dig_out[11]
+ slot5_wrapper_0/dig_in[8] analog_switch_array_7[4]/analog_pswitch_small_0/enable
+ housekeeping_top_0/proj_sel[0] housekeeping_top_0/dbus_out[1] slot5_wrapper_0/dig_in[9]
+ housekeeping_top_0/dbus_out[17] housekeeping_top_0/dbus_out[2] vdd1v2_uq2 slot5_wrapper_0/dig_out[10]
+ housekeeping_top_0/proj_dig_ena slot5_wrapper_0/dig_out[11] housekeeping_top_0/dbus_out[10]
+ vss3v3 vss3v3 project_control_area_9/user_project_control_0/dig_out[5] housekeeping_top_0/proj_ibias_ena[1]
+ housekeeping_top_0/dbus_out[23] slot5_wrapper_0/ibias1 project_control_area_9/user_project_control_0/dig_out[10]
+ slot5_wrapper_0/vdd_3v3 housekeeping_top_0/dbus_out[6] slot5_wrapper_0/ibias0 slot5_wrapper_0/dig_in[10]
+ project_control_area_7/user_project_control_0/dig_out[2] housekeeping_top_0/proj_vbias_ena
+ slot5_wrapper_0/dig_in[11] vdd3v3 slot5_wrapper_0/enable project_control_area_7/user_project_control_0/dig_out[1]
+ project_control_area_7/user_project_control_0/dig_out[3] slot5_wrapper_0/dig_in[12]
+ slot5_wrapper_0/dig_in[13] housekeeping_top_0/proj_3v3_ena project_control_area_7/user_project_control_0/dig_out[4]
+ slot5_wrapper_0/vbias slot5_wrapper_0/dig_in[14] housekeeping_top_0/analog_bus_ena[3]
+ housekeeping_top_0/proj_ibias_ena[0] project_control_area_7/user_project_control_0/dig_out[5]
+ slot5_wrapper_0/dig_in[15] housekeeping_top_0/dbus_out[20] vdd1v2_uq2 housekeeping_top_0/dbus_out[19]
+ slot5_wrapper_0/dig_in[16] project_control_area_7/user_project_control_0/dig_out[6]
+ housekeeping_top_0/proj_sel[4] project_control_area_9/user_project_control_0/dig_out[6]
+ vss3v3 housekeeping_top_0/reset housekeeping_top_0/dbus_out[12] slot5_wrapper_0/dig_in[17]
+ housekeeping_top_0/analog_bus_ena[0] housekeeping_top_0/proj_1v2_ena slot5_wrapper_0/dig_in[18]
+ housekeeping_top_0/proj_ena slot5_wrapper_0/dig_in[19] vdd1v2_uq2 project_control_area_7/user_project_control_0/dig_out[9]
+ vdd3v3 housekeeping_top_0/dbus_out[14] analog_switch_array_7[4]/analog_pswitch_small_1/enable
+ project_control_area_7/user_project_control_0/dig_out[10] housekeeping_top_0/dbus_out[16]
+ housekeeping_top_0/dbus_out[18] slot5_wrapper_0/dig_out[0] housekeeping_top_0/clk_out
+ slot5_wrapper_0/reset slot5_wrapper_0/dig_out[1] project_control_area_9/user_project_control_0/dig_out[2]
+ housekeeping_top_0/dbus_out[0] slot5_wrapper_0/dig_out[2] project_control_area_9/user_project_control_0/dig_out[7]
+ project_control_area_9/user_project_control_0/dig_out[0] slot5_wrapper_0/clk project_control_area_9/user_project_control_0/dig_out[1]
+ housekeeping_top_0/dbus_out[7] slot5_wrapper_0/dig_out[3] housekeeping_top_0/dbus_out[8]
+ housekeeping_top_0/dbus_out[11] project_control_area_7/user_project_control_0/dig_out[7]
+ slot5_wrapper_0/dig_out[4] housekeeping_top_0/dbus_out[3] analog_switch_array_7[4]/analog_switch_small_0/enable
+ housekeeping_top_0/proj_sel[3] slot5_wrapper_0/dig_out[5] project_control_area_7/user_project_control_0/dig_out[8]
+ housekeeping_top_0/dbus_out[4] slot5_wrapper_0/dig_in[0] housekeeping_top_0/dbus_out[15]
+ vss3v3 analog_switch_array_7[4]/analog_switch_med_22/enable housekeeping_top_0/dbus_out[13]
+ slot5_wrapper_0/dig_out[6] vss3v3 slot5_wrapper_0/vdd_1v2 vdd1v2_uq2 vss3v3 slot5_wrapper_0/dig_in[1]
+ project_control_area
Xslot2_wrapper_0 s2_an[0] s2_an[1] s2_an_0_esd s2_an_1_esd slot2_wrapper_0/vbias slot2_wrapper_0/dig_in[23]
+ slot2_wrapper_0/dig_in[22] slot2_wrapper_0/dig_in[21] slot2_wrapper_0/dig_in[20]
+ slot2_wrapper_0/dig_in[19] slot2_wrapper_0/dig_in[18] slot2_wrapper_0/dig_in[17]
+ slot2_wrapper_0/dig_in[16] slot2_wrapper_0/dig_in[15] slot2_wrapper_0/dig_in[14]
+ slot2_wrapper_0/dig_in[13] slot2_wrapper_0/dig_in[12] slot2_wrapper_0/dig_in[11]
+ slot2_wrapper_0/dig_in[10] slot2_wrapper_0/dig_in[9] slot2_wrapper_0/dig_in[8] slot2_wrapper_0/dig_in[7]
+ slot2_wrapper_0/dig_in[6] slot2_wrapper_0/dig_in[5] slot2_wrapper_0/dig_in[4] slot2_wrapper_0/dig_in[3]
+ slot2_wrapper_0/dig_in[2] slot2_wrapper_0/dig_in[1] slot2_wrapper_0/dig_in[0] slot2_wrapper_0/dig_out[11]
+ slot2_wrapper_0/dig_out[10] slot2_wrapper_0/dig_out[9] slot2_wrapper_0/dig_out[8]
+ slot2_wrapper_0/dig_out[7] slot2_wrapper_0/dig_out[6] slot2_wrapper_0/dig_out[5]
+ slot2_wrapper_0/dig_out[4] slot2_wrapper_0/dig_out[3] slot2_wrapper_0/dig_out[2]
+ slot2_wrapper_0/dig_out[1] slot2_wrapper_0/dig_out[0] slot2_wrapper_0/ibias0 slot2_wrapper_0/ibias1
+ slot2_wrapper_0/analog_bus3 slot2_wrapper_0/analog_bus2 slot2_wrapper_0/analog_bus1
+ slot2_wrapper_0/analog_bus0 vss3v3 slot2_wrapper_0/vdd_1v2 vss3v3 slot2_wrapper_0/vdd_3v3
+ slot2_wrapper_0/enable slot2_wrapper_0/clk slot2_wrapper_0/reset slot2_wrapper
Xslot6_wrapper_0 s6_an[0] s6_an[1] s6_an_0_esd s6_an_1_esd slot6_wrapper_0/vbias slot6_wrapper_0/dig_in[23]
+ slot6_wrapper_0/dig_in[22] slot6_wrapper_0/dig_in[21] slot6_wrapper_0/dig_in[20]
+ slot6_wrapper_0/dig_in[19] slot6_wrapper_0/dig_in[18] slot6_wrapper_0/dig_in[17]
+ slot6_wrapper_0/dig_in[16] slot6_wrapper_0/dig_in[15] slot6_wrapper_0/dig_in[14]
+ slot6_wrapper_0/dig_in[13] slot6_wrapper_0/dig_in[12] slot6_wrapper_0/dig_in[11]
+ slot6_wrapper_0/dig_in[10] slot6_wrapper_0/dig_in[9] slot6_wrapper_0/dig_in[8] slot6_wrapper_0/dig_in[7]
+ slot6_wrapper_0/dig_in[6] slot6_wrapper_0/dig_in[5] slot6_wrapper_0/dig_in[4] slot6_wrapper_0/dig_in[3]
+ slot6_wrapper_0/dig_in[2] slot6_wrapper_0/dig_in[1] slot6_wrapper_0/dig_in[0] slot6_wrapper_0/dig_out[11]
+ slot6_wrapper_0/dig_out[10] slot6_wrapper_0/dig_out[9] slot6_wrapper_0/dig_out[8]
+ slot6_wrapper_0/dig_out[7] slot6_wrapper_0/dig_out[6] slot6_wrapper_0/dig_out[5]
+ slot6_wrapper_0/dig_out[4] slot6_wrapper_0/dig_out[3] slot6_wrapper_0/dig_out[2]
+ slot6_wrapper_0/dig_out[1] slot6_wrapper_0/dig_out[0] slot6_wrapper_0/ibias0 slot6_wrapper_0/ibias1
+ slot6_wrapper_0/analog_bus3 slot6_wrapper_0/analog_bus2 slot6_wrapper_0/analog_bus1
+ slot6_wrapper_0/analog_bus0 vss3v3 slot6_wrapper_0/vdd_1v2 vss3v3 slot6_wrapper_0/vdd_3v3
+ slot6_wrapper_0/enable slot6_wrapper_0/clk slot6_wrapper_0/reset slot6_wrapper
Xanalog_pswitch_small_1 analog[1] analog_pswitch_small_1/out vss3v3 analog_switch_small_1/enable
+ vdd3v3 vdd1v2_uq2 vss3v3 analog_pswitch_small
Xanalog_pswitch_small_0 analog[2] analog_pswitch_small_0/out vss3v3 analog_switch_small_1/enable
+ vdd3v3 vdd1v2_uq2 vss3v3 analog_pswitch_small
Xslot10_wrapper_0 s10_an[0] s10_an[1] s10_an[2] s10_an_0_esd s10_an_1_esd s10_an_2_esd
+ slot10_wrapper_0/vbias slot10_wrapper_0/dig_in[23] slot10_wrapper_0/dig_in[22] slot10_wrapper_0/dig_in[21]
+ slot10_wrapper_0/dig_in[20] slot10_wrapper_0/dig_in[19] slot10_wrapper_0/dig_in[18]
+ slot10_wrapper_0/dig_in[17] slot10_wrapper_0/dig_in[16] slot10_wrapper_0/dig_in[15]
+ slot10_wrapper_0/dig_in[14] slot10_wrapper_0/dig_in[13] slot10_wrapper_0/dig_in[12]
+ slot10_wrapper_0/dig_in[11] slot10_wrapper_0/dig_in[10] slot10_wrapper_0/dig_in[9]
+ slot10_wrapper_0/dig_in[8] slot10_wrapper_0/dig_in[7] slot10_wrapper_0/dig_in[6]
+ slot10_wrapper_0/dig_in[5] slot10_wrapper_0/dig_in[4] slot10_wrapper_0/dig_in[3]
+ slot10_wrapper_0/dig_in[2] slot10_wrapper_0/dig_in[1] slot10_wrapper_0/dig_in[0]
+ slot10_wrapper_0/dig_out[11] slot10_wrapper_0/dig_out[10] slot10_wrapper_0/dig_out[9]
+ slot10_wrapper_0/dig_out[8] slot10_wrapper_0/dig_out[7] slot10_wrapper_0/dig_out[6]
+ slot10_wrapper_0/dig_out[5] slot10_wrapper_0/dig_out[4] slot10_wrapper_0/dig_out[3]
+ slot10_wrapper_0/dig_out[2] slot10_wrapper_0/dig_out[1] slot10_wrapper_0/dig_out[0]
+ slot10_wrapper_0/ibias0 slot10_wrapper_0/ibias1 slot10_wrapper_0/analog_bus3 slot10_wrapper_0/analog_bus2
+ slot10_wrapper_0/analog_bus1 slot10_wrapper_0/analog_bus0 vss3v3 slot10_wrapper_0/vdd_1v2
+ vss3v3 slot10_wrapper_0/vdd_3v3 slot10_wrapper_0/enable slot10_wrapper_0/clk slot10_wrapper_0/reset
+ slot10_wrapper
Xslot14_wrapper_0 s14_an[0] s14_an[1] s14_an[2] s14_an_0_esd s14_an_1_esd s14_an_2_esd
+ slot14_wrapper_0/vbias slot14_wrapper_0/dig_in[23] slot14_wrapper_0/dig_in[22] slot14_wrapper_0/dig_in[21]
+ slot14_wrapper_0/dig_in[20] slot14_wrapper_0/dig_in[19] slot14_wrapper_0/dig_in[18]
+ slot14_wrapper_0/dig_in[17] slot14_wrapper_0/dig_in[16] slot14_wrapper_0/dig_in[15]
+ slot14_wrapper_0/dig_in[14] slot14_wrapper_0/dig_in[13] slot14_wrapper_0/dig_in[12]
+ slot14_wrapper_0/dig_in[11] slot14_wrapper_0/dig_in[10] slot14_wrapper_0/dig_in[9]
+ slot14_wrapper_0/dig_in[8] slot14_wrapper_0/dig_in[7] slot14_wrapper_0/dig_in[6]
+ slot14_wrapper_0/dig_in[5] slot14_wrapper_0/dig_in[4] slot14_wrapper_0/dig_in[3]
+ slot14_wrapper_0/dig_in[2] slot14_wrapper_0/dig_in[1] slot14_wrapper_0/dig_in[0]
+ slot14_wrapper_0/dig_out[11] slot14_wrapper_0/dig_out[10] slot14_wrapper_0/dig_out[9]
+ slot14_wrapper_0/dig_out[8] slot14_wrapper_0/dig_out[7] slot14_wrapper_0/dig_out[6]
+ slot14_wrapper_0/dig_out[5] slot14_wrapper_0/dig_out[4] slot14_wrapper_0/dig_out[3]
+ slot14_wrapper_0/dig_out[2] slot14_wrapper_0/dig_out[1] slot14_wrapper_0/dig_out[0]
+ slot14_wrapper_0/ibias0 slot14_wrapper_0/ibias1 slot14_wrapper_0/analog_bus3 slot14_wrapper_0/analog_bus2
+ slot14_wrapper_0/analog_bus1 slot14_wrapper_0/analog_bus0 vss3v3 slot14_wrapper_0/vdd_1v2
+ vss3v3 slot14_wrapper_0/vdd_3v3 slot14_wrapper_0/enable slot14_wrapper_0/clk slot14_wrapper_0/reset
+ slot14_wrapper
Xslot18_wrapper_0 s18_an[0] s18_an[1] s18_an_0_esd s18_an_1_esd slot18_wrapper_0/vbias
+ slot18_wrapper_0/dig_in[23] slot18_wrapper_0/dig_in[22] slot18_wrapper_0/dig_in[21]
+ slot18_wrapper_0/dig_in[20] slot18_wrapper_0/dig_in[19] slot18_wrapper_0/dig_in[18]
+ slot18_wrapper_0/dig_in[17] slot18_wrapper_0/dig_in[16] slot18_wrapper_0/dig_in[15]
+ slot18_wrapper_0/dig_in[14] slot18_wrapper_0/dig_in[13] slot18_wrapper_0/dig_in[12]
+ slot18_wrapper_0/dig_in[11] slot18_wrapper_0/dig_in[10] slot18_wrapper_0/dig_in[9]
+ slot18_wrapper_0/dig_in[8] slot18_wrapper_0/dig_in[7] slot18_wrapper_0/dig_in[6]
+ slot18_wrapper_0/dig_in[5] slot18_wrapper_0/dig_in[4] slot18_wrapper_0/dig_in[3]
+ slot18_wrapper_0/dig_in[2] slot18_wrapper_0/dig_in[1] slot18_wrapper_0/dig_in[0]
+ slot18_wrapper_0/dig_out[11] slot18_wrapper_0/dig_out[10] slot18_wrapper_0/dig_out[9]
+ slot18_wrapper_0/dig_out[8] slot18_wrapper_0/dig_out[7] slot18_wrapper_0/dig_out[6]
+ slot18_wrapper_0/dig_out[5] slot18_wrapper_0/dig_out[4] slot18_wrapper_0/dig_out[3]
+ slot18_wrapper_0/dig_out[2] slot18_wrapper_0/dig_out[1] slot18_wrapper_0/dig_out[0]
+ slot18_wrapper_0/ibias0 slot18_wrapper_0/ibias1 slot18_wrapper_0/analog_bus3 slot18_wrapper_0/analog_bus2
+ slot18_wrapper_0/analog_bus1 slot18_wrapper_0/analog_bus0 vss3v3 slot18_wrapper_0/vdd_1v2
+ vss3v3 slot18_wrapper_0/vdd_3v3 slot18_wrapper_0/enable slot18_wrapper_0/clk slot18_wrapper_0/reset
+ slot18_wrapper
Xslot1_wrapper_0 s1_an[0] s1_an[1] s1_an_0_esd slot1_wrapper_0/vbias slot1_wrapper_0/dig_in[23]
+ slot1_wrapper_0/dig_in[22] slot1_wrapper_0/dig_in[21] slot1_wrapper_0/dig_in[20]
+ slot1_wrapper_0/dig_in[19] slot1_wrapper_0/dig_in[18] slot1_wrapper_0/dig_in[17]
+ slot1_wrapper_0/dig_in[16] slot1_wrapper_0/dig_in[15] slot1_wrapper_0/dig_in[14]
+ slot1_wrapper_0/dig_in[13] slot1_wrapper_0/dig_in[12] slot1_wrapper_0/dig_in[11]
+ slot1_wrapper_0/dig_in[10] slot1_wrapper_0/dig_in[9] slot1_wrapper_0/dig_in[8] slot1_wrapper_0/dig_in[7]
+ slot1_wrapper_0/dig_in[6] slot1_wrapper_0/dig_in[5] slot1_wrapper_0/dig_in[4] slot1_wrapper_0/dig_in[3]
+ slot1_wrapper_0/dig_in[2] slot1_wrapper_0/dig_in[1] slot1_wrapper_0/dig_in[0] slot1_wrapper_0/dig_out[11]
+ slot1_wrapper_0/dig_out[10] slot1_wrapper_0/dig_out[9] slot1_wrapper_0/dig_out[8]
+ slot1_wrapper_0/dig_out[7] slot1_wrapper_0/dig_out[6] slot1_wrapper_0/dig_out[5]
+ slot1_wrapper_0/dig_out[4] slot1_wrapper_0/dig_out[3] slot1_wrapper_0/dig_out[2]
+ slot1_wrapper_0/dig_out[1] slot1_wrapper_0/dig_out[0] slot1_wrapper_0/ibias0 slot1_wrapper_0/ibias1
+ slot1_wrapper_0/analog_bus3 slot1_wrapper_0/analog_bus2 slot1_wrapper_0/analog_bus1
+ slot1_wrapper_0/analog_bus0 vss3v3 slot1_wrapper_0/vdd_1v2 vss3v3 slot1_wrapper_0/vdd_3v3
+ slot1_wrapper_0/enable slot1_wrapper_0/clk slot1_wrapper_0/reset slot1_wrapper
Xslot5_wrapper_0 s5_an[0] s5_an[1] s5_an[2] s5_an_0_esd s5_an_1_esd slot5_wrapper_0/vbias
+ slot5_wrapper_0/dig_in[23] slot5_wrapper_0/dig_in[22] slot5_wrapper_0/dig_in[21]
+ slot5_wrapper_0/dig_in[20] slot5_wrapper_0/dig_in[19] slot5_wrapper_0/dig_in[18]
+ slot5_wrapper_0/dig_in[17] slot5_wrapper_0/dig_in[16] slot5_wrapper_0/dig_in[15]
+ slot5_wrapper_0/dig_in[14] slot5_wrapper_0/dig_in[13] slot5_wrapper_0/dig_in[12]
+ slot5_wrapper_0/dig_in[11] slot5_wrapper_0/dig_in[10] slot5_wrapper_0/dig_in[9]
+ slot5_wrapper_0/dig_in[8] slot5_wrapper_0/dig_in[7] slot5_wrapper_0/dig_in[6] slot5_wrapper_0/dig_in[5]
+ slot5_wrapper_0/dig_in[4] slot5_wrapper_0/dig_in[3] slot5_wrapper_0/dig_in[2] slot5_wrapper_0/dig_in[1]
+ slot5_wrapper_0/dig_in[0] slot5_wrapper_0/dig_out[11] slot5_wrapper_0/dig_out[10]
+ slot5_wrapper_0/dig_out[9] slot5_wrapper_0/dig_out[8] slot5_wrapper_0/dig_out[7]
+ slot5_wrapper_0/dig_out[6] slot5_wrapper_0/dig_out[5] slot5_wrapper_0/dig_out[4]
+ slot5_wrapper_0/dig_out[3] slot5_wrapper_0/dig_out[2] slot5_wrapper_0/dig_out[1]
+ slot5_wrapper_0/dig_out[0] slot5_wrapper_0/ibias0 slot5_wrapper_0/ibias1 slot5_wrapper_0/analog_bus3
+ slot5_wrapper_0/analog_bus2 slot5_wrapper_0/analog_bus1 slot5_wrapper_0/analog_bus0
+ vss3v3 slot5_wrapper_0/vdd_1v2 vss3v3 slot5_wrapper_0/vdd_3v3 slot5_wrapper_0/enable
+ slot5_wrapper_0/clk slot5_wrapper_0/reset slot5_wrapper
Xslot9_wrapper_0 s9_an[0] s9_an[1] s9_an[2] s9_an_0_esd s9_an_1_esd slot9_wrapper_0/vbias
+ slot9_wrapper_0/dig_in[23] slot9_wrapper_0/dig_in[22] slot9_wrapper_0/dig_in[21]
+ slot9_wrapper_0/dig_in[20] slot9_wrapper_0/dig_in[19] slot9_wrapper_0/dig_in[18]
+ slot9_wrapper_0/dig_in[17] slot9_wrapper_0/dig_in[16] slot9_wrapper_0/dig_in[15]
+ slot9_wrapper_0/dig_in[14] slot9_wrapper_0/dig_in[13] slot9_wrapper_0/dig_in[12]
+ slot9_wrapper_0/dig_in[11] slot9_wrapper_0/dig_in[10] slot9_wrapper_0/dig_in[9]
+ slot9_wrapper_0/dig_in[8] slot9_wrapper_0/dig_in[7] slot9_wrapper_0/dig_in[6] slot9_wrapper_0/dig_in[5]
+ slot9_wrapper_0/dig_in[4] slot9_wrapper_0/dig_in[3] slot9_wrapper_0/dig_in[2] slot9_wrapper_0/dig_in[1]
+ slot9_wrapper_0/dig_in[0] slot9_wrapper_0/dig_out[11] slot9_wrapper_0/dig_out[10]
+ slot9_wrapper_0/dig_out[9] slot9_wrapper_0/dig_out[8] slot9_wrapper_0/dig_out[7]
+ slot9_wrapper_0/dig_out[6] slot9_wrapper_0/dig_out[5] slot9_wrapper_0/dig_out[4]
+ slot9_wrapper_0/dig_out[3] slot9_wrapper_0/dig_out[2] slot9_wrapper_0/dig_out[1]
+ slot9_wrapper_0/dig_out[0] slot9_wrapper_0/ibias0 slot9_wrapper_0/ibias1 slot9_wrapper_0/analog_bus3
+ slot9_wrapper_0/analog_bus2 slot9_wrapper_0/analog_bus1 slot9_wrapper_0/analog_bus0
+ vss3v3 slot9_wrapper_0/vdd_1v2 vss3v3 slot9_wrapper_0/vdd_3v3 slot9_wrapper_0/enable
+ slot9_wrapper_0/clk slot9_wrapper_0/reset slot9_wrapper
Xproject_control_area_10 slot15_wrapper_0/dig_in[20] analog_switch_array_7[3]/analog_switch_med_1/enable
+ analog_switch_array_7[3]/analog_switch_med_0/enable slot15_wrapper_0/dig_out[7]
+ housekeeping_top_0/proj_sel[2] project_control_area_8/user_project_control_0/dig_out[0]
+ slot15_wrapper_0/dig_in[2] slot15_wrapper_0/dig_in[21] housekeeping_top_0/dbus_out[22]
+ slot15_wrapper_0/dig_out[8] housekeeping_top_0/proj_sel[1] slot15_wrapper_0/dig_in[3]
+ slot15_wrapper_0/dig_in[22] slot15_wrapper_0/dig_out[9] housekeeping_top_0/analog_bus_ena[2]
+ slot15_wrapper_0/analog_bus3 slot15_wrapper_0/dig_in[4] analog_switch_array_7[3]/analog_switch_med_2/enable
+ slot15_wrapper_0/dig_in[23] project_control_area_10/user_project_control_0/dig_out[3]
+ project_control_area_10/user_project_control_0/dig_out[11] project_control_area_10/user_project_control_0/dig_out[4]
+ slot15_wrapper_0/analog_bus2 slot15_wrapper_0/dig_in[5] housekeeping_top_0/analog_bus_ena[1]
+ slot15_wrapper_0/analog_bus1 housekeeping_top_0/dbus_out[5] slot15_wrapper_0/dig_in[6]
+ housekeeping_top_0/dbus_out[21] housekeeping_top_0/dbus_out[9] project_control_area_10/user_project_control_0/dig_out[8]
+ slot15_wrapper_0/analog_bus0 project_control_area_10/user_project_control_0/dig_out[9]
+ slot15_wrapper_0/dig_in[7] project_control_area_8/user_project_control_0/dig_out[11]
+ slot15_wrapper_0/dig_in[8] analog_switch_array_7[3]/analog_pswitch_small_3/enable
+ housekeeping_top_0/proj_sel[0] housekeeping_top_0/dbus_out[1] slot15_wrapper_0/dig_in[9]
+ housekeeping_top_0/dbus_out[17] housekeeping_top_0/dbus_out[2] vdd1v2_uq2 slot15_wrapper_0/dig_out[10]
+ housekeeping_top_0/proj_dig_ena slot15_wrapper_0/dig_out[11] housekeeping_top_0/dbus_out[10]
+ vdd1v2_uq2 vdd1v2_uq2 project_control_area_10/user_project_control_0/dig_out[5]
+ housekeeping_top_0/proj_ibias_ena[1] housekeeping_top_0/dbus_out[23] slot15_wrapper_0/ibias1
+ project_control_area_10/user_project_control_0/dig_out[10] slot15_wrapper_0/vdd_3v3
+ housekeeping_top_0/dbus_out[6] slot15_wrapper_0/ibias0 slot15_wrapper_0/dig_in[10]
+ project_control_area_8/user_project_control_0/dig_out[2] housekeeping_top_0/proj_vbias_ena
+ slot15_wrapper_0/dig_in[11] vdd3v3 slot15_wrapper_0/enable project_control_area_8/user_project_control_0/dig_out[1]
+ project_control_area_8/user_project_control_0/dig_out[3] slot15_wrapper_0/dig_in[12]
+ slot15_wrapper_0/dig_in[13] housekeeping_top_0/proj_3v3_ena project_control_area_8/user_project_control_0/dig_out[4]
+ slot15_wrapper_0/vbias slot15_wrapper_0/dig_in[14] housekeeping_top_0/analog_bus_ena[3]
+ housekeeping_top_0/proj_ibias_ena[0] project_control_area_8/user_project_control_0/dig_out[5]
+ slot15_wrapper_0/dig_in[15] housekeeping_top_0/dbus_out[20] vdd1v2_uq2 housekeeping_top_0/dbus_out[19]
+ slot15_wrapper_0/dig_in[16] project_control_area_8/user_project_control_0/dig_out[6]
+ housekeeping_top_0/proj_sel[4] project_control_area_10/user_project_control_0/dig_out[6]
+ vss3v3 housekeeping_top_0/reset housekeeping_top_0/dbus_out[12] slot15_wrapper_0/dig_in[17]
+ housekeeping_top_0/analog_bus_ena[0] housekeeping_top_0/proj_1v2_ena slot15_wrapper_0/dig_in[18]
+ housekeeping_top_0/proj_ena slot15_wrapper_0/dig_in[19] vdd1v2_uq2 project_control_area_8/user_project_control_0/dig_out[9]
+ vdd3v3 housekeeping_top_0/dbus_out[14] analog_switch_array_7[3]/analog_pswitch_small_2/enable
+ project_control_area_8/user_project_control_0/dig_out[10] housekeeping_top_0/dbus_out[16]
+ housekeeping_top_0/dbus_out[18] slot15_wrapper_0/dig_out[0] housekeeping_top_0/clk_out
+ slot15_wrapper_0/reset slot15_wrapper_0/dig_out[1] project_control_area_10/user_project_control_0/dig_out[2]
+ housekeeping_top_0/dbus_out[0] slot15_wrapper_0/dig_out[2] project_control_area_10/user_project_control_0/dig_out[7]
+ project_control_area_10/user_project_control_0/dig_out[0] slot15_wrapper_0/clk project_control_area_10/user_project_control_0/dig_out[1]
+ housekeeping_top_0/dbus_out[7] slot15_wrapper_0/dig_out[3] housekeeping_top_0/dbus_out[8]
+ housekeeping_top_0/dbus_out[11] project_control_area_8/user_project_control_0/dig_out[7]
+ slot15_wrapper_0/dig_out[4] housekeeping_top_0/dbus_out[3] analog_switch_array_7[3]/analog_switch_small_1/enable
+ housekeeping_top_0/proj_sel[3] slot15_wrapper_0/dig_out[5] project_control_area_8/user_project_control_0/dig_out[8]
+ housekeeping_top_0/dbus_out[4] slot15_wrapper_0/dig_in[0] housekeeping_top_0/dbus_out[15]
+ vss3v3 analog_switch_array_7[3]/analog_switch_med_3/enable housekeeping_top_0/dbus_out[13]
+ slot15_wrapper_0/dig_out[6] vss3v3 slot15_wrapper_0/vdd_1v2 vdd1v2_uq2 vss3v3 slot15_wrapper_0/dig_in[1]
+ project_control_area
Xslot13_wrapper_0 s13_an[0] s13_an[1] s13_an_0_esd s13_an_1_esd slot13_wrapper_0/vbias
+ slot13_wrapper_0/dig_in[23] slot13_wrapper_0/dig_in[22] slot13_wrapper_0/dig_in[21]
+ slot13_wrapper_0/dig_in[20] slot13_wrapper_0/dig_in[19] slot13_wrapper_0/dig_in[18]
+ slot13_wrapper_0/dig_in[17] slot13_wrapper_0/dig_in[16] slot13_wrapper_0/dig_in[15]
+ slot13_wrapper_0/dig_in[14] slot13_wrapper_0/dig_in[13] slot13_wrapper_0/dig_in[12]
+ slot13_wrapper_0/dig_in[11] slot13_wrapper_0/dig_in[10] slot13_wrapper_0/dig_in[9]
+ slot13_wrapper_0/dig_in[8] slot13_wrapper_0/dig_in[7] slot13_wrapper_0/dig_in[6]
+ slot13_wrapper_0/dig_in[5] slot13_wrapper_0/dig_in[4] slot13_wrapper_0/dig_in[3]
+ slot13_wrapper_0/dig_in[2] slot13_wrapper_0/dig_in[1] slot13_wrapper_0/dig_in[0]
+ slot13_wrapper_0/dig_out[11] slot13_wrapper_0/dig_out[10] slot13_wrapper_0/dig_out[9]
+ slot13_wrapper_0/dig_out[8] slot13_wrapper_0/dig_out[7] slot13_wrapper_0/dig_out[6]
+ slot13_wrapper_0/dig_out[5] slot13_wrapper_0/dig_out[4] slot13_wrapper_0/dig_out[3]
+ slot13_wrapper_0/dig_out[2] slot13_wrapper_0/dig_out[1] slot13_wrapper_0/dig_out[0]
+ slot13_wrapper_0/ibias0 slot13_wrapper_0/ibias1 slot13_wrapper_0/analog_bus3 slot13_wrapper_0/analog_bus2
+ slot13_wrapper_0/analog_bus1 slot13_wrapper_0/analog_bus0 vss3v3 slot13_wrapper_0/vdd_1v2
+ vss3v3 slot13_wrapper_0/vdd_3v3 slot13_wrapper_0/enable slot13_wrapper_0/clk slot13_wrapper_0/reset
+ slot13_wrapper
Xproject_control_area_11 slot4_wrapper_0/dig_in[20] analog_switch_array_7[3]/analog_switch_med_18/enable
+ analog_switch_array_7[3]/analog_switch_med_17/enable slot4_wrapper_0/dig_out[7]
+ housekeeping_top_0/proj_sel[2] project_control_area_9/user_project_control_0/dig_out[0]
+ slot4_wrapper_0/dig_in[2] slot4_wrapper_0/dig_in[21] housekeeping_top_0/dbus_out[22]
+ slot4_wrapper_0/dig_out[8] housekeeping_top_0/proj_sel[1] slot4_wrapper_0/dig_in[3]
+ slot4_wrapper_0/dig_in[22] slot4_wrapper_0/dig_out[9] housekeeping_top_0/analog_bus_ena[2]
+ slot4_wrapper_0/analog_bus3 slot4_wrapper_0/dig_in[4] analog_switch_array_7[3]/analog_switch_med_20/enable
+ slot4_wrapper_0/dig_in[23] project_control_area_11/user_project_control_0/dig_out[3]
+ project_control_area_11/user_project_control_0/dig_out[11] project_control_area_11/user_project_control_0/dig_out[4]
+ slot4_wrapper_0/analog_bus2 slot4_wrapper_0/dig_in[5] housekeeping_top_0/analog_bus_ena[1]
+ slot4_wrapper_0/analog_bus1 housekeeping_top_0/dbus_out[5] slot4_wrapper_0/dig_in[6]
+ housekeeping_top_0/dbus_out[21] housekeeping_top_0/dbus_out[9] project_control_area_11/user_project_control_0/dig_out[8]
+ slot4_wrapper_0/analog_bus0 project_control_area_11/user_project_control_0/dig_out[9]
+ slot4_wrapper_0/dig_in[7] project_control_area_9/user_project_control_0/dig_out[11]
+ slot4_wrapper_0/dig_in[8] analog_switch_array_7[3]/analog_pswitch_small_0/enable
+ housekeeping_top_0/proj_sel[0] housekeeping_top_0/dbus_out[1] slot4_wrapper_0/dig_in[9]
+ housekeeping_top_0/dbus_out[17] housekeeping_top_0/dbus_out[2] vss3v3 slot4_wrapper_0/dig_out[10]
+ housekeeping_top_0/proj_dig_ena slot4_wrapper_0/dig_out[11] housekeeping_top_0/dbus_out[10]
+ vss3v3 vss3v3 project_control_area_11/user_project_control_0/dig_out[5] housekeeping_top_0/proj_ibias_ena[1]
+ housekeeping_top_0/dbus_out[23] slot4_wrapper_0/ibias1 project_control_area_11/user_project_control_0/dig_out[10]
+ slot4_wrapper_0/vdd_3v3 housekeeping_top_0/dbus_out[6] slot4_wrapper_0/ibias0 slot4_wrapper_0/dig_in[10]
+ project_control_area_9/user_project_control_0/dig_out[2] housekeeping_top_0/proj_vbias_ena
+ slot4_wrapper_0/dig_in[11] vdd3v3 slot4_wrapper_0/enable project_control_area_9/user_project_control_0/dig_out[1]
+ project_control_area_9/user_project_control_0/dig_out[3] slot4_wrapper_0/dig_in[12]
+ slot4_wrapper_0/dig_in[13] housekeeping_top_0/proj_3v3_ena project_control_area_9/user_project_control_0/dig_out[4]
+ slot4_wrapper_0/vbias slot4_wrapper_0/dig_in[14] housekeeping_top_0/analog_bus_ena[3]
+ housekeeping_top_0/proj_ibias_ena[0] project_control_area_9/user_project_control_0/dig_out[5]
+ slot4_wrapper_0/dig_in[15] housekeeping_top_0/dbus_out[20] vdd1v2_uq2 housekeeping_top_0/dbus_out[19]
+ slot4_wrapper_0/dig_in[16] project_control_area_9/user_project_control_0/dig_out[6]
+ housekeeping_top_0/proj_sel[4] project_control_area_11/user_project_control_0/dig_out[6]
+ vss3v3 housekeeping_top_0/reset housekeeping_top_0/dbus_out[12] slot4_wrapper_0/dig_in[17]
+ housekeeping_top_0/analog_bus_ena[0] housekeeping_top_0/proj_1v2_ena slot4_wrapper_0/dig_in[18]
+ housekeeping_top_0/proj_ena slot4_wrapper_0/dig_in[19] vdd1v2_uq2 project_control_area_9/user_project_control_0/dig_out[9]
+ vdd3v3 housekeeping_top_0/dbus_out[14] analog_switch_array_7[3]/analog_pswitch_small_1/enable
+ project_control_area_9/user_project_control_0/dig_out[10] housekeeping_top_0/dbus_out[16]
+ housekeeping_top_0/dbus_out[18] slot4_wrapper_0/dig_out[0] housekeeping_top_0/clk_out
+ slot4_wrapper_0/reset slot4_wrapper_0/dig_out[1] project_control_area_11/user_project_control_0/dig_out[2]
+ housekeeping_top_0/dbus_out[0] slot4_wrapper_0/dig_out[2] project_control_area_11/user_project_control_0/dig_out[7]
+ project_control_area_11/user_project_control_0/dig_out[0] slot4_wrapper_0/clk project_control_area_11/user_project_control_0/dig_out[1]
+ housekeeping_top_0/dbus_out[7] slot4_wrapper_0/dig_out[3] housekeeping_top_0/dbus_out[8]
+ housekeeping_top_0/dbus_out[11] project_control_area_9/user_project_control_0/dig_out[7]
+ slot4_wrapper_0/dig_out[4] housekeeping_top_0/dbus_out[3] analog_switch_array_7[3]/analog_switch_small_0/enable
+ housekeeping_top_0/proj_sel[3] slot4_wrapper_0/dig_out[5] project_control_area_9/user_project_control_0/dig_out[8]
+ housekeeping_top_0/dbus_out[4] slot4_wrapper_0/dig_in[0] housekeeping_top_0/dbus_out[15]
+ vss3v3 analog_switch_array_7[3]/analog_switch_med_22/enable housekeeping_top_0/dbus_out[13]
+ slot4_wrapper_0/dig_out[6] vss3v3 slot4_wrapper_0/vdd_1v2 vdd1v2_uq2 vss3v3 slot4_wrapper_0/dig_in[1]
+ project_control_area
Xproject_control_area_12 slot16_wrapper_0/dig_in[20] analog_switch_array_7[2]/analog_switch_med_1/enable
+ analog_switch_array_7[2]/analog_switch_med_0/enable slot16_wrapper_0/dig_out[7]
+ housekeeping_top_0/proj_sel[2] project_control_area_10/user_project_control_0/dig_out[0]
+ slot16_wrapper_0/dig_in[2] slot16_wrapper_0/dig_in[21] housekeeping_top_0/dbus_out[22]
+ slot16_wrapper_0/dig_out[8] housekeeping_top_0/proj_sel[1] slot16_wrapper_0/dig_in[3]
+ slot16_wrapper_0/dig_in[22] slot16_wrapper_0/dig_out[9] housekeeping_top_0/analog_bus_ena[2]
+ slot16_wrapper_0/analog_bus3 slot16_wrapper_0/dig_in[4] analog_switch_array_7[2]/analog_switch_med_2/enable
+ slot16_wrapper_0/dig_in[23] project_control_area_12/user_project_control_0/dig_out[3]
+ project_control_area_12/user_project_control_0/dig_out[11] project_control_area_12/user_project_control_0/dig_out[4]
+ slot16_wrapper_0/analog_bus2 slot16_wrapper_0/dig_in[5] housekeeping_top_0/analog_bus_ena[1]
+ slot16_wrapper_0/analog_bus1 housekeeping_top_0/dbus_out[5] slot16_wrapper_0/dig_in[6]
+ housekeeping_top_0/dbus_out[21] housekeeping_top_0/dbus_out[9] project_control_area_12/user_project_control_0/dig_out[8]
+ slot16_wrapper_0/analog_bus0 project_control_area_12/user_project_control_0/dig_out[9]
+ slot16_wrapper_0/dig_in[7] project_control_area_10/user_project_control_0/dig_out[11]
+ slot16_wrapper_0/dig_in[8] analog_switch_array_7[2]/analog_pswitch_small_3/enable
+ housekeeping_top_0/proj_sel[0] housekeeping_top_0/dbus_out[1] slot16_wrapper_0/dig_in[9]
+ housekeeping_top_0/dbus_out[17] housekeeping_top_0/dbus_out[2] vss3v3 slot16_wrapper_0/dig_out[10]
+ housekeeping_top_0/proj_dig_ena slot16_wrapper_0/dig_out[11] housekeeping_top_0/dbus_out[10]
+ vss3v3 vss3v3 project_control_area_12/user_project_control_0/dig_out[5] housekeeping_top_0/proj_ibias_ena[1]
+ housekeeping_top_0/dbus_out[23] slot16_wrapper_0/ibias1 project_control_area_12/user_project_control_0/dig_out[10]
+ slot16_wrapper_0/vdd_3v3 housekeeping_top_0/dbus_out[6] slot16_wrapper_0/ibias0
+ slot16_wrapper_0/dig_in[10] project_control_area_10/user_project_control_0/dig_out[2]
+ housekeeping_top_0/proj_vbias_ena slot16_wrapper_0/dig_in[11] vdd3v3 slot16_wrapper_0/enable
+ project_control_area_10/user_project_control_0/dig_out[1] project_control_area_10/user_project_control_0/dig_out[3]
+ slot16_wrapper_0/dig_in[12] slot16_wrapper_0/dig_in[13] housekeeping_top_0/proj_3v3_ena
+ project_control_area_10/user_project_control_0/dig_out[4] slot16_wrapper_0/vbias
+ slot16_wrapper_0/dig_in[14] housekeeping_top_0/analog_bus_ena[3] housekeeping_top_0/proj_ibias_ena[0]
+ project_control_area_10/user_project_control_0/dig_out[5] slot16_wrapper_0/dig_in[15]
+ housekeeping_top_0/dbus_out[20] vdd1v2_uq2 housekeeping_top_0/dbus_out[19] slot16_wrapper_0/dig_in[16]
+ project_control_area_10/user_project_control_0/dig_out[6] housekeeping_top_0/proj_sel[4]
+ project_control_area_12/user_project_control_0/dig_out[6] vss3v3 housekeeping_top_0/reset
+ housekeeping_top_0/dbus_out[12] slot16_wrapper_0/dig_in[17] housekeeping_top_0/analog_bus_ena[0]
+ housekeeping_top_0/proj_1v2_ena slot16_wrapper_0/dig_in[18] housekeeping_top_0/proj_ena
+ slot16_wrapper_0/dig_in[19] vdd1v2_uq2 project_control_area_10/user_project_control_0/dig_out[9]
+ vdd3v3 housekeeping_top_0/dbus_out[14] analog_switch_array_7[2]/analog_pswitch_small_2/enable
+ project_control_area_10/user_project_control_0/dig_out[10] housekeeping_top_0/dbus_out[16]
+ housekeeping_top_0/dbus_out[18] slot16_wrapper_0/dig_out[0] housekeeping_top_0/clk_out
+ slot16_wrapper_0/reset slot16_wrapper_0/dig_out[1] project_control_area_12/user_project_control_0/dig_out[2]
+ housekeeping_top_0/dbus_out[0] slot16_wrapper_0/dig_out[2] project_control_area_12/user_project_control_0/dig_out[7]
+ project_control_area_12/user_project_control_0/dig_out[0] slot16_wrapper_0/clk project_control_area_12/user_project_control_0/dig_out[1]
+ housekeeping_top_0/dbus_out[7] slot16_wrapper_0/dig_out[3] housekeeping_top_0/dbus_out[8]
+ housekeeping_top_0/dbus_out[11] project_control_area_10/user_project_control_0/dig_out[7]
+ slot16_wrapper_0/dig_out[4] housekeeping_top_0/dbus_out[3] analog_switch_array_7[2]/analog_switch_small_1/enable
+ housekeeping_top_0/proj_sel[3] slot16_wrapper_0/dig_out[5] project_control_area_10/user_project_control_0/dig_out[8]
+ housekeeping_top_0/dbus_out[4] slot16_wrapper_0/dig_in[0] housekeeping_top_0/dbus_out[15]
+ vdd1v2_uq2 analog_switch_array_7[2]/analog_switch_med_3/enable housekeeping_top_0/dbus_out[13]
+ slot16_wrapper_0/dig_out[6] vss3v3 slot16_wrapper_0/vdd_1v2 vss3v3 vss3v3 slot16_wrapper_0/dig_in[1]
+ project_control_area
Xslot17_wrapper_0 s17_an[0] s17_an[1] s17_an_0_esd s17_an_1_esd slot17_wrapper_0/vbias
+ slot17_wrapper_0/dig_in[23] slot17_wrapper_0/dig_in[22] slot17_wrapper_0/dig_in[21]
+ slot17_wrapper_0/dig_in[20] slot17_wrapper_0/dig_in[19] slot17_wrapper_0/dig_in[18]
+ slot17_wrapper_0/dig_in[17] slot17_wrapper_0/dig_in[16] slot17_wrapper_0/dig_in[15]
+ slot17_wrapper_0/dig_in[14] slot17_wrapper_0/dig_in[13] slot17_wrapper_0/dig_in[12]
+ slot17_wrapper_0/dig_in[11] slot17_wrapper_0/dig_in[10] slot17_wrapper_0/dig_in[9]
+ slot17_wrapper_0/dig_in[8] slot17_wrapper_0/dig_in[7] slot17_wrapper_0/dig_in[6]
+ slot17_wrapper_0/dig_in[5] slot17_wrapper_0/dig_in[4] slot17_wrapper_0/dig_in[3]
+ slot17_wrapper_0/dig_in[2] slot17_wrapper_0/dig_in[1] slot17_wrapper_0/dig_in[0]
+ slot17_wrapper_0/dig_out[11] slot17_wrapper_0/dig_out[10] slot17_wrapper_0/dig_out[9]
+ slot17_wrapper_0/dig_out[8] slot17_wrapper_0/dig_out[7] slot17_wrapper_0/dig_out[6]
+ slot17_wrapper_0/dig_out[5] slot17_wrapper_0/dig_out[4] slot17_wrapper_0/dig_out[3]
+ slot17_wrapper_0/dig_out[2] slot17_wrapper_0/dig_out[1] slot17_wrapper_0/dig_out[0]
+ slot17_wrapper_0/ibias0 slot17_wrapper_0/ibias1 slot17_wrapper_0/analog_bus3 slot17_wrapper_0/analog_bus2
+ slot17_wrapper_0/analog_bus1 slot17_wrapper_0/analog_bus0 vss3v3 slot17_wrapper_0/vdd_1v2
+ vss3v3 slot17_wrapper_0/vdd_3v3 slot17_wrapper_0/enable slot17_wrapper_0/clk slot17_wrapper_0/reset
+ slot17_wrapper
Xanalog_switch_small_0 analog_switch_small_0/in analog[3] vss3v3 analog_switch_small_1/enable
+ vdd3v3 vdd1v2_uq2 vss3v3 analog_switch_small
Xproject_control_area_13 slot3_wrapper_0/dig_in[20] analog_switch_array_7[2]/analog_switch_med_18/enable
+ analog_switch_array_7[2]/analog_switch_med_17/enable slot3_wrapper_0/dig_out[7]
+ housekeeping_top_0/proj_sel[2] project_control_area_11/user_project_control_0/dig_out[0]
+ slot3_wrapper_0/dig_in[2] slot3_wrapper_0/dig_in[21] housekeeping_top_0/dbus_out[22]
+ slot3_wrapper_0/dig_out[8] housekeeping_top_0/proj_sel[1] slot3_wrapper_0/dig_in[3]
+ slot3_wrapper_0/dig_in[22] slot3_wrapper_0/dig_out[9] housekeeping_top_0/analog_bus_ena[2]
+ slot3_wrapper_0/analog_bus3 slot3_wrapper_0/dig_in[4] analog_switch_array_7[2]/analog_switch_med_20/enable
+ slot3_wrapper_0/dig_in[23] project_control_area_13/user_project_control_0/dig_out[3]
+ project_control_area_13/user_project_control_0/dig_out[11] project_control_area_13/user_project_control_0/dig_out[4]
+ slot3_wrapper_0/analog_bus2 slot3_wrapper_0/dig_in[5] housekeeping_top_0/analog_bus_ena[1]
+ slot3_wrapper_0/analog_bus1 housekeeping_top_0/dbus_out[5] slot3_wrapper_0/dig_in[6]
+ housekeeping_top_0/dbus_out[21] housekeeping_top_0/dbus_out[9] project_control_area_13/user_project_control_0/dig_out[8]
+ slot3_wrapper_0/analog_bus0 project_control_area_13/user_project_control_0/dig_out[9]
+ slot3_wrapper_0/dig_in[7] project_control_area_11/user_project_control_0/dig_out[11]
+ slot3_wrapper_0/dig_in[8] analog_switch_array_7[2]/analog_pswitch_small_0/enable
+ housekeeping_top_0/proj_sel[0] housekeeping_top_0/dbus_out[1] slot3_wrapper_0/dig_in[9]
+ housekeeping_top_0/dbus_out[17] housekeeping_top_0/dbus_out[2] vdd1v2_uq2 slot3_wrapper_0/dig_out[10]
+ housekeeping_top_0/proj_dig_ena slot3_wrapper_0/dig_out[11] housekeeping_top_0/dbus_out[10]
+ vdd1v2_uq2 vss3v3 project_control_area_13/user_project_control_0/dig_out[5] housekeeping_top_0/proj_ibias_ena[1]
+ housekeeping_top_0/dbus_out[23] slot3_wrapper_0/ibias1 project_control_area_13/user_project_control_0/dig_out[10]
+ slot3_wrapper_0/vdd_3v3 housekeeping_top_0/dbus_out[6] slot3_wrapper_0/ibias0 slot3_wrapper_0/dig_in[10]
+ project_control_area_11/user_project_control_0/dig_out[2] housekeeping_top_0/proj_vbias_ena
+ slot3_wrapper_0/dig_in[11] vdd3v3 slot3_wrapper_0/enable project_control_area_11/user_project_control_0/dig_out[1]
+ project_control_area_11/user_project_control_0/dig_out[3] slot3_wrapper_0/dig_in[12]
+ slot3_wrapper_0/dig_in[13] housekeeping_top_0/proj_3v3_ena project_control_area_11/user_project_control_0/dig_out[4]
+ slot3_wrapper_0/vbias slot3_wrapper_0/dig_in[14] housekeeping_top_0/analog_bus_ena[3]
+ housekeeping_top_0/proj_ibias_ena[0] project_control_area_11/user_project_control_0/dig_out[5]
+ slot3_wrapper_0/dig_in[15] housekeeping_top_0/dbus_out[20] vdd1v2_uq2 housekeeping_top_0/dbus_out[19]
+ slot3_wrapper_0/dig_in[16] project_control_area_11/user_project_control_0/dig_out[6]
+ housekeeping_top_0/proj_sel[4] project_control_area_13/user_project_control_0/dig_out[6]
+ vss3v3 housekeeping_top_0/reset housekeeping_top_0/dbus_out[12] slot3_wrapper_0/dig_in[17]
+ housekeeping_top_0/analog_bus_ena[0] housekeeping_top_0/proj_1v2_ena slot3_wrapper_0/dig_in[18]
+ housekeeping_top_0/proj_ena slot3_wrapper_0/dig_in[19] vdd1v2_uq2 project_control_area_11/user_project_control_0/dig_out[9]
+ vdd3v3 housekeeping_top_0/dbus_out[14] analog_switch_array_7[2]/analog_pswitch_small_1/enable
+ project_control_area_11/user_project_control_0/dig_out[10] housekeeping_top_0/dbus_out[16]
+ housekeeping_top_0/dbus_out[18] slot3_wrapper_0/dig_out[0] housekeeping_top_0/clk_out
+ slot3_wrapper_0/reset slot3_wrapper_0/dig_out[1] project_control_area_13/user_project_control_0/dig_out[2]
+ housekeeping_top_0/dbus_out[0] slot3_wrapper_0/dig_out[2] project_control_area_13/user_project_control_0/dig_out[7]
+ project_control_area_13/user_project_control_0/dig_out[0] slot3_wrapper_0/clk project_control_area_13/user_project_control_0/dig_out[1]
+ housekeeping_top_0/dbus_out[7] slot3_wrapper_0/dig_out[3] housekeeping_top_0/dbus_out[8]
+ housekeeping_top_0/dbus_out[11] project_control_area_11/user_project_control_0/dig_out[7]
+ slot3_wrapper_0/dig_out[4] housekeeping_top_0/dbus_out[3] analog_switch_array_7[2]/analog_switch_small_0/enable
+ housekeeping_top_0/proj_sel[3] slot3_wrapper_0/dig_out[5] project_control_area_11/user_project_control_0/dig_out[8]
+ housekeeping_top_0/dbus_out[4] slot3_wrapper_0/dig_in[0] housekeeping_top_0/dbus_out[15]
+ vss3v3 analog_switch_array_7[2]/analog_switch_med_22/enable housekeeping_top_0/dbus_out[13]
+ slot3_wrapper_0/dig_out[6] vss3v3 slot3_wrapper_0/vdd_1v2 vss3v3 vss3v3 slot3_wrapper_0/dig_in[1]
+ project_control_area
Xanalog_switch_small_1 analog_switch_small_1/in analog[0] vss3v3 analog_switch_small_1/enable
+ vdd3v3 vdd1v2_uq2 vss3v3 analog_switch_small
Xslot4_wrapper_0 s4_an[0] vss3v3 s4_an_0_esd slot4_wrapper_0/vbias slot4_wrapper_0/dig_in[23]
+ slot4_wrapper_0/dig_in[22] slot4_wrapper_0/dig_in[21] slot4_wrapper_0/dig_in[20]
+ slot4_wrapper_0/dig_in[19] slot4_wrapper_0/dig_in[18] slot4_wrapper_0/dig_in[17]
+ slot4_wrapper_0/dig_in[16] slot4_wrapper_0/dig_in[15] slot4_wrapper_0/dig_in[14]
+ slot4_wrapper_0/dig_in[13] slot4_wrapper_0/dig_in[12] slot4_wrapper_0/dig_in[11]
+ slot4_wrapper_0/dig_in[10] slot4_wrapper_0/dig_in[9] slot4_wrapper_0/dig_in[8] slot4_wrapper_0/dig_in[7]
+ slot4_wrapper_0/dig_in[6] slot4_wrapper_0/dig_in[5] slot4_wrapper_0/dig_in[4] slot4_wrapper_0/dig_in[3]
+ slot4_wrapper_0/dig_in[2] slot4_wrapper_0/dig_in[1] slot4_wrapper_0/dig_in[0] slot4_wrapper_0/dig_out[11]
+ slot4_wrapper_0/dig_out[10] slot4_wrapper_0/dig_out[9] slot4_wrapper_0/dig_out[8]
+ slot4_wrapper_0/dig_out[7] slot4_wrapper_0/dig_out[6] slot4_wrapper_0/dig_out[5]
+ slot4_wrapper_0/dig_out[4] slot4_wrapper_0/dig_out[3] slot4_wrapper_0/dig_out[2]
+ slot4_wrapper_0/dig_out[1] slot4_wrapper_0/dig_out[0] slot4_wrapper_0/ibias0 slot4_wrapper_0/ibias1
+ slot4_wrapper_0/analog_bus3 slot4_wrapper_0/analog_bus2 slot4_wrapper_0/analog_bus1
+ slot4_wrapper_0/analog_bus0 slot4_wrapper_0/vdd_1v2 vss3v3 slot4_wrapper_0/vdd_3v3
+ slot4_wrapper_0/enable slot4_wrapper_0/clk slot4_wrapper_0/reset slot4_wrapper
Xproject_control_area_14 slot17_wrapper_0/dig_in[20] analog_switch_array_7[1]/analog_switch_med_1/enable
+ analog_switch_array_7[1]/analog_switch_med_0/enable slot17_wrapper_0/dig_out[7]
+ housekeeping_top_0/proj_sel[2] project_control_area_12/user_project_control_0/dig_out[0]
+ slot17_wrapper_0/dig_in[2] slot17_wrapper_0/dig_in[21] housekeeping_top_0/dbus_out[22]
+ slot17_wrapper_0/dig_out[8] housekeeping_top_0/proj_sel[1] slot17_wrapper_0/dig_in[3]
+ slot17_wrapper_0/dig_in[22] slot17_wrapper_0/dig_out[9] housekeeping_top_0/analog_bus_ena[2]
+ slot17_wrapper_0/analog_bus3 slot17_wrapper_0/dig_in[4] analog_switch_array_7[1]/analog_switch_med_2/enable
+ slot17_wrapper_0/dig_in[23] project_control_area_14/user_project_control_0/dig_out[3]
+ project_control_area_14/user_project_control_0/dig_out[11] project_control_area_14/user_project_control_0/dig_out[4]
+ slot17_wrapper_0/analog_bus2 slot17_wrapper_0/dig_in[5] housekeeping_top_0/analog_bus_ena[1]
+ slot17_wrapper_0/analog_bus1 housekeeping_top_0/dbus_out[5] slot17_wrapper_0/dig_in[6]
+ housekeeping_top_0/dbus_out[21] housekeeping_top_0/dbus_out[9] project_control_area_14/user_project_control_0/dig_out[8]
+ slot17_wrapper_0/analog_bus0 project_control_area_14/user_project_control_0/dig_out[9]
+ slot17_wrapper_0/dig_in[7] project_control_area_12/user_project_control_0/dig_out[11]
+ slot17_wrapper_0/dig_in[8] analog_switch_array_7[1]/analog_pswitch_small_3/enable
+ housekeeping_top_0/proj_sel[0] housekeeping_top_0/dbus_out[1] slot17_wrapper_0/dig_in[9]
+ housekeeping_top_0/dbus_out[17] housekeeping_top_0/dbus_out[2] vdd1v2_uq2 slot17_wrapper_0/dig_out[10]
+ housekeeping_top_0/proj_dig_ena slot17_wrapper_0/dig_out[11] housekeeping_top_0/dbus_out[10]
+ vss3v3 vss3v3 project_control_area_14/user_project_control_0/dig_out[5] housekeeping_top_0/proj_ibias_ena[1]
+ housekeeping_top_0/dbus_out[23] slot17_wrapper_0/ibias1 project_control_area_14/user_project_control_0/dig_out[10]
+ slot17_wrapper_0/vdd_3v3 housekeeping_top_0/dbus_out[6] slot17_wrapper_0/ibias0
+ slot17_wrapper_0/dig_in[10] project_control_area_12/user_project_control_0/dig_out[2]
+ housekeeping_top_0/proj_vbias_ena slot17_wrapper_0/dig_in[11] vdd3v3 slot17_wrapper_0/enable
+ project_control_area_12/user_project_control_0/dig_out[1] project_control_area_12/user_project_control_0/dig_out[3]
+ slot17_wrapper_0/dig_in[12] slot17_wrapper_0/dig_in[13] housekeeping_top_0/proj_3v3_ena
+ project_control_area_12/user_project_control_0/dig_out[4] slot17_wrapper_0/vbias
+ slot17_wrapper_0/dig_in[14] housekeeping_top_0/analog_bus_ena[3] housekeeping_top_0/proj_ibias_ena[0]
+ project_control_area_12/user_project_control_0/dig_out[5] slot17_wrapper_0/dig_in[15]
+ housekeeping_top_0/dbus_out[20] vdd1v2_uq2 housekeeping_top_0/dbus_out[19] slot17_wrapper_0/dig_in[16]
+ project_control_area_12/user_project_control_0/dig_out[6] housekeeping_top_0/proj_sel[4]
+ project_control_area_14/user_project_control_0/dig_out[6] vss3v3 housekeeping_top_0/reset
+ housekeeping_top_0/dbus_out[12] slot17_wrapper_0/dig_in[17] housekeeping_top_0/analog_bus_ena[0]
+ housekeeping_top_0/proj_1v2_ena slot17_wrapper_0/dig_in[18] housekeeping_top_0/proj_ena
+ slot17_wrapper_0/dig_in[19] vdd1v2_uq2 project_control_area_12/user_project_control_0/dig_out[9]
+ vdd3v3 housekeeping_top_0/dbus_out[14] analog_switch_array_7[1]/analog_pswitch_small_2/enable
+ project_control_area_12/user_project_control_0/dig_out[10] housekeeping_top_0/dbus_out[16]
+ housekeeping_top_0/dbus_out[18] slot17_wrapper_0/dig_out[0] housekeeping_top_0/clk_out
+ slot17_wrapper_0/reset slot17_wrapper_0/dig_out[1] project_control_area_14/user_project_control_0/dig_out[2]
+ housekeeping_top_0/dbus_out[0] slot17_wrapper_0/dig_out[2] project_control_area_14/user_project_control_0/dig_out[7]
+ project_control_area_14/user_project_control_0/dig_out[0] slot17_wrapper_0/clk project_control_area_14/user_project_control_0/dig_out[1]
+ housekeeping_top_0/dbus_out[7] slot17_wrapper_0/dig_out[3] housekeeping_top_0/dbus_out[8]
+ housekeeping_top_0/dbus_out[11] project_control_area_12/user_project_control_0/dig_out[7]
+ slot17_wrapper_0/dig_out[4] housekeeping_top_0/dbus_out[3] analog_switch_array_7[1]/analog_switch_small_1/enable
+ housekeeping_top_0/proj_sel[3] slot17_wrapper_0/dig_out[5] project_control_area_12/user_project_control_0/dig_out[8]
+ housekeeping_top_0/dbus_out[4] slot17_wrapper_0/dig_in[0] housekeeping_top_0/dbus_out[15]
+ vdd1v2_uq2 analog_switch_array_7[1]/analog_switch_med_3/enable housekeeping_top_0/dbus_out[13]
+ slot17_wrapper_0/dig_out[6] vss3v3 slot17_wrapper_0/vdd_1v2 vss3v3 vss3v3 slot17_wrapper_0/dig_in[1]
+ project_control_area
Xproject_control_area_15 slot2_wrapper_0/dig_in[20] analog_switch_array_7[1]/analog_switch_med_18/enable
+ analog_switch_array_7[1]/analog_switch_med_17/enable slot2_wrapper_0/dig_out[7]
+ housekeeping_top_0/proj_sel[2] project_control_area_13/user_project_control_0/dig_out[0]
+ slot2_wrapper_0/dig_in[2] slot2_wrapper_0/dig_in[21] housekeeping_top_0/dbus_out[22]
+ slot2_wrapper_0/dig_out[8] housekeeping_top_0/proj_sel[1] slot2_wrapper_0/dig_in[3]
+ slot2_wrapper_0/dig_in[22] slot2_wrapper_0/dig_out[9] housekeeping_top_0/analog_bus_ena[2]
+ slot2_wrapper_0/analog_bus3 slot2_wrapper_0/dig_in[4] analog_switch_array_7[1]/analog_switch_med_20/enable
+ slot2_wrapper_0/dig_in[23] project_control_area_15/user_project_control_0/dig_out[3]
+ project_control_area_15/user_project_control_0/dig_out[11] project_control_area_15/user_project_control_0/dig_out[4]
+ slot2_wrapper_0/analog_bus2 slot2_wrapper_0/dig_in[5] housekeeping_top_0/analog_bus_ena[1]
+ slot2_wrapper_0/analog_bus1 housekeeping_top_0/dbus_out[5] slot2_wrapper_0/dig_in[6]
+ housekeeping_top_0/dbus_out[21] housekeeping_top_0/dbus_out[9] project_control_area_15/user_project_control_0/dig_out[8]
+ slot2_wrapper_0/analog_bus0 project_control_area_15/user_project_control_0/dig_out[9]
+ slot2_wrapper_0/dig_in[7] project_control_area_13/user_project_control_0/dig_out[11]
+ slot2_wrapper_0/dig_in[8] analog_switch_array_7[1]/analog_pswitch_small_0/enable
+ housekeeping_top_0/proj_sel[0] housekeeping_top_0/dbus_out[1] slot2_wrapper_0/dig_in[9]
+ housekeeping_top_0/dbus_out[17] housekeeping_top_0/dbus_out[2] vss3v3 slot2_wrapper_0/dig_out[10]
+ housekeeping_top_0/proj_dig_ena slot2_wrapper_0/dig_out[11] housekeeping_top_0/dbus_out[10]
+ vdd1v2_uq2 vss3v3 project_control_area_15/user_project_control_0/dig_out[5] housekeeping_top_0/proj_ibias_ena[1]
+ housekeeping_top_0/dbus_out[23] slot2_wrapper_0/ibias1 project_control_area_15/user_project_control_0/dig_out[10]
+ slot2_wrapper_0/vdd_3v3 housekeeping_top_0/dbus_out[6] slot2_wrapper_0/ibias0 slot2_wrapper_0/dig_in[10]
+ project_control_area_13/user_project_control_0/dig_out[2] housekeeping_top_0/proj_vbias_ena
+ slot2_wrapper_0/dig_in[11] vdd3v3 slot2_wrapper_0/enable project_control_area_13/user_project_control_0/dig_out[1]
+ project_control_area_13/user_project_control_0/dig_out[3] slot2_wrapper_0/dig_in[12]
+ slot2_wrapper_0/dig_in[13] housekeeping_top_0/proj_3v3_ena project_control_area_13/user_project_control_0/dig_out[4]
+ slot2_wrapper_0/vbias slot2_wrapper_0/dig_in[14] housekeeping_top_0/analog_bus_ena[3]
+ housekeeping_top_0/proj_ibias_ena[0] project_control_area_13/user_project_control_0/dig_out[5]
+ slot2_wrapper_0/dig_in[15] housekeeping_top_0/dbus_out[20] vdd1v2_uq2 housekeeping_top_0/dbus_out[19]
+ slot2_wrapper_0/dig_in[16] project_control_area_13/user_project_control_0/dig_out[6]
+ housekeeping_top_0/proj_sel[4] project_control_area_15/user_project_control_0/dig_out[6]
+ vss3v3 housekeeping_top_0/reset housekeeping_top_0/dbus_out[12] slot2_wrapper_0/dig_in[17]
+ housekeeping_top_0/analog_bus_ena[0] housekeeping_top_0/proj_1v2_ena slot2_wrapper_0/dig_in[18]
+ housekeeping_top_0/proj_ena slot2_wrapper_0/dig_in[19] vdd1v2_uq2 project_control_area_13/user_project_control_0/dig_out[9]
+ vdd3v3 housekeeping_top_0/dbus_out[14] analog_switch_array_7[1]/analog_pswitch_small_1/enable
+ project_control_area_13/user_project_control_0/dig_out[10] housekeeping_top_0/dbus_out[16]
+ housekeeping_top_0/dbus_out[18] slot2_wrapper_0/dig_out[0] housekeeping_top_0/clk_out
+ slot2_wrapper_0/reset slot2_wrapper_0/dig_out[1] project_control_area_15/user_project_control_0/dig_out[2]
+ housekeeping_top_0/dbus_out[0] slot2_wrapper_0/dig_out[2] project_control_area_15/user_project_control_0/dig_out[7]
+ project_control_area_15/user_project_control_0/dig_out[0] slot2_wrapper_0/clk project_control_area_15/user_project_control_0/dig_out[1]
+ housekeeping_top_0/dbus_out[7] slot2_wrapper_0/dig_out[3] housekeeping_top_0/dbus_out[8]
+ housekeeping_top_0/dbus_out[11] project_control_area_13/user_project_control_0/dig_out[7]
+ slot2_wrapper_0/dig_out[4] housekeeping_top_0/dbus_out[3] analog_switch_array_7[1]/analog_switch_small_0/enable
+ housekeeping_top_0/proj_sel[3] slot2_wrapper_0/dig_out[5] project_control_area_13/user_project_control_0/dig_out[8]
+ housekeeping_top_0/dbus_out[4] slot2_wrapper_0/dig_in[0] housekeeping_top_0/dbus_out[15]
+ vss3v3 analog_switch_array_7[1]/analog_switch_med_22/enable housekeeping_top_0/dbus_out[13]
+ slot2_wrapper_0/dig_out[6] vss3v3 slot2_wrapper_0/vdd_1v2 vss3v3 vss3v3 slot2_wrapper_0/dig_in[1]
+ project_control_area
Xslot8_wrapper_0 vss3v3 s8_an[0] s8_an_0_esd slot8_wrapper_0/vbias slot8_wrapper_0/dig_in[23]
+ slot8_wrapper_0/dig_in[22] slot8_wrapper_0/dig_in[21] slot8_wrapper_0/dig_in[20]
+ slot8_wrapper_0/dig_in[19] slot8_wrapper_0/dig_in[18] slot8_wrapper_0/dig_in[17]
+ slot8_wrapper_0/dig_in[16] slot8_wrapper_0/dig_in[15] slot8_wrapper_0/dig_in[14]
+ slot8_wrapper_0/dig_in[13] slot8_wrapper_0/dig_in[12] slot8_wrapper_0/dig_in[11]
+ slot8_wrapper_0/dig_in[10] slot8_wrapper_0/dig_in[9] slot8_wrapper_0/dig_in[8] slot8_wrapper_0/dig_in[7]
+ slot8_wrapper_0/dig_in[6] slot8_wrapper_0/dig_in[5] slot8_wrapper_0/dig_in[4] slot8_wrapper_0/dig_in[3]
+ slot8_wrapper_0/dig_in[2] slot8_wrapper_0/dig_in[1] slot8_wrapper_0/dig_in[0] slot8_wrapper_0/dig_out[11]
+ slot8_wrapper_0/dig_out[10] slot8_wrapper_0/dig_out[9] slot8_wrapper_0/dig_out[8]
+ slot8_wrapper_0/dig_out[7] slot8_wrapper_0/dig_out[6] slot8_wrapper_0/dig_out[5]
+ slot8_wrapper_0/dig_out[4] slot8_wrapper_0/dig_out[3] slot8_wrapper_0/dig_out[2]
+ slot8_wrapper_0/dig_out[1] slot8_wrapper_0/dig_out[0] slot8_wrapper_0/ibias0 slot8_wrapper_0/ibias1
+ slot8_wrapper_0/analog_bus3 slot8_wrapper_0/analog_bus2 slot8_wrapper_0/analog_bus1
+ slot8_wrapper_0/analog_bus0 vss3v3 slot8_wrapper_0/vdd_1v2 slot8_wrapper_0/vdd_3v3
+ slot8_wrapper_0/enable slot8_wrapper_0/clk slot8_wrapper_0/reset slot8_wrapper
Xproject_control_area_16 slot18_wrapper_0/dig_in[20] analog_switch_array_7[0]/analog_switch_med_1/enable
+ analog_switch_array_7[0]/analog_switch_med_0/enable slot18_wrapper_0/dig_out[7]
+ housekeeping_top_0/proj_sel[2] project_control_area_14/user_project_control_0/dig_out[0]
+ slot18_wrapper_0/dig_in[2] slot18_wrapper_0/dig_in[21] housekeeping_top_0/dbus_out[22]
+ slot18_wrapper_0/dig_out[8] housekeeping_top_0/proj_sel[1] slot18_wrapper_0/dig_in[3]
+ slot18_wrapper_0/dig_in[22] slot18_wrapper_0/dig_out[9] housekeeping_top_0/analog_bus_ena[2]
+ slot18_wrapper_0/analog_bus3 slot18_wrapper_0/dig_in[4] analog_switch_array_7[0]/analog_switch_med_2/enable
+ slot18_wrapper_0/dig_in[23] housekeeping_top_0/dbus_in_left[3] housekeeping_top_0/dbus_in_left[11]
+ housekeeping_top_0/dbus_in_left[4] slot18_wrapper_0/analog_bus2 slot18_wrapper_0/dig_in[5]
+ housekeeping_top_0/analog_bus_ena[1] slot18_wrapper_0/analog_bus1 housekeeping_top_0/dbus_out[5]
+ slot18_wrapper_0/dig_in[6] housekeeping_top_0/dbus_out[21] housekeeping_top_0/dbus_out[9]
+ housekeeping_top_0/dbus_in_left[8] slot18_wrapper_0/analog_bus0 housekeeping_top_0/dbus_in_left[9]
+ slot18_wrapper_0/dig_in[7] project_control_area_14/user_project_control_0/dig_out[11]
+ slot18_wrapper_0/dig_in[8] analog_switch_array_7[0]/analog_pswitch_small_3/enable
+ housekeeping_top_0/proj_sel[0] housekeeping_top_0/dbus_out[1] slot18_wrapper_0/dig_in[9]
+ housekeeping_top_0/dbus_out[17] housekeeping_top_0/dbus_out[2] vss3v3 slot18_wrapper_0/dig_out[10]
+ housekeeping_top_0/proj_dig_ena slot18_wrapper_0/dig_out[11] housekeeping_top_0/dbus_out[10]
+ vdd1v2_uq2 vss3v3 housekeeping_top_0/dbus_in_left[5] housekeeping_top_0/proj_ibias_ena[1]
+ housekeeping_top_0/dbus_out[23] slot18_wrapper_0/ibias1 housekeeping_top_0/dbus_in_left[10]
+ slot18_wrapper_0/vdd_3v3 housekeeping_top_0/dbus_out[6] slot18_wrapper_0/ibias0
+ slot18_wrapper_0/dig_in[10] project_control_area_14/user_project_control_0/dig_out[2]
+ housekeeping_top_0/proj_vbias_ena slot18_wrapper_0/dig_in[11] vdd3v3 slot18_wrapper_0/enable
+ project_control_area_14/user_project_control_0/dig_out[1] project_control_area_14/user_project_control_0/dig_out[3]
+ slot18_wrapper_0/dig_in[12] slot18_wrapper_0/dig_in[13] housekeeping_top_0/proj_3v3_ena
+ project_control_area_14/user_project_control_0/dig_out[4] slot18_wrapper_0/vbias
+ slot18_wrapper_0/dig_in[14] housekeeping_top_0/analog_bus_ena[3] housekeeping_top_0/proj_ibias_ena[0]
+ project_control_area_14/user_project_control_0/dig_out[5] slot18_wrapper_0/dig_in[15]
+ housekeeping_top_0/dbus_out[20] vdd1v2_uq2 housekeeping_top_0/dbus_out[19] slot18_wrapper_0/dig_in[16]
+ project_control_area_14/user_project_control_0/dig_out[6] housekeeping_top_0/proj_sel[4]
+ housekeeping_top_0/dbus_in_left[6] vss3v3 housekeeping_top_0/reset housekeeping_top_0/dbus_out[12]
+ slot18_wrapper_0/dig_in[17] housekeeping_top_0/analog_bus_ena[0] housekeeping_top_0/proj_1v2_ena
+ slot18_wrapper_0/dig_in[18] housekeeping_top_0/proj_ena slot18_wrapper_0/dig_in[19]
+ vdd1v2_uq2 project_control_area_14/user_project_control_0/dig_out[9] vdd3v3 housekeeping_top_0/dbus_out[14]
+ analog_switch_array_7[0]/analog_pswitch_small_2/enable project_control_area_14/user_project_control_0/dig_out[10]
+ housekeeping_top_0/dbus_out[16] housekeeping_top_0/dbus_out[18] slot18_wrapper_0/dig_out[0]
+ housekeeping_top_0/clk_out slot18_wrapper_0/reset slot18_wrapper_0/dig_out[1] housekeeping_top_0/dbus_in_left[2]
+ housekeeping_top_0/dbus_out[0] slot18_wrapper_0/dig_out[2] housekeeping_top_0/dbus_in_left[7]
+ housekeeping_top_0/dbus_in_left[0] slot18_wrapper_0/clk housekeeping_top_0/dbus_in_left[1]
+ housekeeping_top_0/dbus_out[7] slot18_wrapper_0/dig_out[3] housekeeping_top_0/dbus_out[8]
+ housekeeping_top_0/dbus_out[11] project_control_area_14/user_project_control_0/dig_out[7]
+ slot18_wrapper_0/dig_out[4] housekeeping_top_0/dbus_out[3] analog_switch_array_7[0]/analog_switch_small_1/enable
+ housekeeping_top_0/proj_sel[3] slot18_wrapper_0/dig_out[5] project_control_area_14/user_project_control_0/dig_out[8]
+ housekeeping_top_0/dbus_out[4] slot18_wrapper_0/dig_in[0] housekeeping_top_0/dbus_out[15]
+ vdd1v2_uq2 analog_switch_array_7[0]/analog_switch_med_3/enable housekeeping_top_0/dbus_out[13]
+ slot18_wrapper_0/dig_out[6] vss3v3 slot18_wrapper_0/vdd_1v2 vss3v3 vss3v3 slot18_wrapper_0/dig_in[1]
+ project_control_area
Xproject_control_area_17 slot1_wrapper_0/dig_in[20] analog_switch_array_7[0]/analog_switch_med_18/enable
+ analog_switch_array_7[0]/analog_switch_med_17/enable slot1_wrapper_0/dig_out[7]
+ housekeeping_top_0/proj_sel[2] project_control_area_15/user_project_control_0/dig_out[0]
+ slot1_wrapper_0/dig_in[2] slot1_wrapper_0/dig_in[21] housekeeping_top_0/dbus_out[22]
+ slot1_wrapper_0/dig_out[8] housekeeping_top_0/proj_sel[1] slot1_wrapper_0/dig_in[3]
+ slot1_wrapper_0/dig_in[22] slot1_wrapper_0/dig_out[9] housekeeping_top_0/analog_bus_ena[2]
+ slot1_wrapper_0/analog_bus3 slot1_wrapper_0/dig_in[4] analog_switch_array_7[0]/analog_switch_med_20/enable
+ slot1_wrapper_0/dig_in[23] housekeeping_top_0/dbus_in_right[3] housekeeping_top_0/dbus_in_right[11]
+ housekeeping_top_0/dbus_in_right[4] slot1_wrapper_0/analog_bus2 slot1_wrapper_0/dig_in[5]
+ housekeeping_top_0/analog_bus_ena[1] slot1_wrapper_0/analog_bus1 housekeeping_top_0/dbus_out[5]
+ slot1_wrapper_0/dig_in[6] housekeeping_top_0/dbus_out[21] housekeeping_top_0/dbus_out[9]
+ housekeeping_top_0/dbus_in_right[8] slot1_wrapper_0/analog_bus0 housekeeping_top_0/dbus_in_right[9]
+ slot1_wrapper_0/dig_in[7] project_control_area_15/user_project_control_0/dig_out[11]
+ slot1_wrapper_0/dig_in[8] analog_switch_array_7[0]/analog_pswitch_small_0/enable
+ housekeeping_top_0/proj_sel[0] housekeeping_top_0/dbus_out[1] slot1_wrapper_0/dig_in[9]
+ housekeeping_top_0/dbus_out[17] housekeeping_top_0/dbus_out[2] vdd1v2_uq2 slot1_wrapper_0/dig_out[10]
+ housekeeping_top_0/proj_dig_ena slot1_wrapper_0/dig_out[11] housekeeping_top_0/dbus_out[10]
+ vss3v3 vss3v3 housekeeping_top_0/dbus_in_right[5] housekeeping_top_0/proj_ibias_ena[1]
+ housekeeping_top_0/dbus_out[23] slot1_wrapper_0/ibias1 housekeeping_top_0/dbus_in_right[10]
+ slot1_wrapper_0/vdd_3v3 housekeeping_top_0/dbus_out[6] slot1_wrapper_0/ibias0 slot1_wrapper_0/dig_in[10]
+ project_control_area_15/user_project_control_0/dig_out[2] housekeeping_top_0/proj_vbias_ena
+ slot1_wrapper_0/dig_in[11] vdd3v3 slot1_wrapper_0/enable project_control_area_15/user_project_control_0/dig_out[1]
+ project_control_area_15/user_project_control_0/dig_out[3] slot1_wrapper_0/dig_in[12]
+ slot1_wrapper_0/dig_in[13] housekeeping_top_0/proj_3v3_ena project_control_area_15/user_project_control_0/dig_out[4]
+ slot1_wrapper_0/vbias slot1_wrapper_0/dig_in[14] housekeeping_top_0/analog_bus_ena[3]
+ housekeeping_top_0/proj_ibias_ena[0] project_control_area_15/user_project_control_0/dig_out[5]
+ slot1_wrapper_0/dig_in[15] housekeeping_top_0/dbus_out[20] vdd1v2_uq2 housekeeping_top_0/dbus_out[19]
+ slot1_wrapper_0/dig_in[16] project_control_area_15/user_project_control_0/dig_out[6]
+ housekeeping_top_0/proj_sel[4] housekeeping_top_0/dbus_in_right[6] vss3v3 housekeeping_top_0/reset
+ housekeeping_top_0/dbus_out[12] slot1_wrapper_0/dig_in[17] housekeeping_top_0/analog_bus_ena[0]
+ housekeeping_top_0/proj_1v2_ena slot1_wrapper_0/dig_in[18] housekeeping_top_0/proj_ena
+ slot1_wrapper_0/dig_in[19] vdd1v2_uq2 project_control_area_15/user_project_control_0/dig_out[9]
+ vdd3v3 housekeeping_top_0/dbus_out[14] analog_switch_array_7[0]/analog_pswitch_small_1/enable
+ project_control_area_15/user_project_control_0/dig_out[10] housekeeping_top_0/dbus_out[16]
+ housekeeping_top_0/dbus_out[18] slot1_wrapper_0/dig_out[0] housekeeping_top_0/clk_out
+ slot1_wrapper_0/reset slot1_wrapper_0/dig_out[1] housekeeping_top_0/dbus_in_right[2]
+ housekeeping_top_0/dbus_out[0] slot1_wrapper_0/dig_out[2] housekeeping_top_0/dbus_in_right[7]
+ housekeeping_top_0/dbus_in_right[0] slot1_wrapper_0/clk housekeeping_top_0/dbus_in_right[1]
+ housekeeping_top_0/dbus_out[7] slot1_wrapper_0/dig_out[3] housekeeping_top_0/dbus_out[8]
+ housekeeping_top_0/dbus_out[11] project_control_area_15/user_project_control_0/dig_out[7]
+ slot1_wrapper_0/dig_out[4] housekeeping_top_0/dbus_out[3] analog_switch_array_7[0]/analog_switch_small_0/enable
+ housekeeping_top_0/proj_sel[3] slot1_wrapper_0/dig_out[5] project_control_area_15/user_project_control_0/dig_out[8]
+ housekeeping_top_0/dbus_out[4] slot1_wrapper_0/dig_in[0] housekeeping_top_0/dbus_out[15]
+ vss3v3 analog_switch_array_7[0]/analog_switch_med_22/enable housekeeping_top_0/dbus_out[13]
+ slot1_wrapper_0/dig_out[6] vss3v3 slot1_wrapper_0/vdd_1v2 vss3v3 vss3v3 slot1_wrapper_0/dig_in[1]
+ project_control_area
Xsg13cmos5l_ocd_ip__bandgap_v3_0 analog_switch_small_0/in sg13cmos5l_ocd_ip__bandgap_v3_0/ibias1_250n
+ housekeeping_top_0/bandgap_trim[15] housekeeping_top_0/bandgap_trim[14] housekeeping_top_0/bandgap_trim[13]
+ housekeeping_top_0/bandgap_trim[12] housekeeping_top_0/bandgap_trim[11] housekeeping_top_0/bandgap_trim[10]
+ housekeeping_top_0/bandgap_trim[9] housekeeping_top_0/bandgap_trim[8] housekeeping_top_0/bandgap_trim[7]
+ housekeeping_top_0/bandgap_trim[6] housekeeping_top_0/bandgap_trim[5] housekeeping_top_0/bandgap_trim[4]
+ housekeeping_top_0/bandgap_trim[3] housekeeping_top_0/bandgap_trim[2] housekeeping_top_0/bandgap_trim[1]
+ housekeeping_top_0/bandgap_trim[0] housekeeping_top_0/bandgap_ena sg13cmos5l_ocd_ip__bandgap_v3_0/ibias2_1u
+ vdd1v2_uq2 vdd3v3 vss3v3 vss3v3 sg13cmos5l_ocd_ip__bandgap_v3
Xslot12_wrapper_0 vss3v3 s12_an[0] s12_an[1] s12_an_0_esd s12_an_1_esd slot12_wrapper_0/vbias
+ slot12_wrapper_0/dig_in[23] slot12_wrapper_0/dig_in[22] slot12_wrapper_0/dig_in[21]
+ slot12_wrapper_0/dig_in[20] slot12_wrapper_0/dig_in[19] slot12_wrapper_0/dig_in[18]
+ slot12_wrapper_0/dig_in[17] slot12_wrapper_0/dig_in[16] slot12_wrapper_0/dig_in[15]
+ slot12_wrapper_0/dig_in[14] slot12_wrapper_0/dig_in[13] slot12_wrapper_0/dig_in[12]
+ slot12_wrapper_0/dig_in[11] slot12_wrapper_0/dig_in[10] slot12_wrapper_0/dig_in[9]
+ slot12_wrapper_0/dig_in[8] slot12_wrapper_0/dig_in[7] slot12_wrapper_0/dig_in[6]
+ slot12_wrapper_0/dig_in[5] slot12_wrapper_0/dig_in[4] slot12_wrapper_0/dig_in[3]
+ slot12_wrapper_0/dig_in[2] slot12_wrapper_0/dig_in[1] slot12_wrapper_0/dig_in[0]
+ slot12_wrapper_0/dig_out[11] slot12_wrapper_0/dig_out[10] slot12_wrapper_0/dig_out[9]
+ slot12_wrapper_0/dig_out[8] slot12_wrapper_0/dig_out[7] slot12_wrapper_0/dig_out[6]
+ slot12_wrapper_0/dig_out[5] slot12_wrapper_0/dig_out[4] slot12_wrapper_0/dig_out[3]
+ slot12_wrapper_0/dig_out[2] slot12_wrapper_0/dig_out[1] slot12_wrapper_0/dig_out[0]
+ slot12_wrapper_0/ibias0 slot12_wrapper_0/ibias1 slot12_wrapper_0/analog_bus3 slot12_wrapper_0/analog_bus2
+ slot12_wrapper_0/analog_bus1 slot12_wrapper_0/analog_bus0 vss3v3 slot12_wrapper_0/vdd_1v2
+ slot12_wrapper_0/vdd_3v3 slot12_wrapper_0/enable slot12_wrapper_0/clk slot12_wrapper_0/reset
+ slot12_wrapper
Xhousekeeping_top_0 CSB_in SCK_in SDI_in SDO_out housekeeping_top_0/analog_bus_ena[0]
+ housekeeping_top_0/analog_bus_ena[1] housekeeping_top_0/analog_bus_ena[2] housekeeping_top_0/analog_bus_ena[3]
+ housekeeping_top_0/bandgap_ena housekeeping_top_0/bandgap_sink1[0] housekeeping_top_0/bandgap_sink1[1]
+ housekeeping_top_0/bandgap_sink1[2] housekeeping_top_0/bandgap_sink2[0] housekeeping_top_0/bandgap_sink2[1]
+ housekeeping_top_0/bandgap_trim[0] housekeeping_top_0/bandgap_trim[10] housekeeping_top_0/bandgap_trim[11]
+ housekeeping_top_0/bandgap_trim[12] housekeeping_top_0/bandgap_trim[13] housekeeping_top_0/bandgap_trim[14]
+ housekeeping_top_0/bandgap_trim[15] housekeeping_top_0/bandgap_trim[1] housekeeping_top_0/bandgap_trim[2]
+ housekeeping_top_0/bandgap_trim[3] housekeeping_top_0/bandgap_trim[4] housekeeping_top_0/bandgap_trim[5]
+ housekeeping_top_0/bandgap_trim[6] housekeeping_top_0/bandgap_trim[7] housekeeping_top_0/bandgap_trim[8]
+ housekeeping_top_0/bandgap_trim[9] housekeeping_top_0/biasgen_coarse housekeeping_top_0/biasgen_ena
+ housekeeping_top_0/biasgen_fine housekeeping_top_0/biasgen_ref_vbg clk_in housekeeping_top_0/clk_out
+ housekeeping_top_0/dbus_in_left[0] housekeeping_top_0/dbus_in_left[10] housekeeping_top_0/dbus_in_left[11]
+ housekeeping_top_0/dbus_in_left[1] housekeeping_top_0/dbus_in_left[2] housekeeping_top_0/dbus_in_left[3]
+ housekeeping_top_0/dbus_in_left[4] housekeeping_top_0/dbus_in_left[5] housekeeping_top_0/dbus_in_left[6]
+ housekeeping_top_0/dbus_in_left[7] housekeeping_top_0/dbus_in_left[8] housekeeping_top_0/dbus_in_left[9]
+ housekeeping_top_0/dbus_in_right[0] housekeeping_top_0/dbus_in_right[10] housekeeping_top_0/dbus_in_right[11]
+ housekeeping_top_0/dbus_in_right[1] housekeeping_top_0/dbus_in_right[2] housekeeping_top_0/dbus_in_right[3]
+ housekeeping_top_0/dbus_in_right[4] housekeeping_top_0/dbus_in_right[5] housekeeping_top_0/dbus_in_right[6]
+ housekeeping_top_0/dbus_in_right[7] housekeeping_top_0/dbus_in_right[8] housekeeping_top_0/dbus_in_right[9]
+ housekeeping_top_0/dbus_out[0] housekeeping_top_0/dbus_out[10] housekeeping_top_0/dbus_out[11]
+ housekeeping_top_0/dbus_out[12] housekeeping_top_0/dbus_out[13] housekeeping_top_0/dbus_out[14]
+ housekeeping_top_0/dbus_out[15] housekeeping_top_0/dbus_out[16] housekeeping_top_0/dbus_out[17]
+ housekeeping_top_0/dbus_out[18] housekeeping_top_0/dbus_out[19] housekeeping_top_0/dbus_out[1]
+ housekeeping_top_0/dbus_out[20] housekeeping_top_0/dbus_out[21] housekeeping_top_0/dbus_out[22]
+ housekeeping_top_0/dbus_out[23] housekeeping_top_0/dbus_out[2] housekeeping_top_0/dbus_out[3]
+ housekeeping_top_0/dbus_out[4] housekeeping_top_0/dbus_out[5] housekeeping_top_0/dbus_out[6]
+ housekeeping_top_0/dbus_out[7] housekeeping_top_0/dbus_out[8] housekeeping_top_0/dbus_out[9]
+ housekeeping_top_0/idac1_value[0] housekeeping_top_0/idac1_value[1] housekeeping_top_0/idac1_value[2]
+ housekeeping_top_0/idac1_value[3] housekeeping_top_0/idac1_value[4] housekeeping_top_0/idac2_value[0]
+ housekeeping_top_0/idac2_value[1] housekeeping_top_0/idac2_value[2] housekeeping_top_0/idac2_value[3]
+ housekeeping_top_0/idac2_value[4] gpio_in[0] gpio_in[10] gpio_in[11] gpio_in[1]
+ gpio_in[2] gpio_in[3] gpio_in[4] gpio_in[5] gpio_in[6] gpio_in[7] gpio_in[8] gpio_in[9]
+ gpio_oe[0] gpio_oe[10] gpio_oe[11] gpio_oe[1] gpio_oe[2] gpio_oe[3] gpio_oe[4] gpio_oe[5]
+ gpio_oe[6] gpio_oe[7] gpio_oe[8] gpio_oe[9] gpio_out[0] gpio_out[10] gpio_out[11]
+ gpio_out[1] gpio_out[2] gpio_out[3] gpio_out[4] gpio_out[5] gpio_out[6] gpio_out[7]
+ gpio_out[8] gpio_out[9] mask_rev[0] mask_rev[10] mask_rev[11] mask_rev[12] mask_rev[13]
+ mask_rev[14] mask_rev[15] mask_rev[16] mask_rev[17] mask_rev[18] mask_rev[19] mask_rev[1]
+ mask_rev[20] mask_rev[21] mask_rev[22] mask_rev[23] mask_rev[24] mask_rev[25] mask_rev[26]
+ mask_rev[27] mask_rev[28] mask_rev[29] mask_rev[2] mask_rev[30] mask_rev[31] mask_rev[3]
+ mask_rev[4] mask_rev[5] mask_rev[6] mask_rev[7] mask_rev[8] mask_rev[9] housekeeping_top_0/porb
+ housekeeping_top_0/proj_1v2_ena housekeeping_top_0/proj_3v3_ena housekeeping_top_0/proj_dig_ena
+ housekeeping_top_0/proj_ena housekeeping_top_0/proj_ibias_ena[0] housekeeping_top_0/proj_ibias_ena[1]
+ housekeeping_top_0/proj_sel[0] housekeeping_top_0/proj_sel[1] housekeeping_top_0/proj_sel[2]
+ housekeeping_top_0/proj_sel[3] housekeeping_top_0/proj_sel[4] housekeeping_top_0/proj_vbias_ena
+ analog_switch_small_1/enable housekeeping_top_0/reset SDO_ena housekeeping_top_0/sram_addr[0]
+ housekeeping_top_0/sram_addr[1] housekeeping_top_0/sram_addr[2] housekeeping_top_0/sram_addr[3]
+ housekeeping_top_0/sram_addr[4] housekeeping_top_0/sram_addr[5] housekeeping_top_0/sram_addr[6]
+ housekeeping_top_0/sram_addr[7] housekeeping_top_0/sram_addr[8] housekeeping_top_0/sram_addr[9]
+ housekeeping_top_0/sram_clk housekeeping_top_0/sram_idata[0] housekeeping_top_0/sram_idata[1]
+ housekeeping_top_0/sram_idata[2] housekeeping_top_0/sram_idata[3] housekeeping_top_0/sram_idata[4]
+ housekeeping_top_0/sram_idata[5] housekeeping_top_0/sram_idata[6] housekeeping_top_0/sram_idata[7]
+ housekeeping_top_0/sram_odata[0] housekeeping_top_0/sram_odata[1] housekeeping_top_0/sram_odata[2]
+ housekeeping_top_0/sram_odata[3] housekeeping_top_0/sram_odata[4] housekeeping_top_0/sram_odata[5]
+ housekeeping_top_0/sram_odata[6] housekeeping_top_0/sram_odata[7] housekeeping_top_0/sram_read
+ housekeeping_top_0/sram_write housekeeping_top_0/voltgen_ena[0] housekeeping_top_0/voltgen_ena[1]
+ housekeeping_top_0/voltgen_ena[2] housekeeping_top_0/voltgen_high housekeeping_top_0/voltgen_sink1[0]
+ housekeeping_top_0/voltgen_sink1[1] housekeeping_top_0/voltgen_sink1[2] housekeeping_top_0/voltgen_sink2[0]
+ housekeeping_top_0/voltgen_sink2[1] housekeeping_top_0/voltgen_sink2[2] housekeeping_top_0/voltgen_source[0]
+ housekeeping_top_0/voltgen_source[1] housekeeping_top_0/voltgen_source[2] housekeeping_top_0/voltgen_source[3]
+ housekeeping_top_0/voltgen_source[4] housekeeping_top_0/voltgen_value[0] housekeeping_top_0/voltgen_value[1]
+ housekeeping_top_0/voltgen_value[2] housekeeping_top_0/_7075_/Q housekeeping_top_0/_3465_/Y
+ vddd vss3v3 housekeeping_top
.ends
